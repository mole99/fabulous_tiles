* NGSPICE file created from W_IO4.ext - technology: sky130A

* Black-box entry subcircuit for sky130_fd_sc_hd__fill_1 abstract view
.subckt sky130_fd_sc_hd__fill_1 VGND VNB VPB VPWR
.ends

* Black-box entry subcircuit for sky130_fd_sc_hd__decap_3 abstract view
.subckt sky130_fd_sc_hd__decap_3 VGND VNB VPB VPWR
.ends

* Black-box entry subcircuit for sky130_fd_sc_hd__dlxtp_1 abstract view
.subckt sky130_fd_sc_hd__dlxtp_1 D GATE VGND VNB VPB VPWR Q
.ends

* Black-box entry subcircuit for sky130_fd_sc_hd__clkbuf_1 abstract view
.subckt sky130_fd_sc_hd__clkbuf_1 A VGND VNB VPB VPWR X
.ends

* Black-box entry subcircuit for sky130_fd_sc_hd__tapvpwrvgnd_1 abstract view
.subckt sky130_fd_sc_hd__tapvpwrvgnd_1 VGND VPWR
.ends

* Black-box entry subcircuit for sky130_fd_sc_hd__buf_1 abstract view
.subckt sky130_fd_sc_hd__buf_1 A VGND VNB VPB VPWR X
.ends

* Black-box entry subcircuit for sky130_fd_sc_hd__mux4_1 abstract view
.subckt sky130_fd_sc_hd__mux4_1 A0 A1 A2 A3 S0 S1 VGND VNB VPB VPWR X
.ends

* Black-box entry subcircuit for sky130_fd_sc_hd__o21a_1 abstract view
.subckt sky130_fd_sc_hd__o21a_1 A1 A2 B1 VGND VNB VPB VPWR X
.ends

* Black-box entry subcircuit for sky130_fd_sc_hd__fill_2 abstract view
.subckt sky130_fd_sc_hd__fill_2 VGND VNB VPB VPWR
.ends

* Black-box entry subcircuit for sky130_fd_sc_hd__diode_2 abstract view
.subckt sky130_fd_sc_hd__diode_2 DIODE VGND VNB VPB VPWR
.ends

* Black-box entry subcircuit for sky130_fd_sc_hd__buf_2 abstract view
.subckt sky130_fd_sc_hd__buf_2 A VGND VNB VPB VPWR X
.ends

* Black-box entry subcircuit for sky130_fd_sc_hd__dfxtp_1 abstract view
.subckt sky130_fd_sc_hd__dfxtp_1 CLK D VGND VNB VPB VPWR Q
.ends

* Black-box entry subcircuit for sky130_fd_sc_hd__or2_1 abstract view
.subckt sky130_fd_sc_hd__or2_1 A B VGND VNB VPB VPWR X
.ends

* Black-box entry subcircuit for sky130_fd_sc_hd__clkbuf_2 abstract view
.subckt sky130_fd_sc_hd__clkbuf_2 A VGND VNB VPB VPWR X
.ends

* Black-box entry subcircuit for sky130_fd_sc_hd__a41o_1 abstract view
.subckt sky130_fd_sc_hd__a41o_1 A1 A2 A3 A4 B1 VGND VNB VPB VPWR X
.ends

* Black-box entry subcircuit for sky130_fd_sc_hd__a211oi_1 abstract view
.subckt sky130_fd_sc_hd__a211oi_1 A1 A2 B1 C1 VGND VNB VPB VPWR Y
.ends

* Black-box entry subcircuit for sky130_fd_sc_hd__and3b_1 abstract view
.subckt sky130_fd_sc_hd__and3b_1 A_N B C VGND VNB VPB VPWR X
.ends

* Black-box entry subcircuit for sky130_fd_sc_hd__dlymetal6s2s_1 abstract view
.subckt sky130_fd_sc_hd__dlymetal6s2s_1 A VGND VNB VPB VPWR X
.ends

* Black-box entry subcircuit for sky130_fd_sc_hd__mux2_1 abstract view
.subckt sky130_fd_sc_hd__mux2_1 A0 A1 S VGND VNB VPB VPWR X
.ends

* Black-box entry subcircuit for sky130_fd_sc_hd__nand2_1 abstract view
.subckt sky130_fd_sc_hd__nand2_1 A B VGND VNB VPB VPWR Y
.ends

* Black-box entry subcircuit for sky130_fd_sc_hd__clkbuf_16 abstract view
.subckt sky130_fd_sc_hd__clkbuf_16 A VGND VNB VPB VPWR X
.ends

* Black-box entry subcircuit for sky130_fd_sc_hd__o21ai_1 abstract view
.subckt sky130_fd_sc_hd__o21ai_1 A1 A2 B1 VGND VNB VPB VPWR Y
.ends

* Black-box entry subcircuit for sky130_fd_sc_hd__or3b_1 abstract view
.subckt sky130_fd_sc_hd__or3b_1 A B C_N VGND VNB VPB VPWR X
.ends

* Black-box entry subcircuit for sky130_fd_sc_hd__inv_2 abstract view
.subckt sky130_fd_sc_hd__inv_2 A VGND VNB VPB VPWR Y
.ends

* Black-box entry subcircuit for sky130_fd_sc_hd__inv_1 abstract view
.subckt sky130_fd_sc_hd__inv_1 A VGND VNB VPB VPWR Y
.ends

* Black-box entry subcircuit for sky130_fd_sc_hd__a22o_1 abstract view
.subckt sky130_fd_sc_hd__a22o_1 A1 A2 B1 B2 VGND VNB VPB VPWR X
.ends

.subckt W_IO4 A_I_top A_O_top A_T_top A_config_C_bit0 A_config_C_bit1 A_config_C_bit2
+ A_config_C_bit3 B_I_top B_O_top B_T_top B_config_C_bit0 B_config_C_bit1 B_config_C_bit2
+ B_config_C_bit3 C_I_top C_O_top C_T_top C_config_C_bit0 C_config_C_bit1 C_config_C_bit2
+ C_config_C_bit3 D_I_top D_O_top D_T_top D_config_C_bit0 D_config_C_bit1 D_config_C_bit2
+ D_config_C_bit3 E1BEG[0] E1BEG[1] E1BEG[2] E1BEG[3] E2BEG[0] E2BEG[1] E2BEG[2] E2BEG[3]
+ E2BEG[4] E2BEG[5] E2BEG[6] E2BEG[7] E2BEGb[0] E2BEGb[1] E2BEGb[2] E2BEGb[3] E2BEGb[4]
+ E2BEGb[5] E2BEGb[6] E2BEGb[7] E6BEG[0] E6BEG[10] E6BEG[11] E6BEG[1] E6BEG[2] E6BEG[3]
+ E6BEG[4] E6BEG[5] E6BEG[6] E6BEG[7] E6BEG[8] E6BEG[9] EE4BEG[0] EE4BEG[10] EE4BEG[11]
+ EE4BEG[12] EE4BEG[13] EE4BEG[14] EE4BEG[15] EE4BEG[1] EE4BEG[2] EE4BEG[3] EE4BEG[4]
+ EE4BEG[5] EE4BEG[6] EE4BEG[7] EE4BEG[8] EE4BEG[9] FrameData[0] FrameData[10] FrameData[11]
+ FrameData[12] FrameData[13] FrameData[14] FrameData[15] FrameData[16] FrameData[17]
+ FrameData[18] FrameData[19] FrameData[1] FrameData[20] FrameData[21] FrameData[22]
+ FrameData[23] FrameData[24] FrameData[25] FrameData[26] FrameData[27] FrameData[28]
+ FrameData[29] FrameData[2] FrameData[30] FrameData[31] FrameData[3] FrameData[4]
+ FrameData[5] FrameData[6] FrameData[7] FrameData[8] FrameData[9] FrameData_O[0]
+ FrameData_O[10] FrameData_O[11] FrameData_O[12] FrameData_O[13] FrameData_O[14]
+ FrameData_O[15] FrameData_O[16] FrameData_O[17] FrameData_O[18] FrameData_O[19]
+ FrameData_O[1] FrameData_O[20] FrameData_O[21] FrameData_O[22] FrameData_O[23] FrameData_O[24]
+ FrameData_O[25] FrameData_O[26] FrameData_O[27] FrameData_O[28] FrameData_O[29]
+ FrameData_O[2] FrameData_O[30] FrameData_O[31] FrameData_O[3] FrameData_O[4] FrameData_O[5]
+ FrameData_O[6] FrameData_O[7] FrameData_O[8] FrameData_O[9] FrameStrobe[0] FrameStrobe[10]
+ FrameStrobe[11] FrameStrobe[12] FrameStrobe[13] FrameStrobe[14] FrameStrobe[15]
+ FrameStrobe[16] FrameStrobe[17] FrameStrobe[18] FrameStrobe[19] FrameStrobe[1] FrameStrobe[2]
+ FrameStrobe[3] FrameStrobe[4] FrameStrobe[5] FrameStrobe[6] FrameStrobe[7] FrameStrobe[8]
+ FrameStrobe[9] FrameStrobe_O[0] FrameStrobe_O[10] FrameStrobe_O[11] FrameStrobe_O[12]
+ FrameStrobe_O[13] FrameStrobe_O[14] FrameStrobe_O[15] FrameStrobe_O[16] FrameStrobe_O[17]
+ FrameStrobe_O[18] FrameStrobe_O[19] FrameStrobe_O[1] FrameStrobe_O[2] FrameStrobe_O[3]
+ FrameStrobe_O[4] FrameStrobe_O[5] FrameStrobe_O[6] FrameStrobe_O[7] FrameStrobe_O[8]
+ FrameStrobe_O[9] UserCLK UserCLKo VGND VPWR W1END[0] W1END[1] W1END[2] W1END[3]
+ W2END[0] W2END[1] W2END[2] W2END[3] W2END[4] W2END[5] W2END[6] W2END[7] W2MID[0]
+ W2MID[1] W2MID[2] W2MID[3] W2MID[4] W2MID[5] W2MID[6] W2MID[7] W6END[0] W6END[10]
+ W6END[11] W6END[1] W6END[2] W6END[3] W6END[4] W6END[5] W6END[6] W6END[7] W6END[8]
+ W6END[9] WW4END[0] WW4END[10] WW4END[11] WW4END[12] WW4END[13] WW4END[14] WW4END[15]
+ WW4END[1] WW4END[2] WW4END[3] WW4END[4] WW4END[5] WW4END[6] WW4END[7] WW4END[8]
+ WW4END[9]
XFILLER_36_19 VGND VGND VPWR VPWR sky130_fd_sc_hd__fill_1
XFILLER_52_29 VGND VGND VPWR VPWR sky130_fd_sc_hd__decap_3
XFILLER_7_7 VGND VGND VPWR VPWR sky130_fd_sc_hd__decap_3
XFILLER_77_26 VGND VGND VPWR VPWR sky130_fd_sc_hd__decap_3
X_294_ net27 net77 VGND VGND VPWR VPWR Inst_W_IO4_ConfigMem.Inst_frame0_bit2.Q sky130_fd_sc_hd__dlxtp_1
X_363_ Inst_W_IO4_switch_matrix.EE4BEG3 VGND VGND VPWR VPWR net171 sky130_fd_sc_hd__clkbuf_1
XFILLER_83_80 VGND VGND VPWR VPWR sky130_fd_sc_hd__fill_1
XFILLER_63_39 VGND VGND VPWR VPWR sky130_fd_sc_hd__decap_3
XFILLER_12_10 VGND VGND VPWR VPWR sky130_fd_sc_hd__decap_3
XFILLER_88_69 VGND VGND VPWR VPWR sky130_fd_sc_hd__fill_1
XFILLER_88_36 VGND VGND VPWR VPWR sky130_fd_sc_hd__fill_1
XPHY_EDGE_ROW_0_Left_89 VGND VGND VPWR VPWR sky130_fd_sc_hd__decap_3
XTAP_TAPCELL_ROW_5_184 VGND VPWR sky130_fd_sc_hd__tapvpwrvgnd_1
X_415_ FrameStrobe[7] VGND VGND VPWR VPWR net227 sky130_fd_sc_hd__clkbuf_1
X_346_ Inst_W_IO4_switch_matrix.E2BEGb6 VGND VGND VPWR VPWR net148 sky130_fd_sc_hd__buf_1
X_277_ net13 net70 VGND VGND VPWR VPWR Inst_W_IO4_ConfigMem.Inst_frame1_bit17.Q sky130_fd_sc_hd__dlxtp_1
XPHY_EDGE_ROW_18_Left_107 VGND VGND VPWR VPWR sky130_fd_sc_hd__decap_3
XPHY_EDGE_ROW_27_Left_116 VGND VGND VPWR VPWR sky130_fd_sc_hd__decap_3
X_200_ net31 net61 VGND VGND VPWR VPWR Inst_W_IO4_ConfigMem.Inst_frame3_bit4.Q sky130_fd_sc_hd__dlxtp_1
X_131_ net51 net52 net53 net54 Inst_W_IO4_ConfigMem.Inst_frame0_bit11.Q Inst_W_IO4_ConfigMem.Inst_frame0_bit12.Q
+ VGND VGND VPWR VPWR _054_ sky130_fd_sc_hd__mux4_1
XPHY_EDGE_ROW_36_Left_125 VGND VGND VPWR VPWR sky130_fd_sc_hd__decap_3
XFILLER_48_50 VGND VGND VPWR VPWR sky130_fd_sc_hd__decap_3
XFILLER_0_35 VGND VGND VPWR VPWR sky130_fd_sc_hd__decap_3
XFILLER_0_57 VGND VGND VPWR VPWR sky130_fd_sc_hd__decap_3
XPHY_EDGE_ROW_45_Left_134 VGND VGND VPWR VPWR sky130_fd_sc_hd__decap_3
XFILLER_9_44 VGND VGND VPWR VPWR sky130_fd_sc_hd__decap_3
XPHY_EDGE_ROW_54_Left_143 VGND VGND VPWR VPWR sky130_fd_sc_hd__decap_3
X_329_ Inst_W_IO4_switch_matrix.E1BEG1 VGND VGND VPWR VPWR net131 sky130_fd_sc_hd__buf_1
XPHY_EDGE_ROW_63_Left_152 VGND VGND VPWR VPWR sky130_fd_sc_hd__decap_3
XPHY_EDGE_ROW_72_Left_161 VGND VGND VPWR VPWR sky130_fd_sc_hd__decap_3
XFILLER_60_29 VGND VGND VPWR VPWR sky130_fd_sc_hd__decap_3
XFILLER_69_16 VGND VGND VPWR VPWR sky130_fd_sc_hd__fill_1
XPHY_EDGE_ROW_81_Left_170 VGND VGND VPWR VPWR sky130_fd_sc_hd__decap_3
XFILLER_34_41 VGND VGND VPWR VPWR sky130_fd_sc_hd__decap_3
X_114_ _004_ _038_ Inst_W_IO4_ConfigMem.Inst_frame0_bit28.Q VGND VGND VPWR VPWR _039_
+ sky130_fd_sc_hd__o21a_1
XFILLER_50_73 VGND VGND VPWR VPWR sky130_fd_sc_hd__fill_2
XPHY_EDGE_ROW_3_Left_92 VGND VGND VPWR VPWR sky130_fd_sc_hd__decap_3
XFILLER_59_60 VGND VGND VPWR VPWR sky130_fd_sc_hd__decap_3
XFILLER_20_32 VGND VGND VPWR VPWR sky130_fd_sc_hd__decap_3
XFILLER_6_67 VGND VGND VPWR VPWR sky130_fd_sc_hd__decap_3
XANTENNA_5 net202 VGND VGND VPWR VPWR sky130_fd_sc_hd__diode_2
XFILLER_82_49 VGND VGND VPWR VPWR sky130_fd_sc_hd__decap_3
XFILLER_15_43 VGND VGND VPWR VPWR sky130_fd_sc_hd__decap_3
Xoutput97 net116 VGND VGND VPWR VPWR B_config_C_bit2 sky130_fd_sc_hd__buf_2
XTAP_TAPCELL_ROW_64_243 VGND VPWR sky130_fd_sc_hd__tapvpwrvgnd_1
XFILLER_26_20 VGND VGND VPWR VPWR sky130_fd_sc_hd__decap_3
XFILLER_26_42 VGND VGND VPWR VPWR sky130_fd_sc_hd__fill_2
X_362_ Inst_W_IO4_switch_matrix.EE4BEG2 VGND VGND VPWR VPWR net170 sky130_fd_sc_hd__buf_1
X_293_ net16 net77 VGND VGND VPWR VPWR Inst_W_IO4_ConfigMem.Inst_frame0_bit1.Q sky130_fd_sc_hd__dlxtp_1
XFILLER_3_24 VGND VGND VPWR VPWR sky130_fd_sc_hd__fill_2
XFILLER_3_79 VGND VGND VPWR VPWR sky130_fd_sc_hd__fill_2
XFILLER_80_3 VGND VGND VPWR VPWR sky130_fd_sc_hd__decap_3
X_414_ FrameStrobe[6] VGND VGND VPWR VPWR net226 sky130_fd_sc_hd__clkbuf_1
X_345_ Inst_W_IO4_switch_matrix.E2BEGb5 VGND VGND VPWR VPWR net147 sky130_fd_sc_hd__clkbuf_1
X_276_ net12 net70 VGND VGND VPWR VPWR Inst_W_IO4_ConfigMem.Inst_frame1_bit16.Q sky130_fd_sc_hd__dlxtp_1
XFILLER_53_40 VGND VGND VPWR VPWR sky130_fd_sc_hd__decap_3
XTAP_TAPCELL_ROW_34_213 VGND VPWR sky130_fd_sc_hd__tapvpwrvgnd_1
Xoutput210 net229 VGND VGND VPWR VPWR FrameStrobe_O[9] sky130_fd_sc_hd__buf_2
XPHY_EDGE_ROW_12_Right_12 VGND VGND VPWR VPWR sky130_fd_sc_hd__decap_3
XFILLER_58_29 VGND VGND VPWR VPWR sky130_fd_sc_hd__decap_3
XPHY_EDGE_ROW_21_Right_21 VGND VGND VPWR VPWR sky130_fd_sc_hd__decap_3
XFILLER_23_10 VGND VGND VPWR VPWR sky130_fd_sc_hd__decap_3
X_130_ _008_ _052_ Inst_W_IO4_ConfigMem.Inst_frame0_bit14.Q VGND VGND VPWR VPWR _053_
+ sky130_fd_sc_hd__o21a_1
XPHY_EDGE_ROW_30_Right_30 VGND VGND VPWR VPWR sky130_fd_sc_hd__decap_3
XFILLER_48_62 VGND VGND VPWR VPWR sky130_fd_sc_hd__decap_3
XFILLER_0_14 VGND VGND VPWR VPWR sky130_fd_sc_hd__decap_3
XFILLER_0_47 VGND VGND VPWR VPWR sky130_fd_sc_hd__decap_3
XFILLER_0_69 VGND VGND VPWR VPWR sky130_fd_sc_hd__decap_3
XFILLER_9_23 VGND VGND VPWR VPWR sky130_fd_sc_hd__decap_3
X_259_ net29 net67 VGND VGND VPWR VPWR Inst_W_IO4_ConfigMem.Inst_frame2_bit31.Q sky130_fd_sc_hd__dlxtp_1
X_328_ Inst_W_IO4_switch_matrix.E1BEG0 VGND VGND VPWR VPWR net130 sky130_fd_sc_hd__buf_1
XFILLER_85_27 VGND VGND VPWR VPWR sky130_fd_sc_hd__fill_2
XFILLER_18_10 VGND VGND VPWR VPWR sky130_fd_sc_hd__decap_3
X_113_ net47 net48 net49 net50 Inst_W_IO4_ConfigMem.Inst_frame0_bit25.Q Inst_W_IO4_ConfigMem.Inst_frame0_bit26.Q
+ VGND VGND VPWR VPWR _038_ sky130_fd_sc_hd__mux4_1
XFILLER_34_53 VGND VGND VPWR VPWR sky130_fd_sc_hd__decap_3
XFILLER_50_41 VGND VGND VPWR VPWR sky130_fd_sc_hd__decap_3
XFILLER_20_22 VGND VGND VPWR VPWR sky130_fd_sc_hd__decap_3
XFILLER_20_44 VGND VGND VPWR VPWR sky130_fd_sc_hd__decap_3
XANTENNA_6 net204 VGND VGND VPWR VPWR sky130_fd_sc_hd__diode_2
XFILLER_6_79 VGND VGND VPWR VPWR sky130_fd_sc_hd__fill_2
XPHY_EDGE_ROW_6_Right_6 VGND VGND VPWR VPWR sky130_fd_sc_hd__decap_3
XFILLER_66_18 VGND VGND VPWR VPWR sky130_fd_sc_hd__decap_3
Xoutput87 net106 VGND VGND VPWR VPWR A_I_top sky130_fd_sc_hd__buf_2
Xoutput98 net117 VGND VGND VPWR VPWR B_config_C_bit3 sky130_fd_sc_hd__buf_2
XPHY_EDGE_ROW_59_Right_59 VGND VGND VPWR VPWR sky130_fd_sc_hd__decap_3
XFILLER_82_7 VGND VGND VPWR VPWR sky130_fd_sc_hd__fill_1
XPHY_EDGE_ROW_68_Right_68 VGND VGND VPWR VPWR sky130_fd_sc_hd__decap_3
XPHY_EDGE_ROW_77_Right_77 VGND VGND VPWR VPWR sky130_fd_sc_hd__decap_3
XPHY_EDGE_ROW_86_Right_86 VGND VGND VPWR VPWR sky130_fd_sc_hd__decap_3
XFILLER_77_17 VGND VGND VPWR VPWR sky130_fd_sc_hd__decap_3
X_361_ Inst_W_IO4_switch_matrix.EE4BEG1 VGND VGND VPWR VPWR net169 sky130_fd_sc_hd__buf_1
X_292_ net5 net77 VGND VGND VPWR VPWR Inst_W_IO4_ConfigMem.Inst_frame0_bit0.Q sky130_fd_sc_hd__dlxtp_1
XFILLER_73_3 VGND VGND VPWR VPWR sky130_fd_sc_hd__fill_2
XTAP_TAPCELL_ROW_20_199 VGND VPWR sky130_fd_sc_hd__tapvpwrvgnd_1
X_413_ FrameStrobe[5] VGND VGND VPWR VPWR net225 sky130_fd_sc_hd__clkbuf_1
XFILLER_53_52 VGND VGND VPWR VPWR sky130_fd_sc_hd__decap_3
X_275_ net11 net70 VGND VGND VPWR VPWR Inst_W_IO4_ConfigMem.Inst_frame1_bit15.Q sky130_fd_sc_hd__dlxtp_1
X_344_ Inst_W_IO4_switch_matrix.E2BEGb4 VGND VGND VPWR VPWR net146 sky130_fd_sc_hd__buf_1
Xoutput200 net219 VGND VGND VPWR VPWR FrameStrobe_O[18] sky130_fd_sc_hd__buf_2
Xoutput211 net230 VGND VGND VPWR VPWR UserCLKo sky130_fd_sc_hd__buf_1
XFILLER_58_19 VGND VGND VPWR VPWR sky130_fd_sc_hd__decap_3
XFILLER_23_33 VGND VGND VPWR VPWR sky130_fd_sc_hd__fill_2
XFILLER_0_26 VGND VGND VPWR VPWR sky130_fd_sc_hd__fill_2
XFILLER_9_35 VGND VGND VPWR VPWR sky130_fd_sc_hd__decap_3
X_189_ net22 net60 VGND VGND VPWR VPWR net115 sky130_fd_sc_hd__dlxtp_1
X_327_ clknet_1_0__leaf_UserCLK_regs net4 VGND VGND VPWR VPWR Inst_D_IO_1_bidirectional_frame_config_pass.Q
+ sky130_fd_sc_hd__dfxtp_1
X_258_ net28 net67 VGND VGND VPWR VPWR Inst_W_IO4_ConfigMem.Inst_frame2_bit30.Q sky130_fd_sc_hd__dlxtp_1
XFILLER_80_50 VGND VGND VPWR VPWR sky130_fd_sc_hd__decap_3
XFILLER_34_10 VGND VGND VPWR VPWR sky130_fd_sc_hd__decap_3
X_112_ Inst_W_IO4_ConfigMem.Inst_frame0_bit27.Q _036_ VGND VGND VPWR VPWR _037_ sky130_fd_sc_hd__or2_1
XFILLER_59_51 VGND VGND VPWR VPWR sky130_fd_sc_hd__decap_3
XTAP_TAPCELL_ROW_85_264 VGND VPWR sky130_fd_sc_hd__tapvpwrvgnd_1
XFILLER_45_20 VGND VGND VPWR VPWR sky130_fd_sc_hd__decap_3
XANTENNA_7 net205 VGND VGND VPWR VPWR sky130_fd_sc_hd__diode_2
XFILLER_86_60 VGND VGND VPWR VPWR sky130_fd_sc_hd__fill_1
XFILLER_15_34 VGND VGND VPWR VPWR sky130_fd_sc_hd__decap_3
XFILLER_82_29 VGND VGND VPWR VPWR sky130_fd_sc_hd__fill_2
Xoutput99 net118 VGND VGND VPWR VPWR C_I_top sky130_fd_sc_hd__buf_2
Xoutput88 net107 VGND VGND VPWR VPWR A_T_top sky130_fd_sc_hd__buf_2
XFILLER_68_6 VGND VGND VPWR VPWR sky130_fd_sc_hd__fill_1
XFILLER_77_29 VGND VGND VPWR VPWR sky130_fd_sc_hd__decap_3
XFILLER_26_11 VGND VGND VPWR VPWR sky130_fd_sc_hd__decap_3
XTAP_TAPCELL_ROW_55_234 VGND VPWR sky130_fd_sc_hd__tapvpwrvgnd_1
XFILLER_42_32 VGND VGND VPWR VPWR sky130_fd_sc_hd__decap_3
X_360_ Inst_W_IO4_switch_matrix.EE4BEG0 VGND VGND VPWR VPWR net162 sky130_fd_sc_hd__clkbuf_1
X_291_ net29 net69 VGND VGND VPWR VPWR Inst_W_IO4_ConfigMem.Inst_frame1_bit31.Q sky130_fd_sc_hd__dlxtp_1
XFILLER_83_72 VGND VGND VPWR VPWR sky130_fd_sc_hd__decap_3
XFILLER_12_13 VGND VGND VPWR VPWR sky130_fd_sc_hd__fill_2
XFILLER_37_32 VGND VGND VPWR VPWR sky130_fd_sc_hd__decap_3
X_412_ net38 VGND VGND VPWR VPWR net224 sky130_fd_sc_hd__clkbuf_2
XFILLER_53_31 VGND VGND VPWR VPWR sky130_fd_sc_hd__decap_3
X_343_ Inst_W_IO4_switch_matrix.E2BEGb3 VGND VGND VPWR VPWR net145 sky130_fd_sc_hd__clkbuf_1
X_274_ net10 net70 VGND VGND VPWR VPWR Inst_W_IO4_ConfigMem.Inst_frame1_bit14.Q sky130_fd_sc_hd__dlxtp_1
Xoutput201 net220 VGND VGND VPWR VPWR FrameStrobe_O[19] sky130_fd_sc_hd__buf_2
XTAP_TAPCELL_ROW_25_204 VGND VPWR sky130_fd_sc_hd__tapvpwrvgnd_1
XFILLER_0_38 VGND VGND VPWR VPWR sky130_fd_sc_hd__decap_3
XFILLER_48_53 VGND VGND VPWR VPWR sky130_fd_sc_hd__decap_3
XPHY_EDGE_ROW_14_Left_103 VGND VGND VPWR VPWR sky130_fd_sc_hd__decap_3
XFILLER_9_47 VGND VGND VPWR VPWR sky130_fd_sc_hd__decap_3
X_326_ clknet_1_1__leaf_UserCLK_regs net3 VGND VGND VPWR VPWR Inst_C_IO_1_bidirectional_frame_config_pass.Q
+ sky130_fd_sc_hd__dfxtp_1
X_188_ net21 net60 VGND VGND VPWR VPWR net114 sky130_fd_sc_hd__dlxtp_1
XPHY_EDGE_ROW_23_Left_112 VGND VGND VPWR VPWR sky130_fd_sc_hd__decap_3
X_257_ net26 net67 VGND VGND VPWR VPWR Inst_W_IO4_ConfigMem.Inst_frame2_bit29.Q sky130_fd_sc_hd__dlxtp_1
XPHY_EDGE_ROW_32_Left_121 VGND VGND VPWR VPWR sky130_fd_sc_hd__decap_3
XPHY_EDGE_ROW_41_Left_130 VGND VGND VPWR VPWR sky130_fd_sc_hd__decap_3
XFILLER_34_22 VGND VGND VPWR VPWR sky130_fd_sc_hd__decap_3
XFILLER_34_44 VGND VGND VPWR VPWR sky130_fd_sc_hd__decap_3
X_111_ net43 net45 net44 net46 Inst_W_IO4_ConfigMem.Inst_frame0_bit26.Q Inst_W_IO4_ConfigMem.Inst_frame0_bit25.Q
+ VGND VGND VPWR VPWR _036_ sky130_fd_sc_hd__mux4_1
XFILLER_50_10 VGND VGND VPWR VPWR sky130_fd_sc_hd__decap_3
XFILLER_50_32 VGND VGND VPWR VPWR sky130_fd_sc_hd__decap_3
XFILLER_59_63 VGND VGND VPWR VPWR sky130_fd_sc_hd__fill_2
X_309_ net13 net77 VGND VGND VPWR VPWR Inst_W_IO4_ConfigMem.Inst_frame0_bit17.Q sky130_fd_sc_hd__dlxtp_1
XFILLER_20_35 VGND VGND VPWR VPWR sky130_fd_sc_hd__decap_3
XFILLER_20_79 VGND VGND VPWR VPWR sky130_fd_sc_hd__fill_2
XFILLER_29_55 VGND VGND VPWR VPWR sky130_fd_sc_hd__fill_1
XANTENNA_8 FrameStrobe[10] VGND VGND VPWR VPWR sky130_fd_sc_hd__diode_2
XFILLER_6_48 VGND VGND VPWR VPWR sky130_fd_sc_hd__fill_1
XFILLER_6_26 VGND VGND VPWR VPWR sky130_fd_sc_hd__fill_2
XPHY_EDGE_ROW_7_Left_96 VGND VGND VPWR VPWR sky130_fd_sc_hd__decap_3
XFILLER_15_57 VGND VGND VPWR VPWR sky130_fd_sc_hd__fill_2
XFILLER_15_46 VGND VGND VPWR VPWR sky130_fd_sc_hd__decap_3
Xoutput89 net108 VGND VGND VPWR VPWR A_config_C_bit0 sky130_fd_sc_hd__buf_2
XFILLER_72_41 VGND VGND VPWR VPWR sky130_fd_sc_hd__fill_1
XFILLER_26_23 VGND VGND VPWR VPWR sky130_fd_sc_hd__decap_3
X_290_ net28 net69 VGND VGND VPWR VPWR Inst_W_IO4_ConfigMem.Inst_frame1_bit30.Q sky130_fd_sc_hd__dlxtp_1
XTAP_TAPCELL_ROW_70_249 VGND VPWR sky130_fd_sc_hd__tapvpwrvgnd_1
XFILLER_3_38 VGND VGND VPWR VPWR sky130_fd_sc_hd__fill_2
XPHY_EDGE_ROW_79_Left_168 VGND VGND VPWR VPWR sky130_fd_sc_hd__decap_3
XPHY_EDGE_ROW_88_Left_177 VGND VGND VPWR VPWR sky130_fd_sc_hd__decap_3
XFILLER_53_43 VGND VGND VPWR VPWR sky130_fd_sc_hd__decap_3
X_342_ Inst_W_IO4_switch_matrix.E2BEGb2 VGND VGND VPWR VPWR net144 sky130_fd_sc_hd__buf_1
X_411_ net63 VGND VGND VPWR VPWR net223 sky130_fd_sc_hd__clkbuf_1
X_273_ net9 net71 VGND VGND VPWR VPWR Inst_W_IO4_ConfigMem.Inst_frame1_bit13.Q sky130_fd_sc_hd__dlxtp_1
Xoutput202 net221 VGND VGND VPWR VPWR FrameStrobe_O[1] sky130_fd_sc_hd__buf_2
XFILLER_23_13 VGND VGND VPWR VPWR sky130_fd_sc_hd__fill_1
XTAP_TAPCELL_ROW_40_219 VGND VPWR sky130_fd_sc_hd__tapvpwrvgnd_1
XFILLER_48_32 VGND VGND VPWR VPWR sky130_fd_sc_hd__decap_3
XFILLER_48_65 VGND VGND VPWR VPWR sky130_fd_sc_hd__decap_3
XFILLER_9_26 VGND VGND VPWR VPWR sky130_fd_sc_hd__decap_3
XTAP_TAPCELL_ROW_1_180 VGND VPWR sky130_fd_sc_hd__tapvpwrvgnd_1
XFILLER_64_75 VGND VGND VPWR VPWR sky130_fd_sc_hd__fill_2
X_325_ clknet_1_1__leaf_UserCLK_regs net2 VGND VGND VPWR VPWR Inst_B_IO_1_bidirectional_frame_config_pass.Q
+ sky130_fd_sc_hd__dfxtp_1
X_187_ net20 net60 VGND VGND VPWR VPWR net111 sky130_fd_sc_hd__dlxtp_1
X_256_ net25 net68 VGND VGND VPWR VPWR Inst_W_IO4_ConfigMem.Inst_frame2_bit28.Q sky130_fd_sc_hd__dlxtp_1
X_110_ Inst_W_IO4_ConfigMem.Inst_frame0_bit29.Q _033_ _034_ _035_ _032_ VGND VGND
+ VPWR VPWR net125 sky130_fd_sc_hd__a41o_1
XFILLER_34_56 VGND VGND VPWR VPWR sky130_fd_sc_hd__fill_2
XFILLER_75_30 VGND VGND VPWR VPWR sky130_fd_sc_hd__fill_1
X_239_ net7 net65 VGND VGND VPWR VPWR Inst_W_IO4_ConfigMem.Inst_frame2_bit11.Q sky130_fd_sc_hd__dlxtp_1
X_308_ net12 net77 VGND VGND VPWR VPWR Inst_W_IO4_ConfigMem.Inst_frame0_bit16.Q sky130_fd_sc_hd__dlxtp_1
XFILLER_1_60 VGND VGND VPWR VPWR sky130_fd_sc_hd__decap_3
XFILLER_20_25 VGND VGND VPWR VPWR sky130_fd_sc_hd__decap_3
XFILLER_20_47 VGND VGND VPWR VPWR sky130_fd_sc_hd__fill_1
XANTENNA_9 FrameStrobe[11] VGND VGND VPWR VPWR sky130_fd_sc_hd__diode_2
XPHY_EDGE_ROW_60_Left_149 VGND VGND VPWR VPWR sky130_fd_sc_hd__decap_3
XTAP_TAPCELL_ROW_76_255 VGND VPWR sky130_fd_sc_hd__tapvpwrvgnd_1
XFILLER_31_57 VGND VGND VPWR VPWR sky130_fd_sc_hd__fill_1
XFILLER_56_32 VGND VGND VPWR VPWR sky130_fd_sc_hd__decap_3
XPHY_EDGE_ROW_19_Right_19 VGND VGND VPWR VPWR sky130_fd_sc_hd__decap_3
XPHY_EDGE_ROW_28_Right_28 VGND VGND VPWR VPWR sky130_fd_sc_hd__decap_3
XPHY_EDGE_ROW_37_Right_37 VGND VGND VPWR VPWR sky130_fd_sc_hd__decap_3
XTAP_TAPCELL_ROW_17_196 VGND VPWR sky130_fd_sc_hd__tapvpwrvgnd_1
XFILLER_7_70 VGND VGND VPWR VPWR sky130_fd_sc_hd__decap_3
XPHY_EDGE_ROW_46_Right_46 VGND VGND VPWR VPWR sky130_fd_sc_hd__decap_3
XPHY_EDGE_ROW_55_Right_55 VGND VGND VPWR VPWR sky130_fd_sc_hd__decap_3
XFILLER_42_23 VGND VGND VPWR VPWR sky130_fd_sc_hd__decap_3
XPHY_EDGE_ROW_64_Right_64 VGND VGND VPWR VPWR sky130_fd_sc_hd__decap_3
XTAP_TAPCELL_ROW_46_225 VGND VPWR sky130_fd_sc_hd__tapvpwrvgnd_1
XPHY_EDGE_ROW_73_Right_73 VGND VGND VPWR VPWR sky130_fd_sc_hd__decap_3
XPHY_EDGE_ROW_82_Right_82 VGND VGND VPWR VPWR sky130_fd_sc_hd__decap_3
X_341_ Inst_W_IO4_switch_matrix.E2BEGb1 VGND VGND VPWR VPWR net143 sky130_fd_sc_hd__buf_1
X_410_ net67 VGND VGND VPWR VPWR net222 sky130_fd_sc_hd__buf_1
XFILLER_53_55 VGND VGND VPWR VPWR sky130_fd_sc_hd__fill_1
X_272_ net8 net71 VGND VGND VPWR VPWR Inst_W_IO4_ConfigMem.Inst_frame1_bit12.Q sky130_fd_sc_hd__dlxtp_1
XFILLER_78_41 VGND VGND VPWR VPWR sky130_fd_sc_hd__decap_3
XFILLER_71_3 VGND VGND VPWR VPWR sky130_fd_sc_hd__fill_1
Xoutput203 net222 VGND VGND VPWR VPWR FrameStrobe_O[2] sky130_fd_sc_hd__buf_2
XFILLER_48_11 VGND VGND VPWR VPWR sky130_fd_sc_hd__fill_2
XFILLER_0_29 VGND VGND VPWR VPWR sky130_fd_sc_hd__decap_3
XFILLER_64_10 VGND VGND VPWR VPWR sky130_fd_sc_hd__decap_3
XFILLER_9_38 VGND VGND VPWR VPWR sky130_fd_sc_hd__decap_3
X_255_ net24 net67 VGND VGND VPWR VPWR Inst_W_IO4_ConfigMem.Inst_frame2_bit27.Q sky130_fd_sc_hd__dlxtp_1
X_324_ clknet_1_0__leaf_UserCLK_regs net1 VGND VGND VPWR VPWR Inst_A_IO_1_bidirectional_frame_config_pass.Q
+ sky130_fd_sc_hd__dfxtp_1
Xfanout70 net72 VGND VGND VPWR VPWR net70 sky130_fd_sc_hd__clkbuf_2
X_186_ net19 net60 VGND VGND VPWR VPWR net110 sky130_fd_sc_hd__dlxtp_1
XFILLER_18_25 VGND VGND VPWR VPWR sky130_fd_sc_hd__decap_3
XFILLER_34_13 VGND VGND VPWR VPWR sky130_fd_sc_hd__decap_3
XFILLER_1_3 VGND VGND VPWR VPWR sky130_fd_sc_hd__decap_3
XFILLER_59_21 VGND VGND VPWR VPWR sky130_fd_sc_hd__decap_3
XFILLER_59_54 VGND VGND VPWR VPWR sky130_fd_sc_hd__fill_2
X_169_ net86 net88 net79 net2 Inst_W_IO4_ConfigMem.Inst_frame2_bit14.Q Inst_W_IO4_ConfigMem.Inst_frame2_bit15.Q
+ VGND VGND VPWR VPWR Inst_W_IO4_switch_matrix.EE4BEG1 sky130_fd_sc_hd__mux4_1
X_238_ net6 net65 VGND VGND VPWR VPWR Inst_W_IO4_ConfigMem.Inst_frame2_bit10.Q sky130_fd_sc_hd__dlxtp_1
X_307_ net11 net77 VGND VGND VPWR VPWR Inst_W_IO4_ConfigMem.Inst_frame0_bit15.Q sky130_fd_sc_hd__dlxtp_1
XFILLER_1_72 VGND VGND VPWR VPWR sky130_fd_sc_hd__decap_3
XFILLER_45_23 VGND VGND VPWR VPWR sky130_fd_sc_hd__fill_1
XFILLER_45_34 VGND VGND VPWR VPWR sky130_fd_sc_hd__fill_1
XFILLER_86_63 VGND VGND VPWR VPWR sky130_fd_sc_hd__fill_1
XFILLER_15_37 VGND VGND VPWR VPWR sky130_fd_sc_hd__decap_3
XFILLER_56_55 VGND VGND VPWR VPWR sky130_fd_sc_hd__decap_3
XFILLER_72_21 VGND VGND VPWR VPWR sky130_fd_sc_hd__decap_3
XFILLER_72_32 VGND VGND VPWR VPWR sky130_fd_sc_hd__decap_3
XFILLER_72_54 VGND VGND VPWR VPWR sky130_fd_sc_hd__fill_1
XFILLER_7_60 VGND VGND VPWR VPWR sky130_fd_sc_hd__decap_3
XFILLER_26_14 VGND VGND VPWR VPWR sky130_fd_sc_hd__decap_3
XFILLER_26_36 VGND VGND VPWR VPWR sky130_fd_sc_hd__decap_3
XFILLER_42_35 VGND VGND VPWR VPWR sky130_fd_sc_hd__decap_3
XTAP_TAPCELL_ROW_8_187 VGND VPWR sky130_fd_sc_hd__tapvpwrvgnd_1
XFILLER_67_10 VGND VGND VPWR VPWR sky130_fd_sc_hd__fill_2
XFILLER_67_54 VGND VGND VPWR VPWR sky130_fd_sc_hd__fill_2
XFILLER_83_31 VGND VGND VPWR VPWR sky130_fd_sc_hd__decap_3
XFILLER_80_8 VGND VGND VPWR VPWR sky130_fd_sc_hd__fill_2
XFILLER_12_27 VGND VGND VPWR VPWR sky130_fd_sc_hd__fill_1
XFILLER_37_57 VGND VGND VPWR VPWR sky130_fd_sc_hd__fill_2
X_340_ Inst_W_IO4_switch_matrix.E2BEGb0 VGND VGND VPWR VPWR net142 sky130_fd_sc_hd__clkbuf_1
X_271_ net7 net69 VGND VGND VPWR VPWR Inst_W_IO4_ConfigMem.Inst_frame1_bit11.Q sky130_fd_sc_hd__dlxtp_1
XFILLER_53_34 VGND VGND VPWR VPWR sky130_fd_sc_hd__decap_3
Xoutput204 net223 VGND VGND VPWR VPWR FrameStrobe_O[3] sky130_fd_sc_hd__buf_2
XFILLER_3_7 VGND VGND VPWR VPWR sky130_fd_sc_hd__fill_2
XFILLER_48_56 VGND VGND VPWR VPWR sky130_fd_sc_hd__decap_3
XFILLER_9_17 VGND VGND VPWR VPWR sky130_fd_sc_hd__decap_3
Xfanout60 net38 VGND VGND VPWR VPWR net60 sky130_fd_sc_hd__clkbuf_2
X_185_ net18 net60 VGND VGND VPWR VPWR net109 sky130_fd_sc_hd__dlxtp_1
X_323_ net29 net77 VGND VGND VPWR VPWR Inst_W_IO4_ConfigMem.Inst_frame0_bit31.Q sky130_fd_sc_hd__dlxtp_1
X_254_ net23 net67 VGND VGND VPWR VPWR Inst_W_IO4_ConfigMem.Inst_frame2_bit26.Q sky130_fd_sc_hd__dlxtp_1
XFILLER_80_32 VGND VGND VPWR VPWR sky130_fd_sc_hd__decap_3
Xfanout71 net72 VGND VGND VPWR VPWR net71 sky130_fd_sc_hd__buf_1
XFILLER_34_25 VGND VGND VPWR VPWR sky130_fd_sc_hd__decap_3
XFILLER_34_47 VGND VGND VPWR VPWR sky130_fd_sc_hd__decap_3
XFILLER_50_13 VGND VGND VPWR VPWR sky130_fd_sc_hd__decap_3
XFILLER_50_35 VGND VGND VPWR VPWR sky130_fd_sc_hd__decap_3
XFILLER_50_68 VGND VGND VPWR VPWR sky130_fd_sc_hd__fill_1
XFILLER_75_10 VGND VGND VPWR VPWR sky130_fd_sc_hd__decap_3
X_306_ net10 net37 VGND VGND VPWR VPWR Inst_W_IO4_ConfigMem.Inst_frame0_bit14.Q sky130_fd_sc_hd__dlxtp_1
X_237_ net36 net66 VGND VGND VPWR VPWR Inst_W_IO4_ConfigMem.Inst_frame2_bit9.Q sky130_fd_sc_hd__dlxtp_1
X_168_ net81 net83 net85 Inst_A_IO_1_bidirectional_frame_config_pass.Q Inst_W_IO4_ConfigMem.Inst_frame2_bit16.Q
+ Inst_W_IO4_ConfigMem.Inst_frame2_bit17.Q VGND VGND VPWR VPWR Inst_W_IO4_switch_matrix.EE4BEG2
+ sky130_fd_sc_hd__mux4_1
X_099_ _002_ _024_ _025_ Inst_W_IO4_ConfigMem.Inst_frame0_bit22.Q VGND VGND VPWR VPWR
+ _026_ sky130_fd_sc_hd__a211oi_1
XFILLER_20_38 VGND VGND VPWR VPWR sky130_fd_sc_hd__decap_3
XFILLER_29_69 VGND VGND VPWR VPWR sky130_fd_sc_hd__fill_2
XFILLER_45_57 VGND VGND VPWR VPWR sky130_fd_sc_hd__fill_2
XFILLER_86_75 VGND VGND VPWR VPWR sky130_fd_sc_hd__fill_2
XTAP_TAPCELL_ROW_67_246 VGND VPWR sky130_fd_sc_hd__tapvpwrvgnd_1
XFILLER_15_49 VGND VGND VPWR VPWR sky130_fd_sc_hd__decap_3
XPHY_EDGE_ROW_1_Right_1 VGND VGND VPWR VPWR sky130_fd_sc_hd__decap_3
XTAP_TAPCELL_ROW_81_260 VGND VPWR sky130_fd_sc_hd__tapvpwrvgnd_1
XFILLER_7_50 VGND VGND VPWR VPWR sky130_fd_sc_hd__decap_3
XFILLER_26_26 VGND VGND VPWR VPWR sky130_fd_sc_hd__fill_2
XPHY_EDGE_ROW_39_Left_128 VGND VGND VPWR VPWR sky130_fd_sc_hd__decap_3
XFILLER_67_33 VGND VGND VPWR VPWR sky130_fd_sc_hd__fill_1
XPHY_EDGE_ROW_48_Left_137 VGND VGND VPWR VPWR sky130_fd_sc_hd__decap_3
XPHY_EDGE_ROW_57_Left_146 VGND VGND VPWR VPWR sky130_fd_sc_hd__decap_3
XFILLER_73_8 VGND VGND VPWR VPWR sky130_fd_sc_hd__decap_3
XTAP_TAPCELL_ROW_37_216 VGND VPWR sky130_fd_sc_hd__tapvpwrvgnd_1
XPHY_EDGE_ROW_66_Left_155 VGND VGND VPWR VPWR sky130_fd_sc_hd__decap_3
XPHY_EDGE_ROW_75_Left_164 VGND VGND VPWR VPWR sky130_fd_sc_hd__decap_3
XPHY_EDGE_ROW_84_Left_173 VGND VGND VPWR VPWR sky130_fd_sc_hd__decap_3
XFILLER_53_13 VGND VGND VPWR VPWR sky130_fd_sc_hd__decap_3
X_270_ net6 net69 VGND VGND VPWR VPWR Inst_W_IO4_ConfigMem.Inst_frame1_bit10.Q sky130_fd_sc_hd__dlxtp_1
XTAP_TAPCELL_ROW_51_230 VGND VPWR sky130_fd_sc_hd__tapvpwrvgnd_1
XFILLER_53_46 VGND VGND VPWR VPWR sky130_fd_sc_hd__decap_3
XFILLER_78_21 VGND VGND VPWR VPWR sky130_fd_sc_hd__decap_3
XFILLER_78_32 VGND VGND VPWR VPWR sky130_fd_sc_hd__decap_3
XFILLER_27_80 VGND VGND VPWR VPWR sky130_fd_sc_hd__fill_1
Xoutput205 net224 VGND VGND VPWR VPWR FrameStrobe_O[4] sky130_fd_sc_hd__buf_2
X_399_ net20 VGND VGND VPWR VPWR net193 sky130_fd_sc_hd__clkbuf_2
XFILLER_48_35 VGND VGND VPWR VPWR sky130_fd_sc_hd__decap_3
XFILLER_48_68 VGND VGND VPWR VPWR sky130_fd_sc_hd__decap_3
XFILLER_9_29 VGND VGND VPWR VPWR sky130_fd_sc_hd__decap_3
X_322_ net28 net77 VGND VGND VPWR VPWR Inst_W_IO4_ConfigMem.Inst_frame0_bit30.Q sky130_fd_sc_hd__dlxtp_1
XFILLER_80_22 VGND VGND VPWR VPWR sky130_fd_sc_hd__decap_3
X_184_ net17 net60 VGND VGND VPWR VPWR net108 sky130_fd_sc_hd__dlxtp_1
Xfanout61 net62 VGND VGND VPWR VPWR net61 sky130_fd_sc_hd__buf_2
Xfanout72 net73 VGND VGND VPWR VPWR net72 sky130_fd_sc_hd__clkbuf_2
X_253_ net22 net68 VGND VGND VPWR VPWR Inst_W_IO4_ConfigMem.Inst_frame2_bit25.Q sky130_fd_sc_hd__dlxtp_1
XFILLER_29_7 VGND VGND VPWR VPWR sky130_fd_sc_hd__decap_3
XTAP_TAPCELL_ROW_21_200 VGND VPWR sky130_fd_sc_hd__tapvpwrvgnd_1
XFILLER_59_45 VGND VGND VPWR VPWR sky130_fd_sc_hd__decap_3
XFILLER_75_55 VGND VGND VPWR VPWR sky130_fd_sc_hd__fill_1
X_305_ net9 net74 VGND VGND VPWR VPWR Inst_W_IO4_ConfigMem.Inst_frame0_bit13.Q sky130_fd_sc_hd__dlxtp_1
X_098_ Inst_W_IO4_ConfigMem.Inst_frame0_bit23.Q Inst_W_IO4_ConfigMem.Inst_frame0_bit24.Q
+ net46 VGND VGND VPWR VPWR _025_ sky130_fd_sc_hd__and3b_1
X_236_ net35 net66 VGND VGND VPWR VPWR Inst_W_IO4_ConfigMem.Inst_frame2_bit8.Q sky130_fd_sc_hd__dlxtp_1
X_167_ net87 net89 net80 Inst_B_IO_1_bidirectional_frame_config_pass.Q Inst_W_IO4_ConfigMem.Inst_frame2_bit18.Q
+ Inst_W_IO4_ConfigMem.Inst_frame2_bit19.Q VGND VGND VPWR VPWR Inst_W_IO4_switch_matrix.EE4BEG3
+ sky130_fd_sc_hd__mux4_1
XFILLER_1_30 VGND VGND VPWR VPWR sky130_fd_sc_hd__fill_2
XFILLER_1_52 VGND VGND VPWR VPWR sky130_fd_sc_hd__decap_3
XFILLER_1_63 VGND VGND VPWR VPWR sky130_fd_sc_hd__decap_3
XPHY_EDGE_ROW_20_Left_109 VGND VGND VPWR VPWR sky130_fd_sc_hd__decap_3
XFILLER_86_32 VGND VGND VPWR VPWR sky130_fd_sc_hd__decap_3
X_219_ net20 net61 VGND VGND VPWR VPWR Inst_W_IO4_ConfigMem.Inst_frame3_bit23.Q sky130_fd_sc_hd__dlxtp_1
XFILLER_15_28 VGND VGND VPWR VPWR sky130_fd_sc_hd__decap_3
XFILLER_56_35 VGND VGND VPWR VPWR sky130_fd_sc_hd__decap_3
XFILLER_56_79 VGND VGND VPWR VPWR sky130_fd_sc_hd__fill_2
XFILLER_11_7 VGND VGND VPWR VPWR sky130_fd_sc_hd__fill_1
XFILLER_7_73 VGND VGND VPWR VPWR sky130_fd_sc_hd__decap_3
XPHY_EDGE_ROW_15_Right_15 VGND VGND VPWR VPWR sky130_fd_sc_hd__decap_3
XPHY_EDGE_ROW_24_Right_24 VGND VGND VPWR VPWR sky130_fd_sc_hd__decap_3
XFILLER_42_15 VGND VGND VPWR VPWR sky130_fd_sc_hd__fill_1
XFILLER_42_26 VGND VGND VPWR VPWR sky130_fd_sc_hd__fill_2
XPHY_EDGE_ROW_33_Right_33 VGND VGND VPWR VPWR sky130_fd_sc_hd__decap_3
XPHY_EDGE_ROW_42_Right_42 VGND VGND VPWR VPWR sky130_fd_sc_hd__decap_3
XPHY_EDGE_ROW_51_Right_51 VGND VGND VPWR VPWR sky130_fd_sc_hd__decap_3
XPHY_EDGE_ROW_60_Right_60 VGND VGND VPWR VPWR sky130_fd_sc_hd__decap_3
XFILLER_78_44 VGND VGND VPWR VPWR sky130_fd_sc_hd__fill_1
X_398_ net19 VGND VGND VPWR VPWR net192 sky130_fd_sc_hd__clkbuf_2
Xoutput206 net225 VGND VGND VPWR VPWR FrameStrobe_O[5] sky130_fd_sc_hd__buf_2
XFILLER_48_25 VGND VGND VPWR VPWR sky130_fd_sc_hd__decap_3
XFILLER_64_13 VGND VGND VPWR VPWR sky130_fd_sc_hd__fill_2
X_321_ net26 net77 VGND VGND VPWR VPWR Inst_W_IO4_ConfigMem.Inst_frame0_bit29.Q sky130_fd_sc_hd__dlxtp_1
Xfanout73 FrameStrobe[1] VGND VGND VPWR VPWR net73 sky130_fd_sc_hd__dlymetal6s2s_1
X_252_ net21 net68 VGND VGND VPWR VPWR Inst_W_IO4_ConfigMem.Inst_frame2_bit24.Q sky130_fd_sc_hd__dlxtp_1
Xfanout62 net64 VGND VGND VPWR VPWR net62 sky130_fd_sc_hd__buf_2
X_183_ net55 net100 net93 net84 Inst_W_IO4_ConfigMem.Inst_frame3_bit18.Q Inst_W_IO4_ConfigMem.Inst_frame3_bit19.Q
+ VGND VGND VPWR VPWR Inst_W_IO4_switch_matrix.E2BEG3 sky130_fd_sc_hd__mux4_1
XFILLER_34_16 VGND VGND VPWR VPWR sky130_fd_sc_hd__decap_3
XFILLER_1_6 VGND VGND VPWR VPWR sky130_fd_sc_hd__decap_3
XFILLER_59_24 VGND VGND VPWR VPWR sky130_fd_sc_hd__decap_3
XFILLER_59_57 VGND VGND VPWR VPWR sky130_fd_sc_hd__decap_3
XTAP_TAPCELL_ROW_88_267 VGND VPWR sky130_fd_sc_hd__tapvpwrvgnd_1
X_304_ net8 net74 VGND VGND VPWR VPWR Inst_W_IO4_ConfigMem.Inst_frame0_bit12.Q sky130_fd_sc_hd__dlxtp_1
X_235_ net34 net65 VGND VGND VPWR VPWR Inst_W_IO4_ConfigMem.Inst_frame2_bit7.Q sky130_fd_sc_hd__dlxtp_1
X_166_ net45 net47 net49 net3 Inst_W_IO4_ConfigMem.Inst_frame2_bit20.Q Inst_W_IO4_ConfigMem.Inst_frame2_bit21.Q
+ VGND VGND VPWR VPWR Inst_W_IO4_switch_matrix.EE4BEG4 sky130_fd_sc_hd__mux4_1
X_097_ net59 net44 Inst_W_IO4_ConfigMem.Inst_frame0_bit23.Q VGND VGND VPWR VPWR _024_
+ sky130_fd_sc_hd__mux2_1
XFILLER_41_7 VGND VGND VPWR VPWR sky130_fd_sc_hd__fill_1
XFILLER_1_75 VGND VGND VPWR VPWR sky130_fd_sc_hd__decap_3
XFILLER_20_29 VGND VGND VPWR VPWR sky130_fd_sc_hd__decap_3
XFILLER_86_44 VGND VGND VPWR VPWR sky130_fd_sc_hd__fill_2
XFILLER_19_71 VGND VGND VPWR VPWR sky130_fd_sc_hd__decap_3
XPHY_EDGE_ROW_2_Left_91 VGND VGND VPWR VPWR sky130_fd_sc_hd__decap_3
X_218_ net19 net61 VGND VGND VPWR VPWR Inst_W_IO4_ConfigMem.Inst_frame3_bit22.Q sky130_fd_sc_hd__dlxtp_1
X_149_ net42 Inst_A_IO_1_bidirectional_frame_config_pass.Q net98 Inst_C_IO_1_bidirectional_frame_config_pass.Q
+ Inst_W_IO4_ConfigMem.Inst_frame1_bit23.Q Inst_W_IO4_ConfigMem.Inst_frame1_bit22.Q
+ VGND VGND VPWR VPWR Inst_W_IO4_switch_matrix.E6BEG5 sky130_fd_sc_hd__mux4_1
XFILLER_32_3 VGND VGND VPWR VPWR sky130_fd_sc_hd__fill_2
XFILLER_31_17 VGND VGND VPWR VPWR sky130_fd_sc_hd__fill_2
XTAP_TAPCELL_ROW_58_237 VGND VPWR sky130_fd_sc_hd__tapvpwrvgnd_1
XFILLER_72_24 VGND VGND VPWR VPWR sky130_fd_sc_hd__decap_3
XFILLER_72_35 VGND VGND VPWR VPWR sky130_fd_sc_hd__decap_3
XTAP_TAPCELL_ROW_72_251 VGND VPWR sky130_fd_sc_hd__tapvpwrvgnd_1
XFILLER_7_63 VGND VGND VPWR VPWR sky130_fd_sc_hd__decap_3
XFILLER_7_41 VGND VGND VPWR VPWR sky130_fd_sc_hd__decap_3
XFILLER_26_17 VGND VGND VPWR VPWR sky130_fd_sc_hd__decap_3
XFILLER_26_39 VGND VGND VPWR VPWR sky130_fd_sc_hd__decap_3
XFILLER_83_34 VGND VGND VPWR VPWR sky130_fd_sc_hd__fill_1
XTAP_TAPCELL_ROW_13_192 VGND VPWR sky130_fd_sc_hd__tapvpwrvgnd_1
XTAP_TAPCELL_ROW_28_207 VGND VPWR sky130_fd_sc_hd__tapvpwrvgnd_1
XFILLER_53_37 VGND VGND VPWR VPWR sky130_fd_sc_hd__decap_3
XFILLER_27_60 VGND VGND VPWR VPWR sky130_fd_sc_hd__decap_3
XTAP_TAPCELL_ROW_42_221 VGND VPWR sky130_fd_sc_hd__tapvpwrvgnd_1
X_397_ net18 VGND VGND VPWR VPWR net191 sky130_fd_sc_hd__clkbuf_1
Xoutput207 net226 VGND VGND VPWR VPWR FrameStrobe_O[6] sky130_fd_sc_hd__buf_2
XFILLER_48_59 VGND VGND VPWR VPWR sky130_fd_sc_hd__decap_3
XFILLER_64_58 VGND VGND VPWR VPWR sky130_fd_sc_hd__fill_1
X_251_ net20 net66 VGND VGND VPWR VPWR Inst_W_IO4_ConfigMem.Inst_frame2_bit23.Q sky130_fd_sc_hd__dlxtp_1
X_320_ net25 net76 VGND VGND VPWR VPWR Inst_W_IO4_ConfigMem.Inst_frame0_bit28.Q sky130_fd_sc_hd__dlxtp_1
Xfanout74 net76 VGND VGND VPWR VPWR net74 sky130_fd_sc_hd__clkbuf_2
X_182_ net54 net99 net92 net83 Inst_W_IO4_ConfigMem.Inst_frame3_bit20.Q Inst_W_IO4_ConfigMem.Inst_frame3_bit21.Q
+ VGND VGND VPWR VPWR Inst_W_IO4_switch_matrix.E2BEG4 sky130_fd_sc_hd__mux4_1
Xfanout63 net64 VGND VGND VPWR VPWR net63 sky130_fd_sc_hd__buf_2
XFILLER_50_38 VGND VGND VPWR VPWR sky130_fd_sc_hd__decap_3
XTAP_TAPCELL_ROW_88_268 VGND VPWR sky130_fd_sc_hd__tapvpwrvgnd_1
XFILLER_75_13 VGND VGND VPWR VPWR sky130_fd_sc_hd__fill_2
X_165_ net46 net48 net50 net4 Inst_W_IO4_ConfigMem.Inst_frame2_bit22.Q Inst_W_IO4_ConfigMem.Inst_frame2_bit23.Q
+ VGND VGND VPWR VPWR Inst_W_IO4_switch_matrix.EE4BEG5 sky130_fd_sc_hd__mux4_1
X_303_ net7 net74 VGND VGND VPWR VPWR Inst_W_IO4_ConfigMem.Inst_frame0_bit11.Q sky130_fd_sc_hd__dlxtp_1
X_234_ net33 net65 VGND VGND VPWR VPWR Inst_W_IO4_ConfigMem.Inst_frame2_bit6.Q sky130_fd_sc_hd__dlxtp_1
XFILLER_34_7 VGND VGND VPWR VPWR sky130_fd_sc_hd__decap_3
XFILLER_40_60 VGND VGND VPWR VPWR sky130_fd_sc_hd__decap_3
X_096_ Inst_W_IO4_ConfigMem.Inst_frame0_bit15.Q _021_ _022_ _023_ _020_ VGND VGND
+ VPWR VPWR net113 sky130_fd_sc_hd__a41o_1
XFILLER_1_21 VGND VGND VPWR VPWR sky130_fd_sc_hd__decap_3
XFILLER_20_19 VGND VGND VPWR VPWR sky130_fd_sc_hd__decap_3
XFILLER_10_52 VGND VGND VPWR VPWR sky130_fd_sc_hd__fill_2
XFILLER_19_50 VGND VGND VPWR VPWR sky130_fd_sc_hd__fill_2
X_148_ net40 net2 net105 net4 Inst_W_IO4_ConfigMem.Inst_frame1_bit25.Q Inst_W_IO4_ConfigMem.Inst_frame1_bit24.Q
+ VGND VGND VPWR VPWR Inst_W_IO4_switch_matrix.E6BEG6 sky130_fd_sc_hd__mux4_1
X_217_ net18 net63 VGND VGND VPWR VPWR Inst_W_IO4_ConfigMem.Inst_frame3_bit21.Q sky130_fd_sc_hd__dlxtp_1
XFILLER_25_3 VGND VGND VPWR VPWR sky130_fd_sc_hd__decap_3
X_079_ net39 net42 Inst_B_IO_1_bidirectional_frame_config_pass.Q Inst_D_IO_1_bidirectional_frame_config_pass.Q
+ Inst_W_IO4_ConfigMem.Inst_frame3_bit10.Q Inst_W_IO4_ConfigMem.Inst_frame3_bit11.Q
+ VGND VGND VPWR VPWR Inst_W_IO4_switch_matrix.E1BEG3 sky130_fd_sc_hd__mux4_1
XFILLER_21_40 VGND VGND VPWR VPWR sky130_fd_sc_hd__fill_2
XFILLER_21_51 VGND VGND VPWR VPWR sky130_fd_sc_hd__decap_3
XFILLER_7_53 VGND VGND VPWR VPWR sky130_fd_sc_hd__decap_3
XPHY_EDGE_ROW_5_Right_5 VGND VGND VPWR VPWR sky130_fd_sc_hd__decap_3
XFILLER_26_29 VGND VGND VPWR VPWR sky130_fd_sc_hd__fill_1
XPHY_EDGE_ROW_17_Left_106 VGND VGND VPWR VPWR sky130_fd_sc_hd__decap_3
XPHY_EDGE_ROW_26_Left_115 VGND VGND VPWR VPWR sky130_fd_sc_hd__decap_3
XPHY_EDGE_ROW_35_Left_124 VGND VGND VPWR VPWR sky130_fd_sc_hd__decap_3
XPHY_EDGE_ROW_44_Left_133 VGND VGND VPWR VPWR sky130_fd_sc_hd__decap_3
XPHY_EDGE_ROW_53_Left_142 VGND VGND VPWR VPWR sky130_fd_sc_hd__decap_3
XFILLER_53_49 VGND VGND VPWR VPWR sky130_fd_sc_hd__decap_3
XPHY_EDGE_ROW_62_Left_151 VGND VGND VPWR VPWR sky130_fd_sc_hd__decap_3
XFILLER_78_24 VGND VGND VPWR VPWR sky130_fd_sc_hd__decap_3
XPHY_EDGE_ROW_71_Left_160 VGND VGND VPWR VPWR sky130_fd_sc_hd__decap_3
XFILLER_78_35 VGND VGND VPWR VPWR sky130_fd_sc_hd__decap_3
XFILLER_78_57 VGND VGND VPWR VPWR sky130_fd_sc_hd__fill_1
XFILLER_78_79 VGND VGND VPWR VPWR sky130_fd_sc_hd__fill_2
XTAP_TAPCELL_ROW_4_183 VGND VPWR sky130_fd_sc_hd__tapvpwrvgnd_1
X_396_ net17 VGND VGND VPWR VPWR net190 sky130_fd_sc_hd__clkbuf_1
Xoutput208 net227 VGND VGND VPWR VPWR FrameStrobe_O[7] sky130_fd_sc_hd__buf_2
XFILLER_4_32 VGND VGND VPWR VPWR sky130_fd_sc_hd__fill_1
XFILLER_4_21 VGND VGND VPWR VPWR sky130_fd_sc_hd__decap_3
XFILLER_64_7 VGND VGND VPWR VPWR sky130_fd_sc_hd__decap_3
X_250_ net19 net66 VGND VGND VPWR VPWR Inst_W_IO4_ConfigMem.Inst_frame2_bit22.Q sky130_fd_sc_hd__dlxtp_1
Xfanout75 net76 VGND VGND VPWR VPWR net75 sky130_fd_sc_hd__buf_1
X_181_ net53 net98 net91 net82 Inst_W_IO4_ConfigMem.Inst_frame3_bit22.Q Inst_W_IO4_ConfigMem.Inst_frame3_bit23.Q
+ VGND VGND VPWR VPWR Inst_W_IO4_switch_matrix.E2BEG5 sky130_fd_sc_hd__mux4_1
XFILLER_80_25 VGND VGND VPWR VPWR sky130_fd_sc_hd__decap_3
XFILLER_80_47 VGND VGND VPWR VPWR sky130_fd_sc_hd__decap_3
Xfanout64 FrameStrobe[3] VGND VGND VPWR VPWR net64 sky130_fd_sc_hd__clkbuf_2
X_379_ net30 VGND VGND VPWR VPWR net203 sky130_fd_sc_hd__buf_1
XFILLER_59_15 VGND VGND VPWR VPWR sky130_fd_sc_hd__decap_3
XFILLER_59_48 VGND VGND VPWR VPWR sky130_fd_sc_hd__decap_3
X_302_ net6 net74 VGND VGND VPWR VPWR Inst_W_IO4_ConfigMem.Inst_frame0_bit10.Q sky130_fd_sc_hd__dlxtp_1
X_095_ net47 Inst_W_IO4_ConfigMem.Inst_frame0_bit16.Q VGND VGND VPWR VPWR _023_ sky130_fd_sc_hd__nand2_1
X_164_ net53 net55 net57 Inst_C_IO_1_bidirectional_frame_config_pass.Q Inst_W_IO4_ConfigMem.Inst_frame2_bit24.Q
+ Inst_W_IO4_ConfigMem.Inst_frame2_bit25.Q VGND VGND VPWR VPWR Inst_W_IO4_switch_matrix.EE4BEG6
+ sky130_fd_sc_hd__mux4_1
X_233_ net32 net66 VGND VGND VPWR VPWR Inst_W_IO4_ConfigMem.Inst_frame2_bit5.Q sky130_fd_sc_hd__dlxtp_1
XFILLER_1_44 VGND VGND VPWR VPWR sky130_fd_sc_hd__decap_3
XFILLER_1_55 VGND VGND VPWR VPWR sky130_fd_sc_hd__fill_1
XFILLER_1_66 VGND VGND VPWR VPWR sky130_fd_sc_hd__decap_3
XTAP_TAPCELL_ROW_79_258 VGND VPWR sky130_fd_sc_hd__tapvpwrvgnd_1
XFILLER_45_17 VGND VGND VPWR VPWR sky130_fd_sc_hd__decap_3
XFILLER_10_75 VGND VGND VPWR VPWR sky130_fd_sc_hd__fill_2
X_078_ net59 net103 net96 net87 Inst_W_IO4_ConfigMem.Inst_frame3_bit12.Q Inst_W_IO4_ConfigMem.Inst_frame3_bit13.Q
+ VGND VGND VPWR VPWR Inst_W_IO4_switch_matrix.E2BEG0 sky130_fd_sc_hd__mux4_1
X_147_ net39 Inst_B_IO_1_bidirectional_frame_config_pass.Q net104 Inst_D_IO_1_bidirectional_frame_config_pass.Q
+ Inst_W_IO4_ConfigMem.Inst_frame1_bit27.Q Inst_W_IO4_ConfigMem.Inst_frame1_bit26.Q
+ VGND VGND VPWR VPWR Inst_W_IO4_switch_matrix.E6BEG7 sky130_fd_sc_hd__mux4_1
X_216_ net17 net63 VGND VGND VPWR VPWR Inst_W_IO4_ConfigMem.Inst_frame3_bit20.Q sky130_fd_sc_hd__dlxtp_1
XFILLER_18_3 VGND VGND VPWR VPWR sky130_fd_sc_hd__decap_3
XFILLER_56_38 VGND VGND VPWR VPWR sky130_fd_sc_hd__fill_2
XFILLER_72_15 VGND VGND VPWR VPWR sky130_fd_sc_hd__decap_3
XTAP_TAPCELL_ROW_49_228 VGND VPWR sky130_fd_sc_hd__tapvpwrvgnd_1
XFILLER_7_76 VGND VGND VPWR VPWR sky130_fd_sc_hd__decap_3
XFILLER_42_29 VGND VGND VPWR VPWR sky130_fd_sc_hd__decap_3
Xclkbuf_1_0__f_UserCLK_regs clknet_0_UserCLK_regs VGND VGND VPWR VPWR clknet_1_0__leaf_UserCLK_regs
+ sky130_fd_sc_hd__clkbuf_16
XTAP_TAPCELL_ROW_63_242 VGND VPWR sky130_fd_sc_hd__tapvpwrvgnd_1
XFILLER_83_69 VGND VGND VPWR VPWR sky130_fd_sc_hd__decap_3
XPHY_EDGE_ROW_11_Right_11 VGND VGND VPWR VPWR sky130_fd_sc_hd__decap_3
XPHY_EDGE_ROW_20_Right_20 VGND VGND VPWR VPWR sky130_fd_sc_hd__decap_3
XFILLER_85_3 VGND VGND VPWR VPWR sky130_fd_sc_hd__fill_2
XFILLER_37_29 VGND VGND VPWR VPWR sky130_fd_sc_hd__decap_3
XFILLER_53_28 VGND VGND VPWR VPWR sky130_fd_sc_hd__decap_3
XFILLER_27_40 VGND VGND VPWR VPWR sky130_fd_sc_hd__decap_3
X_395_ net15 VGND VGND VPWR VPWR net188 sky130_fd_sc_hd__clkbuf_1
XFILLER_43_72 VGND VGND VPWR VPWR sky130_fd_sc_hd__fill_1
Xoutput209 net228 VGND VGND VPWR VPWR FrameStrobe_O[8] sky130_fd_sc_hd__buf_2
XTAP_TAPCELL_ROW_33_212 VGND VPWR sky130_fd_sc_hd__tapvpwrvgnd_1
XFILLER_64_27 VGND VGND VPWR VPWR sky130_fd_sc_hd__fill_1
Xfanout76 net77 VGND VGND VPWR VPWR net76 sky130_fd_sc_hd__clkbuf_2
X_180_ net52 net97 net105 net81 Inst_W_IO4_ConfigMem.Inst_frame3_bit24.Q Inst_W_IO4_ConfigMem.Inst_frame3_bit25.Q
+ VGND VGND VPWR VPWR Inst_W_IO4_switch_matrix.E2BEG6 sky130_fd_sc_hd__mux4_1
Xfanout65 net66 VGND VGND VPWR VPWR net65 sky130_fd_sc_hd__clkbuf_2
XFILLER_38_50 VGND VGND VPWR VPWR sky130_fd_sc_hd__fill_2
XFILLER_54_60 VGND VGND VPWR VPWR sky130_fd_sc_hd__decap_3
X_378_ net27 VGND VGND VPWR VPWR net200 sky130_fd_sc_hd__buf_1
XFILLER_34_19 VGND VGND VPWR VPWR sky130_fd_sc_hd__decap_3
XFILLER_50_29 VGND VGND VPWR VPWR sky130_fd_sc_hd__decap_3
XFILLER_59_27 VGND VGND VPWR VPWR sky130_fd_sc_hd__fill_2
X_301_ net36 net74 VGND VGND VPWR VPWR Inst_W_IO4_ConfigMem.Inst_frame0_bit9.Q sky130_fd_sc_hd__dlxtp_1
X_232_ net31 net66 VGND VGND VPWR VPWR Inst_W_IO4_ConfigMem.Inst_frame2_bit4.Q sky130_fd_sc_hd__dlxtp_1
X_163_ net54 net59 net56 Inst_D_IO_1_bidirectional_frame_config_pass.Q Inst_W_IO4_ConfigMem.Inst_frame2_bit27.Q
+ Inst_W_IO4_ConfigMem.Inst_frame2_bit26.Q VGND VGND VPWR VPWR Inst_W_IO4_switch_matrix.EE4BEG7
+ sky130_fd_sc_hd__mux4_1
X_094_ Inst_W_IO4_ConfigMem.Inst_frame0_bit16.Q net49 Inst_W_IO4_ConfigMem.Inst_frame0_bit17.Q
+ VGND VGND VPWR VPWR _022_ sky130_fd_sc_hd__o21ai_1
XFILLER_1_78 VGND VGND VPWR VPWR sky130_fd_sc_hd__decap_3
XPHY_EDGE_ROW_49_Right_49 VGND VGND VPWR VPWR sky130_fd_sc_hd__decap_3
XPHY_EDGE_ROW_58_Right_58 VGND VGND VPWR VPWR sky130_fd_sc_hd__decap_3
XFILLER_61_17 VGND VGND VPWR VPWR sky130_fd_sc_hd__fill_2
XPHY_EDGE_ROW_67_Right_67 VGND VGND VPWR VPWR sky130_fd_sc_hd__decap_3
XFILLER_10_43 VGND VGND VPWR VPWR sky130_fd_sc_hd__decap_3
XFILLER_10_32 VGND VGND VPWR VPWR sky130_fd_sc_hd__fill_2
XFILLER_19_74 VGND VGND VPWR VPWR sky130_fd_sc_hd__decap_3
XPHY_EDGE_ROW_76_Right_76 VGND VGND VPWR VPWR sky130_fd_sc_hd__decap_3
XPHY_EDGE_ROW_85_Right_85 VGND VGND VPWR VPWR sky130_fd_sc_hd__decap_3
X_215_ net15 net61 VGND VGND VPWR VPWR Inst_W_IO4_ConfigMem.Inst_frame3_bit19.Q sky130_fd_sc_hd__dlxtp_1
X_077_ net57 net102 net95 net86 Inst_W_IO4_ConfigMem.Inst_frame3_bit14.Q Inst_W_IO4_ConfigMem.Inst_frame3_bit15.Q
+ VGND VGND VPWR VPWR Inst_W_IO4_switch_matrix.E2BEG1 sky130_fd_sc_hd__mux4_1
X_146_ net101 net94 net2 net4 Inst_W_IO4_ConfigMem.Inst_frame1_bit28.Q Inst_W_IO4_ConfigMem.Inst_frame1_bit29.Q
+ VGND VGND VPWR VPWR Inst_W_IO4_switch_matrix.E6BEG8 sky130_fd_sc_hd__mux4_1
XFILLER_72_27 VGND VGND VPWR VPWR sky130_fd_sc_hd__fill_1
XFILLER_72_38 VGND VGND VPWR VPWR sky130_fd_sc_hd__decap_3
XFILLER_21_31 VGND VGND VPWR VPWR sky130_fd_sc_hd__decap_3
XPHY_EDGE_ROW_6_Left_95 VGND VGND VPWR VPWR sky130_fd_sc_hd__decap_3
XFILLER_7_44 VGND VGND VPWR VPWR sky130_fd_sc_hd__decap_3
XFILLER_62_71 VGND VGND VPWR VPWR sky130_fd_sc_hd__fill_2
X_129_ net47 net48 net49 net50 Inst_W_IO4_ConfigMem.Inst_frame0_bit11.Q Inst_W_IO4_ConfigMem.Inst_frame0_bit12.Q
+ VGND VGND VPWR VPWR _052_ sky130_fd_sc_hd__mux4_1
Xinput80 WW4END[3] VGND VGND VPWR VPWR net99 sky130_fd_sc_hd__dlymetal6s2s_1
XFILLER_78_15 VGND VGND VPWR VPWR sky130_fd_sc_hd__decap_3
XFILLER_27_52 VGND VGND VPWR VPWR sky130_fd_sc_hd__decap_3
X_394_ net14 VGND VGND VPWR VPWR net187 sky130_fd_sc_hd__clkbuf_1
XFILLER_48_29 VGND VGND VPWR VPWR sky130_fd_sc_hd__decap_3
XFILLER_13_21 VGND VGND VPWR VPWR sky130_fd_sc_hd__decap_3
Xfanout77 net37 VGND VGND VPWR VPWR net77 sky130_fd_sc_hd__clkbuf_2
Xfanout66 FrameStrobe[2] VGND VGND VPWR VPWR net66 sky130_fd_sc_hd__buf_2
X_377_ net16 VGND VGND VPWR VPWR net189 sky130_fd_sc_hd__clkbuf_1
XFILLER_75_27 VGND VGND VPWR VPWR sky130_fd_sc_hd__decap_3
X_162_ net86 net88 net79 net3 Inst_W_IO4_ConfigMem.Inst_frame2_bit28.Q Inst_W_IO4_ConfigMem.Inst_frame2_bit29.Q
+ VGND VGND VPWR VPWR Inst_W_IO4_switch_matrix.EE4BEG8 sky130_fd_sc_hd__mux4_1
X_300_ net35 net74 VGND VGND VPWR VPWR Inst_W_IO4_ConfigMem.Inst_frame0_bit8.Q sky130_fd_sc_hd__dlxtp_1
XFILLER_24_42 VGND VGND VPWR VPWR sky130_fd_sc_hd__decap_3
X_231_ net30 net65 VGND VGND VPWR VPWR Inst_W_IO4_ConfigMem.Inst_frame2_bit3.Q sky130_fd_sc_hd__dlxtp_1
XFILLER_40_63 VGND VGND VPWR VPWR sky130_fd_sc_hd__decap_3
X_093_ Inst_W_IO4_ConfigMem.Inst_frame0_bit16.Q Inst_W_IO4_ConfigMem.Inst_frame0_bit17.Q
+ net59 VGND VGND VPWR VPWR _021_ sky130_fd_sc_hd__or3b_1
XFILLER_1_24 VGND VGND VPWR VPWR sky130_fd_sc_hd__decap_3
XFILLER_49_50 VGND VGND VPWR VPWR sky130_fd_sc_hd__decap_3
XFILLER_1_57 VGND VGND VPWR VPWR sky130_fd_sc_hd__decap_3
XFILLER_60_3 VGND VGND VPWR VPWR sky130_fd_sc_hd__fill_2
Xinput1 A_O_top VGND VGND VPWR VPWR net1 sky130_fd_sc_hd__buf_2
XTAP_TAPCELL_ROW_84_263 VGND VPWR sky130_fd_sc_hd__tapvpwrvgnd_1
X_145_ net100 net93 Inst_B_IO_1_bidirectional_frame_config_pass.Q Inst_D_IO_1_bidirectional_frame_config_pass.Q
+ Inst_W_IO4_ConfigMem.Inst_frame1_bit30.Q Inst_W_IO4_ConfigMem.Inst_frame1_bit31.Q
+ VGND VGND VPWR VPWR Inst_W_IO4_switch_matrix.E6BEG9 sky130_fd_sc_hd__mux4_1
XFILLER_51_51 VGND VGND VPWR VPWR sky130_fd_sc_hd__decap_3
X_214_ net14 net61 VGND VGND VPWR VPWR Inst_W_IO4_ConfigMem.Inst_frame3_bit18.Q sky130_fd_sc_hd__dlxtp_1
X_076_ net56 net101 net94 net85 Inst_W_IO4_ConfigMem.Inst_frame3_bit16.Q Inst_W_IO4_ConfigMem.Inst_frame3_bit17.Q
+ VGND VGND VPWR VPWR Inst_W_IO4_switch_matrix.E2BEG2 sky130_fd_sc_hd__mux4_1
XFILLER_56_29 VGND VGND VPWR VPWR sky130_fd_sc_hd__decap_3
XFILLER_21_54 VGND VGND VPWR VPWR sky130_fd_sc_hd__fill_2
Xoutput190 net209 VGND VGND VPWR VPWR FrameData_O[9] sky130_fd_sc_hd__buf_2
Xclkbuf_1_0__f_UserCLK clknet_0_UserCLK VGND VGND VPWR VPWR clknet_1_0__leaf_UserCLK
+ sky130_fd_sc_hd__clkbuf_16
X_128_ Inst_W_IO4_ConfigMem.Inst_frame0_bit13.Q _050_ VGND VGND VPWR VPWR _051_ sky130_fd_sc_hd__or2_1
Xinput81 WW4END[4] VGND VGND VPWR VPWR net100 sky130_fd_sc_hd__buf_1
Xinput70 W6END[9] VGND VGND VPWR VPWR net89 sky130_fd_sc_hd__buf_1
XFILLER_16_32 VGND VGND VPWR VPWR sky130_fd_sc_hd__fill_1
XTAP_TAPCELL_ROW_54_233 VGND VPWR sky130_fd_sc_hd__tapvpwrvgnd_1
XFILLER_32_20 VGND VGND VPWR VPWR sky130_fd_sc_hd__decap_3
XPHY_EDGE_ROW_9_Right_9 VGND VGND VPWR VPWR sky130_fd_sc_hd__decap_3
XPHY_EDGE_ROW_13_Left_102 VGND VGND VPWR VPWR sky130_fd_sc_hd__decap_3
XPHY_EDGE_ROW_22_Left_111 VGND VGND VPWR VPWR sky130_fd_sc_hd__decap_3
XPHY_EDGE_ROW_31_Left_120 VGND VGND VPWR VPWR sky130_fd_sc_hd__decap_3
XFILLER_78_27 VGND VGND VPWR VPWR sky130_fd_sc_hd__fill_1
XFILLER_78_38 VGND VGND VPWR VPWR sky130_fd_sc_hd__decap_3
XFILLER_27_31 VGND VGND VPWR VPWR sky130_fd_sc_hd__decap_3
XFILLER_43_30 VGND VGND VPWR VPWR sky130_fd_sc_hd__fill_1
XFILLER_43_52 VGND VGND VPWR VPWR sky130_fd_sc_hd__decap_3
X_393_ net13 VGND VGND VPWR VPWR net186 sky130_fd_sc_hd__clkbuf_1
XFILLER_4_24 VGND VGND VPWR VPWR sky130_fd_sc_hd__decap_3
XFILLER_64_29 VGND VGND VPWR VPWR sky130_fd_sc_hd__fill_2
XTAP_TAPCELL_ROW_24_203 VGND VPWR sky130_fd_sc_hd__tapvpwrvgnd_1
Xfanout67 FrameStrobe[2] VGND VGND VPWR VPWR net67 sky130_fd_sc_hd__buf_2
XFILLER_38_41 VGND VGND VPWR VPWR sky130_fd_sc_hd__decap_3
XFILLER_38_63 VGND VGND VPWR VPWR sky130_fd_sc_hd__decap_3
XFILLER_54_51 VGND VGND VPWR VPWR sky130_fd_sc_hd__decap_3
X_376_ net5 VGND VGND VPWR VPWR net178 sky130_fd_sc_hd__clkbuf_1
XFILLER_59_18 VGND VGND VPWR VPWR sky130_fd_sc_hd__decap_3
X_230_ net27 net65 VGND VGND VPWR VPWR Inst_W_IO4_ConfigMem.Inst_frame2_bit2.Q sky130_fd_sc_hd__dlxtp_1
X_161_ net83 net87 net85 net4 Inst_W_IO4_ConfigMem.Inst_frame2_bit31.Q Inst_W_IO4_ConfigMem.Inst_frame2_bit30.Q
+ VGND VGND VPWR VPWR Inst_W_IO4_switch_matrix.EE4BEG9 sky130_fd_sc_hd__mux4_1
X_092_ _001_ _018_ _019_ Inst_W_IO4_ConfigMem.Inst_frame0_bit15.Q VGND VGND VPWR VPWR
+ _020_ sky130_fd_sc_hd__a211oi_1
XFILLER_1_47 VGND VGND VPWR VPWR sky130_fd_sc_hd__fill_2
XFILLER_1_69 VGND VGND VPWR VPWR sky130_fd_sc_hd__decap_3
X_428_ clknet_1_0__leaf_UserCLK VGND VGND VPWR VPWR net230 sky130_fd_sc_hd__buf_2
XFILLER_81_60 VGND VGND VPWR VPWR sky130_fd_sc_hd__decap_3
X_359_ Inst_W_IO4_switch_matrix.E6BEG11 VGND VGND VPWR VPWR net152 sky130_fd_sc_hd__clkbuf_1
Xinput2 B_O_top VGND VGND VPWR VPWR net2 sky130_fd_sc_hd__buf_2
XFILLER_10_23 VGND VGND VPWR VPWR sky130_fd_sc_hd__decap_3
XFILLER_86_27 VGND VGND VPWR VPWR sky130_fd_sc_hd__fill_1
X_075_ Inst_W_IO4_ConfigMem.Inst_frame0_bit7.Q VGND VGND VPWR VPWR _011_ sky130_fd_sc_hd__inv_2
X_144_ net40 net2 net97 net4 Inst_W_IO4_ConfigMem.Inst_frame0_bit1.Q Inst_W_IO4_ConfigMem.Inst_frame0_bit0.Q
+ VGND VGND VPWR VPWR Inst_W_IO4_switch_matrix.E6BEG10 sky130_fd_sc_hd__mux4_1
X_213_ net13 net63 VGND VGND VPWR VPWR Inst_W_IO4_ConfigMem.Inst_frame3_bit17.Q sky130_fd_sc_hd__dlxtp_1
XPHY_EDGE_ROW_69_Left_158 VGND VGND VPWR VPWR sky130_fd_sc_hd__decap_3
XPHY_EDGE_ROW_78_Left_167 VGND VGND VPWR VPWR sky130_fd_sc_hd__decap_3
XPHY_EDGE_ROW_87_Left_176 VGND VGND VPWR VPWR sky130_fd_sc_hd__decap_3
XFILLER_72_18 VGND VGND VPWR VPWR sky130_fd_sc_hd__decap_3
XFILLER_72_29 VGND VGND VPWR VPWR sky130_fd_sc_hd__decap_3
XFILLER_21_22 VGND VGND VPWR VPWR sky130_fd_sc_hd__decap_3
Xoutput191 net210 VGND VGND VPWR VPWR FrameStrobe_O[0] sky130_fd_sc_hd__buf_2
Xoutput180 net199 VGND VGND VPWR VPWR FrameData_O[29] sky130_fd_sc_hd__buf_2
XFILLER_87_9 VGND VGND VPWR VPWR sky130_fd_sc_hd__fill_2
XFILLER_7_79 VGND VGND VPWR VPWR sky130_fd_sc_hd__fill_2
XFILLER_7_57 VGND VGND VPWR VPWR sky130_fd_sc_hd__decap_3
X_127_ net43 net45 net44 net46 Inst_W_IO4_ConfigMem.Inst_frame0_bit12.Q Inst_W_IO4_ConfigMem.Inst_frame0_bit11.Q
+ VGND VGND VPWR VPWR _050_ sky130_fd_sc_hd__mux4_1
Xinput71 WW4END[0] VGND VGND VPWR VPWR net90 sky130_fd_sc_hd__buf_1
Xinput82 WW4END[5] VGND VGND VPWR VPWR net101 sky130_fd_sc_hd__dlymetal6s2s_1
Xinput60 W6END[10] VGND VGND VPWR VPWR net79 sky130_fd_sc_hd__dlymetal6s2s_1
XFILLER_83_28 VGND VGND VPWR VPWR sky130_fd_sc_hd__decap_3
XFILLER_16_22 VGND VGND VPWR VPWR sky130_fd_sc_hd__decap_3
XFILLER_32_32 VGND VGND VPWR VPWR sky130_fd_sc_hd__decap_3
XFILLER_27_21 VGND VGND VPWR VPWR sky130_fd_sc_hd__decap_3
XFILLER_27_43 VGND VGND VPWR VPWR sky130_fd_sc_hd__decap_3
X_392_ net12 VGND VGND VPWR VPWR net185 sky130_fd_sc_hd__clkbuf_1
XTAP_TAPCELL_ROW_10_189 VGND VPWR sky130_fd_sc_hd__tapvpwrvgnd_1
XFILLER_4_36 VGND VGND VPWR VPWR sky130_fd_sc_hd__decap_3
Xfanout68 FrameStrobe[2] VGND VGND VPWR VPWR net68 sky130_fd_sc_hd__dlymetal6s2s_1
XFILLER_54_63 VGND VGND VPWR VPWR sky130_fd_sc_hd__decap_3
X_375_ Inst_W_IO4_switch_matrix.EE4BEG15 VGND VGND VPWR VPWR net168 sky130_fd_sc_hd__clkbuf_1
XPHY_EDGE_ROW_50_Left_139 VGND VGND VPWR VPWR sky130_fd_sc_hd__decap_3
XFILLER_40_21 VGND VGND VPWR VPWR sky130_fd_sc_hd__fill_1
XFILLER_40_32 VGND VGND VPWR VPWR sky130_fd_sc_hd__decap_3
X_091_ Inst_W_IO4_ConfigMem.Inst_frame0_bit16.Q net48 Inst_W_IO4_ConfigMem.Inst_frame0_bit17.Q
+ VGND VGND VPWR VPWR _019_ sky130_fd_sc_hd__and3b_1
X_160_ net78 net82 net84 net1 Inst_W_IO4_ConfigMem.Inst_frame1_bit0.Q Inst_W_IO4_ConfigMem.Inst_frame1_bit1.Q
+ VGND VGND VPWR VPWR Inst_W_IO4_switch_matrix.EE4BEG10 sky130_fd_sc_hd__mux4_1
Xclkbuf_regs_0_UserCLK UserCLK VGND VGND VPWR VPWR UserCLK_regs sky130_fd_sc_hd__clkbuf_16
X_427_ FrameStrobe[19] VGND VGND VPWR VPWR net220 sky130_fd_sc_hd__clkbuf_1
X_358_ Inst_W_IO4_switch_matrix.E6BEG10 VGND VGND VPWR VPWR net151 sky130_fd_sc_hd__buf_1
XFILLER_81_50 VGND VGND VPWR VPWR sky130_fd_sc_hd__decap_3
XFILLER_81_72 VGND VGND VPWR VPWR sky130_fd_sc_hd__decap_3
X_289_ net26 net69 VGND VGND VPWR VPWR Inst_W_IO4_ConfigMem.Inst_frame1_bit29.Q sky130_fd_sc_hd__dlxtp_1
XPHY_EDGE_ROW_18_Right_18 VGND VGND VPWR VPWR sky130_fd_sc_hd__decap_3
Xinput3 C_O_top VGND VGND VPWR VPWR net3 sky130_fd_sc_hd__buf_2
XPHY_EDGE_ROW_27_Right_27 VGND VGND VPWR VPWR sky130_fd_sc_hd__decap_3
XFILLER_10_46 VGND VGND VPWR VPWR sky130_fd_sc_hd__decap_3
XPHY_EDGE_ROW_36_Right_36 VGND VGND VPWR VPWR sky130_fd_sc_hd__decap_3
XPHY_EDGE_ROW_45_Right_45 VGND VGND VPWR VPWR sky130_fd_sc_hd__decap_3
X_212_ net12 net63 VGND VGND VPWR VPWR Inst_W_IO4_ConfigMem.Inst_frame3_bit16.Q sky130_fd_sc_hd__dlxtp_1
X_074_ Inst_W_IO4_ConfigMem.Inst_frame0_bit6.Q VGND VGND VPWR VPWR _010_ sky130_fd_sc_hd__inv_1
X_143_ net39 Inst_B_IO_1_bidirectional_frame_config_pass.Q net90 Inst_D_IO_1_bidirectional_frame_config_pass.Q
+ Inst_W_IO4_ConfigMem.Inst_frame0_bit3.Q Inst_W_IO4_ConfigMem.Inst_frame0_bit2.Q
+ VGND VGND VPWR VPWR Inst_W_IO4_switch_matrix.E6BEG11 sky130_fd_sc_hd__mux4_1
XFILLER_51_31 VGND VGND VPWR VPWR sky130_fd_sc_hd__decap_3
XPHY_EDGE_ROW_54_Right_54 VGND VGND VPWR VPWR sky130_fd_sc_hd__decap_3
XPHY_EDGE_ROW_63_Right_63 VGND VGND VPWR VPWR sky130_fd_sc_hd__decap_3
XTAP_TAPCELL_ROW_75_254 VGND VPWR sky130_fd_sc_hd__tapvpwrvgnd_1
XPHY_EDGE_ROW_72_Right_72 VGND VGND VPWR VPWR sky130_fd_sc_hd__decap_3
XPHY_EDGE_ROW_81_Right_81 VGND VGND VPWR VPWR sky130_fd_sc_hd__decap_3
XFILLER_21_34 VGND VGND VPWR VPWR sky130_fd_sc_hd__decap_3
XFILLER_21_45 VGND VGND VPWR VPWR sky130_fd_sc_hd__decap_3
XANTENNA_30 net15 VGND VGND VPWR VPWR sky130_fd_sc_hd__diode_2
Xoutput192 net211 VGND VGND VPWR VPWR FrameStrobe_O[10] sky130_fd_sc_hd__buf_2
Xoutput170 net189 VGND VGND VPWR VPWR FrameData_O[1] sky130_fd_sc_hd__buf_2
Xoutput181 net200 VGND VGND VPWR VPWR FrameData_O[2] sky130_fd_sc_hd__buf_2
XFILLER_7_47 VGND VGND VPWR VPWR sky130_fd_sc_hd__decap_3
X_126_ _044_ _046_ _049_ _007_ VGND VGND VPWR VPWR net118 sky130_fd_sc_hd__a22o_1
XTAP_TAPCELL_ROW_16_195 VGND VPWR sky130_fd_sc_hd__tapvpwrvgnd_1
Xinput50 W2END[7] VGND VGND VPWR VPWR net50 sky130_fd_sc_hd__dlymetal6s2s_1
Xinput72 WW4END[10] VGND VGND VPWR VPWR net91 sky130_fd_sc_hd__buf_1
Xinput61 W6END[11] VGND VGND VPWR VPWR net80 sky130_fd_sc_hd__buf_1
Xinput83 WW4END[6] VGND VGND VPWR VPWR net102 sky130_fd_sc_hd__clkbuf_2
XPHY_EDGE_ROW_0_Right_0 VGND VGND VPWR VPWR sky130_fd_sc_hd__decap_3
XFILLER_57_52 VGND VGND VPWR VPWR sky130_fd_sc_hd__fill_1
XTAP_TAPCELL_ROW_45_224 VGND VPWR sky130_fd_sc_hd__tapvpwrvgnd_1
XFILLER_73_51 VGND VGND VPWR VPWR sky130_fd_sc_hd__decap_3
X_109_ net47 Inst_W_IO4_ConfigMem.Inst_frame0_bit30.Q VGND VGND VPWR VPWR _035_ sky130_fd_sc_hd__nand2_1
XFILLER_78_18 VGND VGND VPWR VPWR sky130_fd_sc_hd__decap_3
XFILLER_78_29 VGND VGND VPWR VPWR sky130_fd_sc_hd__decap_3
X_391_ net11 VGND VGND VPWR VPWR net184 sky130_fd_sc_hd__buf_1
XFILLER_27_55 VGND VGND VPWR VPWR sky130_fd_sc_hd__fill_1
XFILLER_43_21 VGND VGND VPWR VPWR sky130_fd_sc_hd__decap_3
XFILLER_43_43 VGND VGND VPWR VPWR sky130_fd_sc_hd__decap_3
XFILLER_4_15 VGND VGND VPWR VPWR sky130_fd_sc_hd__decap_3
XFILLER_13_24 VGND VGND VPWR VPWR sky130_fd_sc_hd__decap_3
Xfanout69 net72 VGND VGND VPWR VPWR net69 sky130_fd_sc_hd__buf_2
X_374_ Inst_W_IO4_switch_matrix.EE4BEG14 VGND VGND VPWR VPWR net167 sky130_fd_sc_hd__clkbuf_1
XFILLER_24_23 VGND VGND VPWR VPWR sky130_fd_sc_hd__fill_2
XFILLER_24_45 VGND VGND VPWR VPWR sky130_fd_sc_hd__decap_3
X_090_ net57 net43 Inst_W_IO4_ConfigMem.Inst_frame0_bit16.Q VGND VGND VPWR VPWR _018_
+ sky130_fd_sc_hd__mux2_1
Xclkbuf_0_UserCLK_regs UserCLK_regs VGND VGND VPWR VPWR clknet_0_UserCLK_regs sky130_fd_sc_hd__clkbuf_16
XFILLER_49_53 VGND VGND VPWR VPWR sky130_fd_sc_hd__decap_3
XFILLER_1_27 VGND VGND VPWR VPWR sky130_fd_sc_hd__decap_3
XFILLER_65_30 VGND VGND VPWR VPWR sky130_fd_sc_hd__fill_1
X_426_ FrameStrobe[18] VGND VGND VPWR VPWR net219 sky130_fd_sc_hd__clkbuf_1
X_357_ Inst_W_IO4_switch_matrix.E6BEG9 VGND VGND VPWR VPWR net161 sky130_fd_sc_hd__clkbuf_1
X_288_ net25 net69 VGND VGND VPWR VPWR Inst_W_IO4_ConfigMem.Inst_frame1_bit28.Q sky130_fd_sc_hd__dlxtp_1
Xinput4 D_O_top VGND VGND VPWR VPWR net4 sky130_fd_sc_hd__clkbuf_2
X_142_ _058_ _060_ _063_ _011_ VGND VGND VPWR VPWR net106 sky130_fd_sc_hd__a22o_1
XFILLER_51_10 VGND VGND VPWR VPWR sky130_fd_sc_hd__decap_3
XFILLER_51_54 VGND VGND VPWR VPWR sky130_fd_sc_hd__fill_2
X_211_ net11 net63 VGND VGND VPWR VPWR Inst_W_IO4_ConfigMem.Inst_frame3_bit15.Q sky130_fd_sc_hd__dlxtp_1
X_073_ Inst_W_IO4_ConfigMem.Inst_frame0_bit14.Q VGND VGND VPWR VPWR _009_ sky130_fd_sc_hd__inv_2
XFILLER_76_51 VGND VGND VPWR VPWR sky130_fd_sc_hd__decap_3
X_409_ net70 VGND VGND VPWR VPWR net221 sky130_fd_sc_hd__buf_1
XANTENNA_20 FrameStrobe[5] VGND VGND VPWR VPWR sky130_fd_sc_hd__diode_2
XANTENNA_31 net15 VGND VGND VPWR VPWR sky130_fd_sc_hd__diode_2
XFILLER_21_57 VGND VGND VPWR VPWR sky130_fd_sc_hd__fill_2
Xoutput193 net212 VGND VGND VPWR VPWR FrameStrobe_O[11] sky130_fd_sc_hd__buf_2
Xoutput160 net179 VGND VGND VPWR VPWR FrameData_O[10] sky130_fd_sc_hd__buf_2
Xoutput171 net190 VGND VGND VPWR VPWR FrameData_O[20] sky130_fd_sc_hd__buf_2
Xoutput182 net201 VGND VGND VPWR VPWR FrameData_O[30] sky130_fd_sc_hd__buf_2
XFILLER_7_26 VGND VGND VPWR VPWR sky130_fd_sc_hd__fill_2
X_125_ _047_ _048_ _006_ VGND VGND VPWR VPWR _049_ sky130_fd_sc_hd__mux2_1
Xinput51 W2MID[0] VGND VGND VPWR VPWR net51 sky130_fd_sc_hd__buf_1
Xinput40 W1END[1] VGND VGND VPWR VPWR net40 sky130_fd_sc_hd__clkbuf_2
Xinput84 WW4END[7] VGND VGND VPWR VPWR net103 sky130_fd_sc_hd__buf_1
Xinput73 WW4END[11] VGND VGND VPWR VPWR net92 sky130_fd_sc_hd__dlymetal6s2s_1
Xinput62 W6END[1] VGND VGND VPWR VPWR net81 sky130_fd_sc_hd__clkbuf_2
XPHY_EDGE_ROW_10_Left_99 VGND VGND VPWR VPWR sky130_fd_sc_hd__decap_3
XFILLER_16_13 VGND VGND VPWR VPWR sky130_fd_sc_hd__decap_3
XFILLER_16_79 VGND VGND VPWR VPWR sky130_fd_sc_hd__fill_2
XFILLER_32_23 VGND VGND VPWR VPWR sky130_fd_sc_hd__decap_3
XTAP_TAPCELL_ROW_7_186 VGND VPWR sky130_fd_sc_hd__tapvpwrvgnd_1
XTAP_TAPCELL_ROW_60_239 VGND VPWR sky130_fd_sc_hd__tapvpwrvgnd_1
XFILLER_85_8 VGND VGND VPWR VPWR sky130_fd_sc_hd__fill_2
X_108_ net49 Inst_W_IO4_ConfigMem.Inst_frame0_bit30.Q Inst_W_IO4_ConfigMem.Inst_frame0_bit31.Q
+ VGND VGND VPWR VPWR _034_ sky130_fd_sc_hd__o21ai_1
XFILLER_8_80 VGND VGND VPWR VPWR sky130_fd_sc_hd__fill_1
XFILLER_27_34 VGND VGND VPWR VPWR sky130_fd_sc_hd__decap_3
XFILLER_43_55 VGND VGND VPWR VPWR sky130_fd_sc_hd__fill_1
X_390_ net10 VGND VGND VPWR VPWR net183 sky130_fd_sc_hd__clkbuf_1
XFILLER_4_27 VGND VGND VPWR VPWR sky130_fd_sc_hd__fill_1
Xfanout59 net58 VGND VGND VPWR VPWR net59 sky130_fd_sc_hd__buf_2
XFILLER_8_7 VGND VGND VPWR VPWR sky130_fd_sc_hd__fill_1
XFILLER_38_22 VGND VGND VPWR VPWR sky130_fd_sc_hd__decap_3
XFILLER_38_44 VGND VGND VPWR VPWR sky130_fd_sc_hd__decap_3
XFILLER_38_66 VGND VGND VPWR VPWR sky130_fd_sc_hd__decap_3
XFILLER_54_10 VGND VGND VPWR VPWR sky130_fd_sc_hd__decap_3
XTAP_TAPCELL_ROW_30_209 VGND VPWR sky130_fd_sc_hd__tapvpwrvgnd_1
XFILLER_54_54 VGND VGND VPWR VPWR sky130_fd_sc_hd__decap_3
X_373_ Inst_W_IO4_switch_matrix.EE4BEG13 VGND VGND VPWR VPWR net166 sky130_fd_sc_hd__clkbuf_1
XFILLER_79_51 VGND VGND VPWR VPWR sky130_fd_sc_hd__decap_3
XFILLER_40_12 VGND VGND VPWR VPWR sky130_fd_sc_hd__decap_3
X_425_ FrameStrobe[17] VGND VGND VPWR VPWR net218 sky130_fd_sc_hd__clkbuf_1
X_287_ net24 net69 VGND VGND VPWR VPWR Inst_W_IO4_ConfigMem.Inst_frame1_bit27.Q sky130_fd_sc_hd__dlxtp_1
X_356_ Inst_W_IO4_switch_matrix.E6BEG8 VGND VGND VPWR VPWR net160 sky130_fd_sc_hd__clkbuf_1
XFILLER_81_63 VGND VGND VPWR VPWR sky130_fd_sc_hd__decap_3
Xinput5 FrameData[0] VGND VGND VPWR VPWR net5 sky130_fd_sc_hd__buf_1
XFILLER_10_26 VGND VGND VPWR VPWR sky130_fd_sc_hd__fill_2
X_141_ _061_ _062_ Inst_W_IO4_ConfigMem.Inst_frame0_bit6.Q VGND VGND VPWR VPWR _063_
+ sky130_fd_sc_hd__mux2_1
X_210_ net10 net64 VGND VGND VPWR VPWR Inst_W_IO4_ConfigMem.Inst_frame3_bit14.Q sky130_fd_sc_hd__dlxtp_1
X_072_ Inst_W_IO4_ConfigMem.Inst_frame0_bit13.Q VGND VGND VPWR VPWR _008_ sky130_fd_sc_hd__inv_1
XPHY_EDGE_ROW_29_Left_118 VGND VGND VPWR VPWR sky130_fd_sc_hd__decap_3
XPHY_EDGE_ROW_38_Left_127 VGND VGND VPWR VPWR sky130_fd_sc_hd__decap_3
X_408_ net37 VGND VGND VPWR VPWR net210 sky130_fd_sc_hd__buf_1
X_339_ Inst_W_IO4_switch_matrix.E2BEG7 VGND VGND VPWR VPWR net141 sky130_fd_sc_hd__clkbuf_1
XPHY_EDGE_ROW_47_Left_136 VGND VGND VPWR VPWR sky130_fd_sc_hd__decap_3
XFILLER_51_3 VGND VGND VPWR VPWR sky130_fd_sc_hd__decap_3
XFILLER_2_71 VGND VGND VPWR VPWR sky130_fd_sc_hd__fill_2
XPHY_EDGE_ROW_56_Left_145 VGND VGND VPWR VPWR sky130_fd_sc_hd__decap_3
XTAP_TAPCELL_ROW_66_245 VGND VPWR sky130_fd_sc_hd__tapvpwrvgnd_1
XANTENNA_10 FrameStrobe[12] VGND VGND VPWR VPWR sky130_fd_sc_hd__diode_2
XANTENNA_21 FrameStrobe[7] VGND VGND VPWR VPWR sky130_fd_sc_hd__diode_2
XANTENNA_32 net49 VGND VGND VPWR VPWR sky130_fd_sc_hd__diode_2
XFILLER_21_25 VGND VGND VPWR VPWR sky130_fd_sc_hd__decap_3
Xoutput150 net169 VGND VGND VPWR VPWR EE4BEG[1] sky130_fd_sc_hd__buf_2
XPHY_EDGE_ROW_65_Left_154 VGND VGND VPWR VPWR sky130_fd_sc_hd__decap_3
Xoutput161 net180 VGND VGND VPWR VPWR FrameData_O[11] sky130_fd_sc_hd__buf_2
Xoutput194 net213 VGND VGND VPWR VPWR FrameStrobe_O[12] sky130_fd_sc_hd__buf_2
Xoutput172 net191 VGND VGND VPWR VPWR FrameData_O[21] sky130_fd_sc_hd__buf_2
XPHY_EDGE_ROW_74_Left_163 VGND VGND VPWR VPWR sky130_fd_sc_hd__decap_3
Xoutput183 net202 VGND VGND VPWR VPWR FrameData_O[31] sky130_fd_sc_hd__buf_2
XFILLER_46_44 VGND VGND VPWR VPWR sky130_fd_sc_hd__fill_2
XPHY_EDGE_ROW_83_Left_172 VGND VGND VPWR VPWR sky130_fd_sc_hd__decap_3
X_124_ net51 net52 net53 net54 Inst_W_IO4_ConfigMem.Inst_frame0_bit18.Q Inst_W_IO4_ConfigMem.Inst_frame0_bit19.Q
+ VGND VGND VPWR VPWR _048_ sky130_fd_sc_hd__mux4_1
XFILLER_87_40 VGND VGND VPWR VPWR sky130_fd_sc_hd__decap_3
XFILLER_23_7 VGND VGND VPWR VPWR sky130_fd_sc_hd__decap_3
XPHY_EDGE_ROW_1_Left_90 VGND VGND VPWR VPWR sky130_fd_sc_hd__decap_3
Xinput52 W2MID[1] VGND VGND VPWR VPWR net52 sky130_fd_sc_hd__buf_1
Xinput41 W1END[2] VGND VGND VPWR VPWR net41 sky130_fd_sc_hd__clkbuf_2
Xinput85 WW4END[8] VGND VGND VPWR VPWR net104 sky130_fd_sc_hd__buf_1
Xinput74 WW4END[12] VGND VGND VPWR VPWR net93 sky130_fd_sc_hd__buf_1
Xinput63 W6END[2] VGND VGND VPWR VPWR net82 sky130_fd_sc_hd__buf_1
Xinput30 FrameData[3] VGND VGND VPWR VPWR net30 sky130_fd_sc_hd__clkbuf_2
XFILLER_16_25 VGND VGND VPWR VPWR sky130_fd_sc_hd__decap_3
XFILLER_32_35 VGND VGND VPWR VPWR sky130_fd_sc_hd__fill_1
XFILLER_57_10 VGND VGND VPWR VPWR sky130_fd_sc_hd__decap_3
XFILLER_73_20 VGND VGND VPWR VPWR sky130_fd_sc_hd__decap_3
XFILLER_73_42 VGND VGND VPWR VPWR sky130_fd_sc_hd__decap_3
X_107_ Inst_W_IO4_ConfigMem.Inst_frame0_bit30.Q Inst_W_IO4_ConfigMem.Inst_frame0_bit31.Q
+ net58 VGND VGND VPWR VPWR _033_ sky130_fd_sc_hd__or3b_1
XTAP_TAPCELL_ROW_36_215 VGND VPWR sky130_fd_sc_hd__tapvpwrvgnd_1
XFILLER_27_24 VGND VGND VPWR VPWR sky130_fd_sc_hd__decap_3
XFILLER_27_46 VGND VGND VPWR VPWR sky130_fd_sc_hd__decap_3
XFILLER_27_57 VGND VGND VPWR VPWR sky130_fd_sc_hd__decap_3
XFILLER_13_15 VGND VGND VPWR VPWR sky130_fd_sc_hd__decap_3
XFILLER_54_22 VGND VGND VPWR VPWR sky130_fd_sc_hd__decap_3
XFILLER_54_66 VGND VGND VPWR VPWR sky130_fd_sc_hd__decap_3
XFILLER_70_32 VGND VGND VPWR VPWR sky130_fd_sc_hd__decap_3
X_372_ Inst_W_IO4_switch_matrix.EE4BEG12 VGND VGND VPWR VPWR net165 sky130_fd_sc_hd__buf_1
XFILLER_5_60 VGND VGND VPWR VPWR sky130_fd_sc_hd__decap_3
XFILLER_40_35 VGND VGND VPWR VPWR sky130_fd_sc_hd__fill_1
XFILLER_40_57 VGND VGND VPWR VPWR sky130_fd_sc_hd__decap_3
XFILLER_49_22 VGND VGND VPWR VPWR sky130_fd_sc_hd__decap_3
XFILLER_65_21 VGND VGND VPWR VPWR sky130_fd_sc_hd__decap_3
X_424_ FrameStrobe[16] VGND VGND VPWR VPWR net217 sky130_fd_sc_hd__clkbuf_1
XFILLER_65_54 VGND VGND VPWR VPWR sky130_fd_sc_hd__fill_2
XFILLER_81_20 VGND VGND VPWR VPWR sky130_fd_sc_hd__decap_3
XFILLER_81_53 VGND VGND VPWR VPWR sky130_fd_sc_hd__decap_3
X_286_ net23 net69 VGND VGND VPWR VPWR Inst_W_IO4_ConfigMem.Inst_frame1_bit26.Q sky130_fd_sc_hd__dlxtp_1
X_355_ Inst_W_IO4_switch_matrix.E6BEG7 VGND VGND VPWR VPWR net159 sky130_fd_sc_hd__clkbuf_1
XFILLER_53_7 VGND VGND VPWR VPWR sky130_fd_sc_hd__fill_2
Xinput6 FrameData[10] VGND VGND VPWR VPWR net6 sky130_fd_sc_hd__clkbuf_2
XFILLER_10_49 VGND VGND VPWR VPWR sky130_fd_sc_hd__decap_3
XFILLER_35_57 VGND VGND VPWR VPWR sky130_fd_sc_hd__fill_2
XPHY_EDGE_ROW_14_Right_14 VGND VGND VPWR VPWR sky130_fd_sc_hd__decap_3
X_140_ net55 net57 net56 net59 Inst_W_IO4_ConfigMem.Inst_frame0_bit5.Q Inst_W_IO4_ConfigMem.Inst_frame0_bit4.Q
+ VGND VGND VPWR VPWR _062_ sky130_fd_sc_hd__mux4_1
X_071_ Inst_W_IO4_ConfigMem.Inst_frame0_bit21.Q VGND VGND VPWR VPWR _007_ sky130_fd_sc_hd__inv_2
XFILLER_51_34 VGND VGND VPWR VPWR sky130_fd_sc_hd__fill_2
XPHY_EDGE_ROW_23_Right_23 VGND VGND VPWR VPWR sky130_fd_sc_hd__decap_3
X_407_ net29 VGND VGND VPWR VPWR net202 sky130_fd_sc_hd__clkbuf_2
X_338_ Inst_W_IO4_switch_matrix.E2BEG6 VGND VGND VPWR VPWR net140 sky130_fd_sc_hd__clkbuf_1
XPHY_EDGE_ROW_32_Right_32 VGND VGND VPWR VPWR sky130_fd_sc_hd__decap_3
X_269_ net36 net70 VGND VGND VPWR VPWR Inst_W_IO4_ConfigMem.Inst_frame1_bit9.Q sky130_fd_sc_hd__dlxtp_1
XPHY_EDGE_ROW_41_Right_41 VGND VGND VPWR VPWR sky130_fd_sc_hd__decap_3
XPHY_EDGE_ROW_50_Right_50 VGND VGND VPWR VPWR sky130_fd_sc_hd__decap_3
Xclkbuf_1_1__f_UserCLK_regs clknet_0_UserCLK_regs VGND VGND VPWR VPWR clknet_1_1__leaf_UserCLK_regs
+ sky130_fd_sc_hd__clkbuf_16
XANTENNA_11 FrameStrobe[13] VGND VGND VPWR VPWR sky130_fd_sc_hd__diode_2
XANTENNA_22 FrameStrobe[7] VGND VGND VPWR VPWR sky130_fd_sc_hd__diode_2
XFILLER_21_37 VGND VGND VPWR VPWR sky130_fd_sc_hd__decap_3
XANTENNA_33 net99 VGND VGND VPWR VPWR sky130_fd_sc_hd__diode_2
Xoutput195 net214 VGND VGND VPWR VPWR FrameStrobe_O[13] sky130_fd_sc_hd__buf_2
XFILLER_21_48 VGND VGND VPWR VPWR sky130_fd_sc_hd__decap_3
Xoutput151 net170 VGND VGND VPWR VPWR EE4BEG[2] sky130_fd_sc_hd__buf_2
Xoutput140 net159 VGND VGND VPWR VPWR E6BEG[7] sky130_fd_sc_hd__buf_2
Xoutput184 net203 VGND VGND VPWR VPWR FrameData_O[3] sky130_fd_sc_hd__buf_2
Xoutput162 net181 VGND VGND VPWR VPWR FrameData_O[12] sky130_fd_sc_hd__buf_2
Xoutput173 net192 VGND VGND VPWR VPWR FrameData_O[22] sky130_fd_sc_hd__buf_2
XFILLER_62_11 VGND VGND VPWR VPWR sky130_fd_sc_hd__decap_3
X_123_ net55 net57 net56 net59 Inst_W_IO4_ConfigMem.Inst_frame0_bit19.Q Inst_W_IO4_ConfigMem.Inst_frame0_bit18.Q
+ VGND VGND VPWR VPWR _047_ sky130_fd_sc_hd__mux4_1
XFILLER_16_7 VGND VGND VPWR VPWR sky130_fd_sc_hd__fill_2
Xinput31 FrameData[4] VGND VGND VPWR VPWR net31 sky130_fd_sc_hd__clkbuf_2
Xinput20 FrameData[23] VGND VGND VPWR VPWR net20 sky130_fd_sc_hd__buf_2
Xinput53 W2MID[2] VGND VGND VPWR VPWR net53 sky130_fd_sc_hd__clkbuf_2
Xinput42 W1END[3] VGND VGND VPWR VPWR net42 sky130_fd_sc_hd__clkbuf_2
Xinput86 WW4END[9] VGND VGND VPWR VPWR net105 sky130_fd_sc_hd__buf_1
Xinput75 WW4END[13] VGND VGND VPWR VPWR net94 sky130_fd_sc_hd__dlymetal6s2s_1
Xinput64 W6END[3] VGND VGND VPWR VPWR net83 sky130_fd_sc_hd__clkbuf_2
XFILLER_73_32 VGND VGND VPWR VPWR sky130_fd_sc_hd__decap_3
XFILLER_73_54 VGND VGND VPWR VPWR sky130_fd_sc_hd__fill_2
X_106_ _003_ _030_ _031_ Inst_W_IO4_ConfigMem.Inst_frame0_bit29.Q VGND VGND VPWR VPWR
+ _032_ sky130_fd_sc_hd__a211oi_1
XFILLER_8_71 VGND VGND VPWR VPWR sky130_fd_sc_hd__decap_3
XPHY_EDGE_ROW_4_Right_4 VGND VGND VPWR VPWR sky130_fd_sc_hd__decap_3
XFILLER_43_24 VGND VGND VPWR VPWR sky130_fd_sc_hd__decap_3
XFILLER_43_46 VGND VGND VPWR VPWR sky130_fd_sc_hd__decap_3
XFILLER_4_29 VGND VGND VPWR VPWR sky130_fd_sc_hd__decap_3
XFILLER_4_18 VGND VGND VPWR VPWR sky130_fd_sc_hd__decap_3
XFILLER_13_27 VGND VGND VPWR VPWR sky130_fd_sc_hd__decap_3
XFILLER_13_49 VGND VGND VPWR VPWR sky130_fd_sc_hd__decap_3
XFILLER_38_79 VGND VGND VPWR VPWR sky130_fd_sc_hd__fill_2
X_371_ Inst_W_IO4_switch_matrix.EE4BEG11 VGND VGND VPWR VPWR net164 sky130_fd_sc_hd__buf_1
XPHY_EDGE_ROW_79_Right_79 VGND VGND VPWR VPWR sky130_fd_sc_hd__decap_3
XPHY_EDGE_ROW_88_Right_88 VGND VGND VPWR VPWR sky130_fd_sc_hd__decap_3
XFILLER_79_20 VGND VGND VPWR VPWR sky130_fd_sc_hd__decap_3
XFILLER_40_25 VGND VGND VPWR VPWR sky130_fd_sc_hd__decap_3
XTAP_TAPCELL_ROW_87_266 VGND VPWR sky130_fd_sc_hd__tapvpwrvgnd_1
X_423_ FrameStrobe[15] VGND VGND VPWR VPWR net216 sky130_fd_sc_hd__clkbuf_1
X_354_ Inst_W_IO4_switch_matrix.E6BEG6 VGND VGND VPWR VPWR net158 sky130_fd_sc_hd__buf_1
X_285_ net22 net73 VGND VGND VPWR VPWR Inst_W_IO4_ConfigMem.Inst_frame1_bit25.Q sky130_fd_sc_hd__dlxtp_1
Xinput7 FrameData[11] VGND VGND VPWR VPWR net7 sky130_fd_sc_hd__clkbuf_2
X_070_ Inst_W_IO4_ConfigMem.Inst_frame0_bit20.Q VGND VGND VPWR VPWR _006_ sky130_fd_sc_hd__inv_2
XFILLER_51_13 VGND VGND VPWR VPWR sky130_fd_sc_hd__decap_3
XFILLER_76_10 VGND VGND VPWR VPWR sky130_fd_sc_hd__fill_1
XFILLER_76_32 VGND VGND VPWR VPWR sky130_fd_sc_hd__fill_1
XFILLER_76_54 VGND VGND VPWR VPWR sky130_fd_sc_hd__fill_1
X_406_ net28 VGND VGND VPWR VPWR net201 sky130_fd_sc_hd__clkbuf_2
X_337_ Inst_W_IO4_switch_matrix.E2BEG5 VGND VGND VPWR VPWR net139 sky130_fd_sc_hd__clkbuf_1
X_268_ net35 net70 VGND VGND VPWR VPWR Inst_W_IO4_ConfigMem.Inst_frame1_bit8.Q sky130_fd_sc_hd__dlxtp_1
X_199_ net30 net64 VGND VGND VPWR VPWR net129 sky130_fd_sc_hd__dlxtp_1
XFILLER_37_3 VGND VGND VPWR VPWR sky130_fd_sc_hd__decap_3
XANTENNA_12 FrameStrobe[14] VGND VGND VPWR VPWR sky130_fd_sc_hd__diode_2
XANTENNA_23 FrameStrobe[8] VGND VGND VPWR VPWR sky130_fd_sc_hd__diode_2
XANTENNA_34 net14 VGND VGND VPWR VPWR sky130_fd_sc_hd__diode_2
Xoutput196 net215 VGND VGND VPWR VPWR FrameStrobe_O[14] sky130_fd_sc_hd__buf_2
Xoutput130 net149 VGND VGND VPWR VPWR E2BEGb[7] sky130_fd_sc_hd__buf_2
Xoutput152 net171 VGND VGND VPWR VPWR EE4BEG[3] sky130_fd_sc_hd__buf_2
Xoutput141 net160 VGND VGND VPWR VPWR E6BEG[8] sky130_fd_sc_hd__buf_2
Xoutput163 net182 VGND VGND VPWR VPWR FrameData_O[13] sky130_fd_sc_hd__buf_2
Xoutput185 net204 VGND VGND VPWR VPWR FrameData_O[4] sky130_fd_sc_hd__buf_2
Xoutput174 net193 VGND VGND VPWR VPWR FrameData_O[23] sky130_fd_sc_hd__buf_2
XFILLER_46_13 VGND VGND VPWR VPWR sky130_fd_sc_hd__fill_2
XFILLER_46_79 VGND VGND VPWR VPWR sky130_fd_sc_hd__fill_2
XTAP_TAPCELL_ROW_57_236 VGND VPWR sky130_fd_sc_hd__tapvpwrvgnd_1
X_122_ _006_ _045_ Inst_W_IO4_ConfigMem.Inst_frame0_bit21.Q VGND VGND VPWR VPWR _046_
+ sky130_fd_sc_hd__o21a_1
XTAP_TAPCELL_ROW_71_250 VGND VPWR sky130_fd_sc_hd__tapvpwrvgnd_1
Xinput54 W2MID[3] VGND VGND VPWR VPWR net54 sky130_fd_sc_hd__clkbuf_2
Xinput43 W2END[0] VGND VGND VPWR VPWR net43 sky130_fd_sc_hd__buf_2
Xinput32 FrameData[5] VGND VGND VPWR VPWR net32 sky130_fd_sc_hd__clkbuf_2
Xinput10 FrameData[14] VGND VGND VPWR VPWR net10 sky130_fd_sc_hd__clkbuf_2
Xinput21 FrameData[24] VGND VGND VPWR VPWR net21 sky130_fd_sc_hd__buf_2
Xinput76 WW4END[14] VGND VGND VPWR VPWR net95 sky130_fd_sc_hd__dlymetal6s2s_1
Xinput65 W6END[4] VGND VGND VPWR VPWR net84 sky130_fd_sc_hd__buf_1
XFILLER_16_16 VGND VGND VPWR VPWR sky130_fd_sc_hd__decap_3
XFILLER_32_26 VGND VGND VPWR VPWR sky130_fd_sc_hd__fill_2
XFILLER_73_11 VGND VGND VPWR VPWR sky130_fd_sc_hd__decap_3
X_105_ Inst_W_IO4_ConfigMem.Inst_frame0_bit30.Q Inst_W_IO4_ConfigMem.Inst_frame0_bit31.Q
+ net48 VGND VGND VPWR VPWR _031_ sky130_fd_sc_hd__and3b_1
XTAP_TAPCELL_ROW_12_191 VGND VPWR sky130_fd_sc_hd__tapvpwrvgnd_1
XFILLER_27_15 VGND VGND VPWR VPWR sky130_fd_sc_hd__decap_3
XFILLER_27_37 VGND VGND VPWR VPWR sky130_fd_sc_hd__decap_3
XTAP_TAPCELL_ROW_27_206 VGND VPWR sky130_fd_sc_hd__tapvpwrvgnd_1
XFILLER_68_22 VGND VGND VPWR VPWR sky130_fd_sc_hd__decap_3
XFILLER_68_33 VGND VGND VPWR VPWR sky130_fd_sc_hd__fill_1
XFILLER_84_76 VGND VGND VPWR VPWR sky130_fd_sc_hd__fill_1
XTAP_TAPCELL_ROW_41_220 VGND VPWR sky130_fd_sc_hd__tapvpwrvgnd_1
XFILLER_76_7 VGND VGND VPWR VPWR sky130_fd_sc_hd__decap_3
XFILLER_38_25 VGND VGND VPWR VPWR sky130_fd_sc_hd__decap_3
XFILLER_38_47 VGND VGND VPWR VPWR sky130_fd_sc_hd__decap_3
XFILLER_38_58 VGND VGND VPWR VPWR sky130_fd_sc_hd__fill_2
X_370_ Inst_W_IO4_switch_matrix.EE4BEG10 VGND VGND VPWR VPWR net163 sky130_fd_sc_hd__clkbuf_1
XFILLER_54_13 VGND VGND VPWR VPWR sky130_fd_sc_hd__decap_3
XFILLER_54_57 VGND VGND VPWR VPWR sky130_fd_sc_hd__decap_3
XFILLER_79_32 VGND VGND VPWR VPWR sky130_fd_sc_hd__decap_3
XFILLER_79_43 VGND VGND VPWR VPWR sky130_fd_sc_hd__decap_3
XFILLER_79_54 VGND VGND VPWR VPWR sky130_fd_sc_hd__fill_2
XFILLER_5_40 VGND VGND VPWR VPWR sky130_fd_sc_hd__decap_3
XFILLER_40_15 VGND VGND VPWR VPWR sky130_fd_sc_hd__decap_3
X_422_ FrameStrobe[14] VGND VGND VPWR VPWR net215 sky130_fd_sc_hd__clkbuf_1
X_284_ net21 net73 VGND VGND VPWR VPWR Inst_W_IO4_ConfigMem.Inst_frame1_bit24.Q sky130_fd_sc_hd__dlxtp_1
X_353_ Inst_W_IO4_switch_matrix.E6BEG5 VGND VGND VPWR VPWR net157 sky130_fd_sc_hd__clkbuf_1
XFILLER_81_66 VGND VGND VPWR VPWR sky130_fd_sc_hd__decap_3
Xinput8 FrameData[12] VGND VGND VPWR VPWR net8 sky130_fd_sc_hd__clkbuf_2
XFILLER_10_29 VGND VGND VPWR VPWR sky130_fd_sc_hd__decap_3
X_267_ net34 net69 VGND VGND VPWR VPWR Inst_W_IO4_ConfigMem.Inst_frame1_bit7.Q sky130_fd_sc_hd__dlxtp_1
X_336_ Inst_W_IO4_switch_matrix.E2BEG4 VGND VGND VPWR VPWR net138 sky130_fd_sc_hd__buf_1
X_405_ net26 VGND VGND VPWR VPWR net199 sky130_fd_sc_hd__clkbuf_1
X_198_ net27 net64 VGND VGND VPWR VPWR net128 sky130_fd_sc_hd__dlxtp_1
XPHY_EDGE_ROW_16_Left_105 VGND VGND VPWR VPWR sky130_fd_sc_hd__decap_3
XANTENNA_13 FrameStrobe[15] VGND VGND VPWR VPWR sky130_fd_sc_hd__diode_2
XPHY_EDGE_ROW_25_Left_114 VGND VGND VPWR VPWR sky130_fd_sc_hd__decap_3
XANTENNA_24 FrameStrobe[9] VGND VGND VPWR VPWR sky130_fd_sc_hd__diode_2
XFILLER_21_28 VGND VGND VPWR VPWR sky130_fd_sc_hd__decap_3
XANTENNA_35 net46 VGND VGND VPWR VPWR sky130_fd_sc_hd__diode_2
Xoutput197 net216 VGND VGND VPWR VPWR FrameStrobe_O[15] sky130_fd_sc_hd__buf_2
XPHY_EDGE_ROW_34_Left_123 VGND VGND VPWR VPWR sky130_fd_sc_hd__decap_3
Xoutput120 net139 VGND VGND VPWR VPWR E2BEG[5] sky130_fd_sc_hd__buf_2
Xoutput153 net172 VGND VGND VPWR VPWR EE4BEG[4] sky130_fd_sc_hd__buf_2
Xoutput131 net150 VGND VGND VPWR VPWR E6BEG[0] sky130_fd_sc_hd__buf_2
Xoutput142 net161 VGND VGND VPWR VPWR E6BEG[9] sky130_fd_sc_hd__buf_2
Xoutput186 net205 VGND VGND VPWR VPWR FrameData_O[5] sky130_fd_sc_hd__buf_2
Xoutput164 net183 VGND VGND VPWR VPWR FrameData_O[14] sky130_fd_sc_hd__buf_2
Xoutput175 net194 VGND VGND VPWR VPWR FrameData_O[24] sky130_fd_sc_hd__buf_2
X_121_ net47 net48 net49 net50 Inst_W_IO4_ConfigMem.Inst_frame0_bit18.Q Inst_W_IO4_ConfigMem.Inst_frame0_bit19.Q
+ VGND VGND VPWR VPWR _045_ sky130_fd_sc_hd__mux4_1
XPHY_EDGE_ROW_43_Left_132 VGND VGND VPWR VPWR sky130_fd_sc_hd__decap_3
XFILLER_87_43 VGND VGND VPWR VPWR sky130_fd_sc_hd__decap_3
XPHY_EDGE_ROW_52_Left_141 VGND VGND VPWR VPWR sky130_fd_sc_hd__decap_3
XPHY_EDGE_ROW_61_Left_150 VGND VGND VPWR VPWR sky130_fd_sc_hd__decap_3
Xinput55 W2MID[4] VGND VGND VPWR VPWR net55 sky130_fd_sc_hd__clkbuf_2
X_319_ net24 net76 VGND VGND VPWR VPWR Inst_W_IO4_ConfigMem.Inst_frame0_bit27.Q sky130_fd_sc_hd__dlxtp_1
Xinput44 W2END[1] VGND VGND VPWR VPWR net44 sky130_fd_sc_hd__clkbuf_2
Xinput77 WW4END[15] VGND VGND VPWR VPWR net96 sky130_fd_sc_hd__buf_1
Xinput66 W6END[5] VGND VGND VPWR VPWR net85 sky130_fd_sc_hd__clkbuf_2
Xinput33 FrameData[6] VGND VGND VPWR VPWR net33 sky130_fd_sc_hd__clkbuf_2
Xinput11 FrameData[15] VGND VGND VPWR VPWR net11 sky130_fd_sc_hd__clkbuf_2
Xinput22 FrameData[25] VGND VGND VPWR VPWR net22 sky130_fd_sc_hd__clkbuf_2
XFILLER_57_13 VGND VGND VPWR VPWR sky130_fd_sc_hd__fill_1
XFILLER_73_23 VGND VGND VPWR VPWR sky130_fd_sc_hd__decap_3
XFILLER_73_45 VGND VGND VPWR VPWR sky130_fd_sc_hd__decap_3
X_104_ net57 net43 Inst_W_IO4_ConfigMem.Inst_frame0_bit30.Q VGND VGND VPWR VPWR _030_
+ sky130_fd_sc_hd__mux2_1
XPHY_EDGE_ROW_5_Left_94 VGND VGND VPWR VPWR sky130_fd_sc_hd__decap_3
XFILLER_8_62 VGND VGND VPWR VPWR sky130_fd_sc_hd__decap_3
XFILLER_27_27 VGND VGND VPWR VPWR sky130_fd_sc_hd__fill_1
XFILLER_27_49 VGND VGND VPWR VPWR sky130_fd_sc_hd__decap_3
XFILLER_43_15 VGND VGND VPWR VPWR sky130_fd_sc_hd__decap_3
XFILLER_84_22 VGND VGND VPWR VPWR sky130_fd_sc_hd__fill_2
XTAP_TAPCELL_ROW_3_182 VGND VPWR sky130_fd_sc_hd__tapvpwrvgnd_1
XFILLER_17_60 VGND VGND VPWR VPWR sky130_fd_sc_hd__fill_2
XFILLER_69_7 VGND VGND VPWR VPWR sky130_fd_sc_hd__decap_3
XFILLER_13_18 VGND VGND VPWR VPWR sky130_fd_sc_hd__decap_3
XFILLER_54_25 VGND VGND VPWR VPWR sky130_fd_sc_hd__decap_3
XFILLER_70_35 VGND VGND VPWR VPWR sky130_fd_sc_hd__fill_2
XFILLER_70_57 VGND VGND VPWR VPWR sky130_fd_sc_hd__fill_2
XFILLER_5_63 VGND VGND VPWR VPWR sky130_fd_sc_hd__decap_3
XFILLER_5_52 VGND VGND VPWR VPWR sky130_fd_sc_hd__decap_3
XFILLER_49_25 VGND VGND VPWR VPWR sky130_fd_sc_hd__decap_3
X_421_ FrameStrobe[13] VGND VGND VPWR VPWR net214 sky130_fd_sc_hd__clkbuf_1
XFILLER_65_24 VGND VGND VPWR VPWR sky130_fd_sc_hd__decap_3
X_283_ net20 net70 VGND VGND VPWR VPWR Inst_W_IO4_ConfigMem.Inst_frame1_bit23.Q sky130_fd_sc_hd__dlxtp_1
X_352_ Inst_W_IO4_switch_matrix.E6BEG4 VGND VGND VPWR VPWR net156 sky130_fd_sc_hd__clkbuf_1
XFILLER_81_78 VGND VGND VPWR VPWR sky130_fd_sc_hd__decap_3
Xinput9 FrameData[13] VGND VGND VPWR VPWR net9 sky130_fd_sc_hd__clkbuf_2
XTAP_TAPCELL_ROW_78_257 VGND VPWR sky130_fd_sc_hd__tapvpwrvgnd_1
XFILLER_51_48 VGND VGND VPWR VPWR sky130_fd_sc_hd__decap_3
XFILLER_76_45 VGND VGND VPWR VPWR sky130_fd_sc_hd__decap_3
X_404_ net25 VGND VGND VPWR VPWR net198 sky130_fd_sc_hd__clkbuf_1
X_335_ Inst_W_IO4_switch_matrix.E2BEG3 VGND VGND VPWR VPWR net137 sky130_fd_sc_hd__clkbuf_1
X_197_ net16 net62 VGND VGND VPWR VPWR net127 sky130_fd_sc_hd__dlxtp_1
X_266_ net33 net69 VGND VGND VPWR VPWR Inst_W_IO4_ConfigMem.Inst_frame1_bit6.Q sky130_fd_sc_hd__dlxtp_1
XPHY_EDGE_ROW_10_Right_10 VGND VGND VPWR VPWR sky130_fd_sc_hd__decap_3
XANTENNA_14 FrameStrobe[16] VGND VGND VPWR VPWR sky130_fd_sc_hd__diode_2
XANTENNA_25 net222 VGND VGND VPWR VPWR sky130_fd_sc_hd__diode_2
XTAP_TAPCELL_ROW_19_198 VGND VPWR sky130_fd_sc_hd__tapvpwrvgnd_1
Xoutput121 net140 VGND VGND VPWR VPWR E2BEG[6] sky130_fd_sc_hd__buf_2
Xoutput110 net129 VGND VGND VPWR VPWR D_config_C_bit3 sky130_fd_sc_hd__buf_2
Xoutput143 net162 VGND VGND VPWR VPWR EE4BEG[0] sky130_fd_sc_hd__buf_2
Xoutput132 net151 VGND VGND VPWR VPWR E6BEG[10] sky130_fd_sc_hd__buf_2
Xoutput198 net217 VGND VGND VPWR VPWR FrameStrobe_O[16] sky130_fd_sc_hd__buf_2
Xoutput154 net173 VGND VGND VPWR VPWR EE4BEG[5] sky130_fd_sc_hd__buf_2
Xoutput187 net206 VGND VGND VPWR VPWR FrameData_O[6] sky130_fd_sc_hd__buf_2
Xoutput165 net184 VGND VGND VPWR VPWR FrameData_O[15] sky130_fd_sc_hd__buf_2
Xoutput176 net195 VGND VGND VPWR VPWR FrameData_O[25] sky130_fd_sc_hd__buf_2
XFILLER_62_14 VGND VGND VPWR VPWR sky130_fd_sc_hd__fill_1
X_120_ Inst_W_IO4_ConfigMem.Inst_frame0_bit20.Q _043_ VGND VGND VPWR VPWR _044_ sky130_fd_sc_hd__or2_1
XTAP_TAPCELL_ROW_48_227 VGND VPWR sky130_fd_sc_hd__tapvpwrvgnd_1
Xinput78 WW4END[1] VGND VGND VPWR VPWR net97 sky130_fd_sc_hd__buf_1
Xinput45 W2END[2] VGND VGND VPWR VPWR net45 sky130_fd_sc_hd__clkbuf_2
X_249_ net18 net66 VGND VGND VPWR VPWR Inst_W_IO4_ConfigMem.Inst_frame2_bit21.Q sky130_fd_sc_hd__dlxtp_1
X_318_ net23 net76 VGND VGND VPWR VPWR Inst_W_IO4_ConfigMem.Inst_frame0_bit26.Q sky130_fd_sc_hd__dlxtp_1
Xinput56 W2MID[5] VGND VGND VPWR VPWR net56 sky130_fd_sc_hd__clkbuf_2
Xinput67 W6END[6] VGND VGND VPWR VPWR net86 sky130_fd_sc_hd__clkbuf_2
Xinput34 FrameData[7] VGND VGND VPWR VPWR net34 sky130_fd_sc_hd__clkbuf_2
Xinput12 FrameData[16] VGND VGND VPWR VPWR net12 sky130_fd_sc_hd__buf_1
Xinput23 FrameData[26] VGND VGND VPWR VPWR net23 sky130_fd_sc_hd__buf_2
XFILLER_16_29 VGND VGND VPWR VPWR sky130_fd_sc_hd__decap_3
XTAP_TAPCELL_ROW_62_241 VGND VPWR sky130_fd_sc_hd__tapvpwrvgnd_1
XFILLER_32_17 VGND VGND VPWR VPWR sky130_fd_sc_hd__decap_3
XFILLER_73_35 VGND VGND VPWR VPWR sky130_fd_sc_hd__fill_1
X_103_ Inst_W_IO4_ConfigMem.Inst_frame0_bit22.Q _027_ _028_ _029_ _026_ VGND VGND
+ VPWR VPWR net119 sky130_fd_sc_hd__a41o_1
XFILLER_8_74 VGND VGND VPWR VPWR sky130_fd_sc_hd__decap_3
XFILLER_43_27 VGND VGND VPWR VPWR sky130_fd_sc_hd__decap_3
XFILLER_43_49 VGND VGND VPWR VPWR sky130_fd_sc_hd__decap_3
XPHY_EDGE_ROW_80_Left_169 VGND VGND VPWR VPWR sky130_fd_sc_hd__decap_3
XFILLER_68_46 VGND VGND VPWR VPWR sky130_fd_sc_hd__fill_1
XFILLER_68_68 VGND VGND VPWR VPWR sky130_fd_sc_hd__fill_1
XFILLER_17_50 VGND VGND VPWR VPWR sky130_fd_sc_hd__decap_3
XPHY_EDGE_ROW_8_Right_8 VGND VGND VPWR VPWR sky130_fd_sc_hd__decap_3
XTAP_TAPCELL_ROW_32_211 VGND VPWR sky130_fd_sc_hd__tapvpwrvgnd_1
XFILLER_38_16 VGND VGND VPWR VPWR sky130_fd_sc_hd__decap_3
XPHY_EDGE_ROW_39_Right_39 VGND VGND VPWR VPWR sky130_fd_sc_hd__decap_3
XPHY_EDGE_ROW_48_Right_48 VGND VGND VPWR VPWR sky130_fd_sc_hd__decap_3
XFILLER_70_14 VGND VGND VPWR VPWR sky130_fd_sc_hd__fill_2
XPHY_EDGE_ROW_57_Right_57 VGND VGND VPWR VPWR sky130_fd_sc_hd__decap_3
XFILLER_79_23 VGND VGND VPWR VPWR sky130_fd_sc_hd__decap_3
XPHY_EDGE_ROW_66_Right_66 VGND VGND VPWR VPWR sky130_fd_sc_hd__decap_3
XPHY_EDGE_ROW_75_Right_75 VGND VGND VPWR VPWR sky130_fd_sc_hd__decap_3
XPHY_EDGE_ROW_84_Right_84 VGND VGND VPWR VPWR sky130_fd_sc_hd__decap_3
X_420_ FrameStrobe[12] VGND VGND VPWR VPWR net213 sky130_fd_sc_hd__clkbuf_1
X_351_ Inst_W_IO4_switch_matrix.E6BEG3 VGND VGND VPWR VPWR net155 sky130_fd_sc_hd__buf_1
X_282_ net19 net70 VGND VGND VPWR VPWR Inst_W_IO4_ConfigMem.Inst_frame1_bit22.Q sky130_fd_sc_hd__dlxtp_1
XFILLER_81_57 VGND VGND VPWR VPWR sky130_fd_sc_hd__decap_3
XFILLER_51_16 VGND VGND VPWR VPWR sky130_fd_sc_hd__decap_3
X_403_ net24 VGND VGND VPWR VPWR net197 sky130_fd_sc_hd__clkbuf_2
X_334_ Inst_W_IO4_switch_matrix.E2BEG2 VGND VGND VPWR VPWR net136 sky130_fd_sc_hd__buf_1
X_196_ net5 net64 VGND VGND VPWR VPWR net126 sky130_fd_sc_hd__dlxtp_1
X_265_ net32 net72 VGND VGND VPWR VPWR Inst_W_IO4_ConfigMem.Inst_frame1_bit5.Q sky130_fd_sc_hd__dlxtp_1
XFILLER_2_76 VGND VGND VPWR VPWR sky130_fd_sc_hd__decap_3
XANTENNA_15 FrameStrobe[17] VGND VGND VPWR VPWR sky130_fd_sc_hd__diode_2
XANTENNA_26 net3 VGND VGND VPWR VPWR sky130_fd_sc_hd__diode_2
XFILLER_21_19 VGND VGND VPWR VPWR sky130_fd_sc_hd__decap_3
Xoutput100 net119 VGND VGND VPWR VPWR C_T_top sky130_fd_sc_hd__buf_2
Xoutput111 net130 VGND VGND VPWR VPWR E1BEG[0] sky130_fd_sc_hd__buf_2
Xoutput122 net141 VGND VGND VPWR VPWR E2BEG[7] sky130_fd_sc_hd__buf_2
Xoutput155 net174 VGND VGND VPWR VPWR EE4BEG[6] sky130_fd_sc_hd__buf_2
Xoutput144 net163 VGND VGND VPWR VPWR EE4BEG[10] sky130_fd_sc_hd__buf_2
Xoutput133 net152 VGND VGND VPWR VPWR E6BEG[11] sky130_fd_sc_hd__buf_2
Xoutput166 net185 VGND VGND VPWR VPWR FrameData_O[16] sky130_fd_sc_hd__buf_2
Xoutput177 net196 VGND VGND VPWR VPWR FrameData_O[26] sky130_fd_sc_hd__buf_2
Xoutput199 net218 VGND VGND VPWR VPWR FrameStrobe_O[17] sky130_fd_sc_hd__buf_2
XFILLER_46_27 VGND VGND VPWR VPWR sky130_fd_sc_hd__fill_1
Xoutput188 net207 VGND VGND VPWR VPWR FrameData_O[7] sky130_fd_sc_hd__buf_2
X_317_ net22 net76 VGND VGND VPWR VPWR Inst_W_IO4_ConfigMem.Inst_frame0_bit25.Q sky130_fd_sc_hd__dlxtp_1
Xinput13 FrameData[17] VGND VGND VPWR VPWR net13 sky130_fd_sc_hd__buf_1
Xinput24 FrameData[27] VGND VGND VPWR VPWR net24 sky130_fd_sc_hd__buf_2
X_248_ net17 net66 VGND VGND VPWR VPWR Inst_W_IO4_ConfigMem.Inst_frame2_bit20.Q sky130_fd_sc_hd__dlxtp_1
Xinput57 W2MID[6] VGND VGND VPWR VPWR net57 sky130_fd_sc_hd__buf_2
Xinput46 W2END[3] VGND VGND VPWR VPWR net46 sky130_fd_sc_hd__buf_2
Xinput79 WW4END[2] VGND VGND VPWR VPWR net98 sky130_fd_sc_hd__buf_1
Xinput68 W6END[7] VGND VGND VPWR VPWR net87 sky130_fd_sc_hd__clkbuf_2
X_179_ net51 net90 net104 net78 Inst_W_IO4_ConfigMem.Inst_frame3_bit26.Q Inst_W_IO4_ConfigMem.Inst_frame3_bit27.Q
+ VGND VGND VPWR VPWR Inst_W_IO4_switch_matrix.E2BEG7 sky130_fd_sc_hd__mux4_1
Xinput35 FrameData[8] VGND VGND VPWR VPWR net35 sky130_fd_sc_hd__clkbuf_2
XFILLER_16_19 VGND VGND VPWR VPWR sky130_fd_sc_hd__decap_3
XFILLER_32_29 VGND VGND VPWR VPWR sky130_fd_sc_hd__decap_3
XFILLER_73_14 VGND VGND VPWR VPWR sky130_fd_sc_hd__decap_3
X_102_ net45 Inst_W_IO4_ConfigMem.Inst_frame0_bit23.Q VGND VGND VPWR VPWR _029_ sky130_fd_sc_hd__nand2_1
XFILLER_27_18 VGND VGND VPWR VPWR sky130_fd_sc_hd__decap_3
XFILLER_84_13 VGND VGND VPWR VPWR sky130_fd_sc_hd__decap_3
XFILLER_68_25 VGND VGND VPWR VPWR sky130_fd_sc_hd__decap_3
XFILLER_33_50 VGND VGND VPWR VPWR sky130_fd_sc_hd__decap_3
XFILLER_54_16 VGND VGND VPWR VPWR sky130_fd_sc_hd__decap_3
XFILLER_79_35 VGND VGND VPWR VPWR sky130_fd_sc_hd__decap_3
XFILLER_79_46 VGND VGND VPWR VPWR sky130_fd_sc_hd__fill_2
XFILLER_79_57 VGND VGND VPWR VPWR sky130_fd_sc_hd__decap_3
XFILLER_28_50 VGND VGND VPWR VPWR sky130_fd_sc_hd__decap_3
XFILLER_74_7 VGND VGND VPWR VPWR sky130_fd_sc_hd__decap_3
XFILLER_5_43 VGND VGND VPWR VPWR sky130_fd_sc_hd__decap_3
XFILLER_40_18 VGND VGND VPWR VPWR sky130_fd_sc_hd__decap_3
XFILLER_40_29 VGND VGND VPWR VPWR sky130_fd_sc_hd__decap_3
XFILLER_49_16 VGND VGND VPWR VPWR sky130_fd_sc_hd__decap_3
XFILLER_65_15 VGND VGND VPWR VPWR sky130_fd_sc_hd__decap_3
X_350_ Inst_W_IO4_switch_matrix.E6BEG2 VGND VGND VPWR VPWR net154 sky130_fd_sc_hd__clkbuf_1
XFILLER_81_14 VGND VGND VPWR VPWR sky130_fd_sc_hd__fill_2
XFILLER_81_47 VGND VGND VPWR VPWR sky130_fd_sc_hd__decap_3
XFILLER_81_69 VGND VGND VPWR VPWR sky130_fd_sc_hd__decap_3
X_281_ net18 net70 VGND VGND VPWR VPWR Inst_W_IO4_ConfigMem.Inst_frame1_bit21.Q sky130_fd_sc_hd__dlxtp_1
XFILLER_71_80 VGND VGND VPWR VPWR sky130_fd_sc_hd__fill_1
XTAP_TAPCELL_ROW_69_248 VGND VPWR sky130_fd_sc_hd__tapvpwrvgnd_1
XFILLER_35_18 VGND VGND VPWR VPWR sky130_fd_sc_hd__fill_2
XTAP_TAPCELL_ROW_83_262 VGND VPWR sky130_fd_sc_hd__tapvpwrvgnd_1
X_333_ Inst_W_IO4_switch_matrix.E2BEG1 VGND VGND VPWR VPWR net135 sky130_fd_sc_hd__buf_1
X_402_ net23 VGND VGND VPWR VPWR net196 sky130_fd_sc_hd__clkbuf_2
XFILLER_25_40 VGND VGND VPWR VPWR sky130_fd_sc_hd__decap_3
X_264_ net31 net72 VGND VGND VPWR VPWR Inst_W_IO4_ConfigMem.Inst_frame1_bit4.Q sky130_fd_sc_hd__dlxtp_1
X_195_ net29 net60 VGND VGND VPWR VPWR net123 sky130_fd_sc_hd__dlxtp_1
XFILLER_2_33 VGND VGND VPWR VPWR sky130_fd_sc_hd__fill_1
XANTENNA_16 FrameStrobe[18] VGND VGND VPWR VPWR sky130_fd_sc_hd__diode_2
XANTENNA_27 net54 VGND VGND VPWR VPWR sky130_fd_sc_hd__diode_2
Xoutput101 net120 VGND VGND VPWR VPWR C_config_C_bit0 sky130_fd_sc_hd__buf_2
Xoutput112 net131 VGND VGND VPWR VPWR E1BEG[1] sky130_fd_sc_hd__buf_2
Xoutput123 net142 VGND VGND VPWR VPWR E2BEGb[0] sky130_fd_sc_hd__buf_2
Xoutput145 net164 VGND VGND VPWR VPWR EE4BEG[11] sky130_fd_sc_hd__buf_2
Xoutput156 net175 VGND VGND VPWR VPWR EE4BEG[7] sky130_fd_sc_hd__buf_2
Xoutput134 net153 VGND VGND VPWR VPWR E6BEG[1] sky130_fd_sc_hd__buf_2
Xoutput189 net208 VGND VGND VPWR VPWR FrameData_O[8] sky130_fd_sc_hd__buf_2
Xoutput167 net186 VGND VGND VPWR VPWR FrameData_O[17] sky130_fd_sc_hd__buf_2
Xoutput178 net197 VGND VGND VPWR VPWR FrameData_O[27] sky130_fd_sc_hd__buf_2
XFILLER_62_27 VGND VGND VPWR VPWR sky130_fd_sc_hd__fill_1
XPHY_EDGE_ROW_12_Left_101 VGND VGND VPWR VPWR sky130_fd_sc_hd__decap_3
XFILLER_11_53 VGND VGND VPWR VPWR sky130_fd_sc_hd__decap_3
XFILLER_87_57 VGND VGND VPWR VPWR sky130_fd_sc_hd__fill_1
XFILLER_87_46 VGND VGND VPWR VPWR sky130_fd_sc_hd__decap_3
XPHY_EDGE_ROW_21_Left_110 VGND VGND VPWR VPWR sky130_fd_sc_hd__decap_3
Xinput25 FrameData[28] VGND VGND VPWR VPWR net25 sky130_fd_sc_hd__buf_2
X_316_ net21 net75 VGND VGND VPWR VPWR Inst_W_IO4_ConfigMem.Inst_frame0_bit24.Q sky130_fd_sc_hd__dlxtp_1
Xinput36 FrameData[9] VGND VGND VPWR VPWR net36 sky130_fd_sc_hd__clkbuf_2
X_247_ net15 net67 VGND VGND VPWR VPWR Inst_W_IO4_ConfigMem.Inst_frame2_bit19.Q sky130_fd_sc_hd__dlxtp_1
Xinput14 FrameData[18] VGND VGND VPWR VPWR net14 sky130_fd_sc_hd__clkbuf_2
Xinput58 W2MID[7] VGND VGND VPWR VPWR net58 sky130_fd_sc_hd__clkbuf_1
Xinput47 W2END[4] VGND VGND VPWR VPWR net47 sky130_fd_sc_hd__buf_2
X_178_ net50 net96 net103 net87 Inst_W_IO4_ConfigMem.Inst_frame3_bit29.Q Inst_W_IO4_ConfigMem.Inst_frame3_bit28.Q
+ VGND VGND VPWR VPWR Inst_W_IO4_switch_matrix.E2BEGb0 sky130_fd_sc_hd__mux4_1
Xinput69 W6END[8] VGND VGND VPWR VPWR net88 sky130_fd_sc_hd__dlymetal6s2s_1
XFILLER_28_3 VGND VGND VPWR VPWR sky130_fd_sc_hd__fill_1
XTAP_TAPCELL_ROW_39_218 VGND VPWR sky130_fd_sc_hd__tapvpwrvgnd_1
XFILLER_57_38 VGND VGND VPWR VPWR sky130_fd_sc_hd__fill_2
XTAP_TAPCELL_ROW_53_232 VGND VPWR sky130_fd_sc_hd__tapvpwrvgnd_1
XFILLER_73_26 VGND VGND VPWR VPWR sky130_fd_sc_hd__decap_3
XFILLER_73_48 VGND VGND VPWR VPWR sky130_fd_sc_hd__decap_3
X_101_ net47 Inst_W_IO4_ConfigMem.Inst_frame0_bit23.Q Inst_W_IO4_ConfigMem.Inst_frame0_bit24.Q
+ VGND VGND VPWR VPWR _028_ sky130_fd_sc_hd__o21ai_1
XFILLER_47_60 VGND VGND VPWR VPWR sky130_fd_sc_hd__decap_3
XFILLER_8_65 VGND VGND VPWR VPWR sky130_fd_sc_hd__decap_3
XFILLER_8_32 VGND VGND VPWR VPWR sky130_fd_sc_hd__decap_3
XFILLER_8_21 VGND VGND VPWR VPWR sky130_fd_sc_hd__decap_3
XFILLER_43_18 VGND VGND VPWR VPWR sky130_fd_sc_hd__decap_3
XFILLER_17_41 VGND VGND VPWR VPWR sky130_fd_sc_hd__decap_3
XPHY_EDGE_ROW_9_Left_98 VGND VGND VPWR VPWR sky130_fd_sc_hd__decap_3
XTAP_TAPCELL_ROW_23_202 VGND VPWR sky130_fd_sc_hd__tapvpwrvgnd_1
XFILLER_28_62 VGND VGND VPWR VPWR sky130_fd_sc_hd__decap_3
XFILLER_44_61 VGND VGND VPWR VPWR sky130_fd_sc_hd__decap_3
XFILLER_5_55 VGND VGND VPWR VPWR sky130_fd_sc_hd__fill_1
XFILLER_5_22 VGND VGND VPWR VPWR sky130_fd_sc_hd__decap_3
XPHY_EDGE_ROW_59_Left_148 VGND VGND VPWR VPWR sky130_fd_sc_hd__decap_3
XFILLER_49_28 VGND VGND VPWR VPWR sky130_fd_sc_hd__fill_1
XPHY_EDGE_ROW_68_Left_157 VGND VGND VPWR VPWR sky130_fd_sc_hd__decap_3
XFILLER_65_27 VGND VGND VPWR VPWR sky130_fd_sc_hd__decap_3
X_280_ net17 net71 VGND VGND VPWR VPWR Inst_W_IO4_ConfigMem.Inst_frame1_bit20.Q sky130_fd_sc_hd__dlxtp_1
XPHY_EDGE_ROW_77_Left_166 VGND VGND VPWR VPWR sky130_fd_sc_hd__decap_3
XPHY_EDGE_ROW_86_Left_175 VGND VGND VPWR VPWR sky130_fd_sc_hd__decap_3
XFILLER_39_72 VGND VGND VPWR VPWR sky130_fd_sc_hd__fill_1
XFILLER_55_60 VGND VGND VPWR VPWR sky130_fd_sc_hd__decap_3
XFILLER_76_26 VGND VGND VPWR VPWR sky130_fd_sc_hd__fill_2
XFILLER_76_48 VGND VGND VPWR VPWR sky130_fd_sc_hd__decap_3
X_401_ net22 VGND VGND VPWR VPWR net195 sky130_fd_sc_hd__buf_1
X_332_ Inst_W_IO4_switch_matrix.E2BEG0 VGND VGND VPWR VPWR net134 sky130_fd_sc_hd__clkbuf_1
X_263_ net30 net72 VGND VGND VPWR VPWR Inst_W_IO4_ConfigMem.Inst_frame1_bit3.Q sky130_fd_sc_hd__dlxtp_1
X_194_ net28 net60 VGND VGND VPWR VPWR net122 sky130_fd_sc_hd__dlxtp_1
XFILLER_41_51 VGND VGND VPWR VPWR sky130_fd_sc_hd__decap_3
XFILLER_82_80 VGND VGND VPWR VPWR sky130_fd_sc_hd__fill_1
XANTENNA_17 FrameStrobe[19] VGND VGND VPWR VPWR sky130_fd_sc_hd__diode_2
XANTENNA_28 net130 VGND VGND VPWR VPWR sky130_fd_sc_hd__diode_2
Xoutput102 net121 VGND VGND VPWR VPWR C_config_C_bit1 sky130_fd_sc_hd__buf_2
Xoutput113 net132 VGND VGND VPWR VPWR E1BEG[2] sky130_fd_sc_hd__buf_2
Xoutput124 net143 VGND VGND VPWR VPWR E2BEGb[1] sky130_fd_sc_hd__buf_2
Xoutput157 net176 VGND VGND VPWR VPWR EE4BEG[8] sky130_fd_sc_hd__buf_2
Xoutput146 net165 VGND VGND VPWR VPWR EE4BEG[12] sky130_fd_sc_hd__buf_2
Xoutput135 net154 VGND VGND VPWR VPWR E6BEG[2] sky130_fd_sc_hd__buf_2
Xoutput168 net187 VGND VGND VPWR VPWR FrameData_O[18] sky130_fd_sc_hd__buf_2
Xoutput179 net198 VGND VGND VPWR VPWR FrameData_O[28] sky130_fd_sc_hd__buf_2
Xinput26 FrameData[29] VGND VGND VPWR VPWR net26 sky130_fd_sc_hd__clkbuf_2
X_177_ net49 net95 net102 net86 Inst_W_IO4_ConfigMem.Inst_frame3_bit31.Q Inst_W_IO4_ConfigMem.Inst_frame3_bit30.Q
+ VGND VGND VPWR VPWR Inst_W_IO4_switch_matrix.E2BEGb1 sky130_fd_sc_hd__mux4_1
Xinput37 FrameStrobe[0] VGND VGND VPWR VPWR net37 sky130_fd_sc_hd__clkbuf_2
X_315_ net20 net75 VGND VGND VPWR VPWR Inst_W_IO4_ConfigMem.Inst_frame0_bit23.Q sky130_fd_sc_hd__dlxtp_1
Xinput48 W2END[5] VGND VGND VPWR VPWR net48 sky130_fd_sc_hd__buf_2
Xinput59 W6END[0] VGND VGND VPWR VPWR net78 sky130_fd_sc_hd__buf_1
X_246_ net14 net67 VGND VGND VPWR VPWR Inst_W_IO4_ConfigMem.Inst_frame2_bit18.Q sky130_fd_sc_hd__dlxtp_1
Xinput15 FrameData[19] VGND VGND VPWR VPWR net15 sky130_fd_sc_hd__clkbuf_2
X_100_ Inst_W_IO4_ConfigMem.Inst_frame0_bit23.Q Inst_W_IO4_ConfigMem.Inst_frame0_bit24.Q
+ net43 VGND VGND VPWR VPWR _027_ sky130_fd_sc_hd__or3b_1
XFILLER_22_42 VGND VGND VPWR VPWR sky130_fd_sc_hd__decap_3
XFILLER_47_72 VGND VGND VPWR VPWR sky130_fd_sc_hd__fill_1
XFILLER_8_77 VGND VGND VPWR VPWR sky130_fd_sc_hd__decap_3
X_229_ net16 net65 VGND VGND VPWR VPWR Inst_W_IO4_ConfigMem.Inst_frame2_bit1.Q sky130_fd_sc_hd__dlxtp_1
XPHY_EDGE_ROW_40_Left_129 VGND VGND VPWR VPWR sky130_fd_sc_hd__decap_3
XFILLER_84_26 VGND VGND VPWR VPWR sky130_fd_sc_hd__fill_2
XFILLER_17_31 VGND VGND VPWR VPWR sky130_fd_sc_hd__decap_3
XFILLER_17_53 VGND VGND VPWR VPWR sky130_fd_sc_hd__decap_3
XFILLER_33_41 VGND VGND VPWR VPWR sky130_fd_sc_hd__decap_3
XFILLER_12_7 VGND VGND VPWR VPWR sky130_fd_sc_hd__decap_3
XFILLER_38_19 VGND VGND VPWR VPWR sky130_fd_sc_hd__decap_3
XTAP_TAPCELL_ROW_0_178 VGND VPWR sky130_fd_sc_hd__tapvpwrvgnd_1
XFILLER_54_29 VGND VGND VPWR VPWR sky130_fd_sc_hd__fill_1
XPHY_EDGE_ROW_17_Right_17 VGND VGND VPWR VPWR sky130_fd_sc_hd__decap_3
XFILLER_79_26 VGND VGND VPWR VPWR sky130_fd_sc_hd__decap_3
XPHY_EDGE_ROW_26_Right_26 VGND VGND VPWR VPWR sky130_fd_sc_hd__decap_3
XFILLER_28_41 VGND VGND VPWR VPWR sky130_fd_sc_hd__decap_3
XPHY_EDGE_ROW_35_Right_35 VGND VGND VPWR VPWR sky130_fd_sc_hd__decap_3
XPHY_EDGE_ROW_44_Right_44 VGND VGND VPWR VPWR sky130_fd_sc_hd__decap_3
XPHY_EDGE_ROW_53_Right_53 VGND VGND VPWR VPWR sky130_fd_sc_hd__decap_3
XPHY_EDGE_ROW_62_Right_62 VGND VGND VPWR VPWR sky130_fd_sc_hd__decap_3
XFILLER_14_76 VGND VGND VPWR VPWR sky130_fd_sc_hd__fill_1
XPHY_EDGE_ROW_71_Right_71 VGND VGND VPWR VPWR sky130_fd_sc_hd__decap_3
XPHY_EDGE_ROW_80_Right_80 VGND VGND VPWR VPWR sky130_fd_sc_hd__decap_3
XFILLER_39_40 VGND VGND VPWR VPWR sky130_fd_sc_hd__decap_3
X_400_ net21 VGND VGND VPWR VPWR net194 sky130_fd_sc_hd__buf_1
X_331_ Inst_W_IO4_switch_matrix.E1BEG3 VGND VGND VPWR VPWR net133 sky130_fd_sc_hd__clkbuf_1
X_193_ net26 net60 VGND VGND VPWR VPWR net121 sky130_fd_sc_hd__dlxtp_1
X_262_ net27 net72 VGND VGND VPWR VPWR Inst_W_IO4_ConfigMem.Inst_frame1_bit2.Q sky130_fd_sc_hd__dlxtp_1
XFILLER_2_79 VGND VGND VPWR VPWR sky130_fd_sc_hd__fill_2
XANTENNA_29 FrameStrobe[6] VGND VGND VPWR VPWR sky130_fd_sc_hd__diode_2
XANTENNA_18 FrameStrobe[1] VGND VGND VPWR VPWR sky130_fd_sc_hd__diode_2
XTAP_TAPCELL_ROW_74_253 VGND VPWR sky130_fd_sc_hd__tapvpwrvgnd_1
Xoutput103 net122 VGND VGND VPWR VPWR C_config_C_bit2 sky130_fd_sc_hd__buf_2
Xoutput114 net133 VGND VGND VPWR VPWR E1BEG[3] sky130_fd_sc_hd__buf_2
Xoutput125 net144 VGND VGND VPWR VPWR E2BEGb[2] sky130_fd_sc_hd__buf_2
Xoutput147 net166 VGND VGND VPWR VPWR EE4BEG[13] sky130_fd_sc_hd__buf_2
Xoutput158 net177 VGND VGND VPWR VPWR EE4BEG[9] sky130_fd_sc_hd__buf_2
Xoutput136 net155 VGND VGND VPWR VPWR E6BEG[3] sky130_fd_sc_hd__buf_2
Xoutput169 net188 VGND VGND VPWR VPWR FrameData_O[19] sky130_fd_sc_hd__buf_2
X_314_ net19 net75 VGND VGND VPWR VPWR Inst_W_IO4_ConfigMem.Inst_frame0_bit22.Q sky130_fd_sc_hd__dlxtp_1
Xinput38 FrameStrobe[4] VGND VGND VPWR VPWR net38 sky130_fd_sc_hd__buf_1
Xinput49 W2END[6] VGND VGND VPWR VPWR net49 sky130_fd_sc_hd__buf_2
Xinput16 FrameData[1] VGND VGND VPWR VPWR net16 sky130_fd_sc_hd__buf_1
Xinput27 FrameData[2] VGND VGND VPWR VPWR net27 sky130_fd_sc_hd__dlymetal6s2s_1
X_176_ net48 net94 net101 net85 Inst_W_IO4_ConfigMem.Inst_frame2_bit1.Q Inst_W_IO4_ConfigMem.Inst_frame2_bit0.Q
+ VGND VGND VPWR VPWR Inst_W_IO4_switch_matrix.E2BEGb2 sky130_fd_sc_hd__mux4_1
X_245_ net13 net67 VGND VGND VPWR VPWR Inst_W_IO4_ConfigMem.Inst_frame2_bit17.Q sky130_fd_sc_hd__dlxtp_1
XTAP_TAPCELL_ROW_15_194 VGND VPWR sky130_fd_sc_hd__tapvpwrvgnd_1
XFILLER_73_17 VGND VGND VPWR VPWR sky130_fd_sc_hd__decap_3
XFILLER_73_39 VGND VGND VPWR VPWR sky130_fd_sc_hd__decap_3
XFILLER_47_51 VGND VGND VPWR VPWR sky130_fd_sc_hd__decap_3
XFILLER_8_56 VGND VGND VPWR VPWR sky130_fd_sc_hd__decap_3
XFILLER_8_12 VGND VGND VPWR VPWR sky130_fd_sc_hd__decap_3
XTAP_TAPCELL_ROW_44_223 VGND VPWR sky130_fd_sc_hd__tapvpwrvgnd_1
X_159_ net86 net88 net79 net2 Inst_W_IO4_ConfigMem.Inst_frame1_bit2.Q Inst_W_IO4_ConfigMem.Inst_frame1_bit3.Q
+ VGND VGND VPWR VPWR Inst_W_IO4_switch_matrix.EE4BEG11 sky130_fd_sc_hd__mux4_1
X_228_ net5 net65 VGND VGND VPWR VPWR Inst_W_IO4_ConfigMem.Inst_frame2_bit0.Q sky130_fd_sc_hd__dlxtp_1
XFILLER_88_80 VGND VGND VPWR VPWR sky130_fd_sc_hd__fill_1
XFILLER_84_16 VGND VGND VPWR VPWR sky130_fd_sc_hd__decap_3
XFILLER_33_20 VGND VGND VPWR VPWR sky130_fd_sc_hd__decap_3
XFILLER_54_19 VGND VGND VPWR VPWR sky130_fd_sc_hd__decap_3
XTAP_TAPCELL_ROW_0_179 VGND VPWR sky130_fd_sc_hd__tapvpwrvgnd_1
XFILLER_70_29 VGND VGND VPWR VPWR sky130_fd_sc_hd__decap_3
XFILLER_79_38 VGND VGND VPWR VPWR sky130_fd_sc_hd__fill_2
XFILLER_28_53 VGND VGND VPWR VPWR sky130_fd_sc_hd__decap_3
XFILLER_44_52 VGND VGND VPWR VPWR sky130_fd_sc_hd__decap_3
XFILLER_5_57 VGND VGND VPWR VPWR sky130_fd_sc_hd__decap_3
XFILLER_5_46 VGND VGND VPWR VPWR sky130_fd_sc_hd__decap_3
XFILLER_49_19 VGND VGND VPWR VPWR sky130_fd_sc_hd__decap_3
XFILLER_65_18 VGND VGND VPWR VPWR sky130_fd_sc_hd__decap_3
XFILLER_72_7 VGND VGND VPWR VPWR sky130_fd_sc_hd__fill_1
XFILLER_25_43 VGND VGND VPWR VPWR sky130_fd_sc_hd__fill_1
X_330_ Inst_W_IO4_switch_matrix.E1BEG2 VGND VGND VPWR VPWR net132 sky130_fd_sc_hd__buf_1
X_192_ net25 net38 VGND VGND VPWR VPWR net120 sky130_fd_sc_hd__dlxtp_1
XFILLER_41_42 VGND VGND VPWR VPWR sky130_fd_sc_hd__decap_3
X_261_ net16 net73 VGND VGND VPWR VPWR Inst_W_IO4_ConfigMem.Inst_frame1_bit1.Q sky130_fd_sc_hd__dlxtp_1
XFILLER_82_71 VGND VGND VPWR VPWR sky130_fd_sc_hd__decap_3
XANTENNA_19 FrameStrobe[3] VGND VGND VPWR VPWR sky130_fd_sc_hd__diode_2
Xoutput104 net123 VGND VGND VPWR VPWR C_config_C_bit3 sky130_fd_sc_hd__buf_2
Xoutput115 net134 VGND VGND VPWR VPWR E2BEG[0] sky130_fd_sc_hd__buf_2
Xoutput126 net145 VGND VGND VPWR VPWR E2BEGb[3] sky130_fd_sc_hd__buf_2
Xoutput148 net167 VGND VGND VPWR VPWR EE4BEG[14] sky130_fd_sc_hd__buf_2
Xoutput137 net156 VGND VGND VPWR VPWR E6BEG[4] sky130_fd_sc_hd__buf_2
Xoutput159 net178 VGND VGND VPWR VPWR FrameData_O[0] sky130_fd_sc_hd__buf_2
XFILLER_87_49 VGND VGND VPWR VPWR sky130_fd_sc_hd__decap_3
XFILLER_2_7 VGND VGND VPWR VPWR sky130_fd_sc_hd__decap_3
X_313_ net18 net75 VGND VGND VPWR VPWR Inst_W_IO4_ConfigMem.Inst_frame0_bit21.Q sky130_fd_sc_hd__dlxtp_1
XFILLER_52_63 VGND VGND VPWR VPWR sky130_fd_sc_hd__fill_2
X_244_ net12 net67 VGND VGND VPWR VPWR Inst_W_IO4_ConfigMem.Inst_frame2_bit16.Q sky130_fd_sc_hd__dlxtp_1
Xinput28 FrameData[30] VGND VGND VPWR VPWR net28 sky130_fd_sc_hd__buf_2
Xinput39 W1END[0] VGND VGND VPWR VPWR net39 sky130_fd_sc_hd__clkbuf_2
X_175_ net47 net100 net93 net84 Inst_W_IO4_ConfigMem.Inst_frame2_bit2.Q Inst_W_IO4_ConfigMem.Inst_frame2_bit3.Q
+ VGND VGND VPWR VPWR Inst_W_IO4_switch_matrix.E2BEGb3 sky130_fd_sc_hd__mux4_1
Xinput17 FrameData[20] VGND VGND VPWR VPWR net17 sky130_fd_sc_hd__buf_2
XFILLER_77_60 VGND VGND VPWR VPWR sky130_fd_sc_hd__fill_2
XFILLER_73_29 VGND VGND VPWR VPWR sky130_fd_sc_hd__decap_3
XFILLER_22_22 VGND VGND VPWR VPWR sky130_fd_sc_hd__decap_3
XTAP_TAPCELL_ROW_6_185 VGND VPWR sky130_fd_sc_hd__tapvpwrvgnd_1
XFILLER_47_63 VGND VGND VPWR VPWR sky130_fd_sc_hd__decap_3
XFILLER_63_51 VGND VGND VPWR VPWR sky130_fd_sc_hd__decap_3
XFILLER_8_68 VGND VGND VPWR VPWR sky130_fd_sc_hd__decap_3
XFILLER_8_35 VGND VGND VPWR VPWR sky130_fd_sc_hd__decap_3
XFILLER_8_24 VGND VGND VPWR VPWR sky130_fd_sc_hd__decap_3
X_227_ net29 net61 VGND VGND VPWR VPWR Inst_W_IO4_ConfigMem.Inst_frame3_bit31.Q sky130_fd_sc_hd__dlxtp_1
X_089_ Inst_W_IO4_ConfigMem.Inst_frame0_bit8.Q _015_ _016_ _017_ _014_ VGND VGND VPWR
+ VPWR net107 sky130_fd_sc_hd__a41o_1
X_158_ net81 net83 net85 Inst_A_IO_1_bidirectional_frame_config_pass.Q Inst_W_IO4_ConfigMem.Inst_frame1_bit4.Q
+ Inst_W_IO4_ConfigMem.Inst_frame1_bit5.Q VGND VGND VPWR VPWR Inst_W_IO4_switch_matrix.EE4BEG12
+ sky130_fd_sc_hd__mux4_1
XFILLER_17_44 VGND VGND VPWR VPWR sky130_fd_sc_hd__decap_3
XFILLER_17_22 VGND VGND VPWR VPWR sky130_fd_sc_hd__decap_3
XFILLER_74_50 VGND VGND VPWR VPWR sky130_fd_sc_hd__decap_3
XPHY_EDGE_ROW_3_Right_3 VGND VGND VPWR VPWR sky130_fd_sc_hd__decap_3
XFILLER_44_64 VGND VGND VPWR VPWR sky130_fd_sc_hd__fill_2
XPHY_EDGE_ROW_19_Left_108 VGND VGND VPWR VPWR sky130_fd_sc_hd__decap_3
XPHY_EDGE_ROW_28_Left_117 VGND VGND VPWR VPWR sky130_fd_sc_hd__decap_3
XPHY_EDGE_ROW_37_Left_126 VGND VGND VPWR VPWR sky130_fd_sc_hd__decap_3
XFILLER_14_23 VGND VGND VPWR VPWR sky130_fd_sc_hd__decap_3
XPHY_EDGE_ROW_46_Left_135 VGND VGND VPWR VPWR sky130_fd_sc_hd__decap_3
XFILLER_39_20 VGND VGND VPWR VPWR sky130_fd_sc_hd__decap_3
XPHY_EDGE_ROW_55_Left_144 VGND VGND VPWR VPWR sky130_fd_sc_hd__decap_3
XFILLER_55_63 VGND VGND VPWR VPWR sky130_fd_sc_hd__fill_2
XPHY_EDGE_ROW_64_Left_153 VGND VGND VPWR VPWR sky130_fd_sc_hd__decap_3
XPHY_EDGE_ROW_73_Left_162 VGND VGND VPWR VPWR sky130_fd_sc_hd__decap_3
XPHY_EDGE_ROW_82_Left_171 VGND VGND VPWR VPWR sky130_fd_sc_hd__decap_3
XFILLER_76_29 VGND VGND VPWR VPWR sky130_fd_sc_hd__decap_3
XFILLER_25_22 VGND VGND VPWR VPWR sky130_fd_sc_hd__decap_3
X_260_ net5 net73 VGND VGND VPWR VPWR Inst_W_IO4_ConfigMem.Inst_frame1_bit0.Q sky130_fd_sc_hd__dlxtp_1
X_191_ net24 net38 VGND VGND VPWR VPWR net117 sky130_fd_sc_hd__dlxtp_1
XFILLER_41_54 VGND VGND VPWR VPWR sky130_fd_sc_hd__fill_2
XFILLER_2_26 VGND VGND VPWR VPWR sky130_fd_sc_hd__fill_2
X_389_ net9 VGND VGND VPWR VPWR net182 sky130_fd_sc_hd__clkbuf_1
Xoutput105 net124 VGND VGND VPWR VPWR D_I_top sky130_fd_sc_hd__buf_2
Xoutput116 net135 VGND VGND VPWR VPWR E2BEG[1] sky130_fd_sc_hd__buf_2
Xoutput127 net146 VGND VGND VPWR VPWR E2BEGb[4] sky130_fd_sc_hd__buf_2
Xoutput149 net168 VGND VGND VPWR VPWR EE4BEG[15] sky130_fd_sc_hd__buf_2
XFILLER_56_3 VGND VGND VPWR VPWR sky130_fd_sc_hd__fill_1
Xoutput138 net157 VGND VGND VPWR VPWR E6BEG[5] sky130_fd_sc_hd__buf_2
XTAP_TAPCELL_ROW_65_244 VGND VPWR sky130_fd_sc_hd__tapvpwrvgnd_1
XFILLER_36_32 VGND VGND VPWR VPWR sky130_fd_sc_hd__decap_3
X_243_ net11 net68 VGND VGND VPWR VPWR Inst_W_IO4_ConfigMem.Inst_frame2_bit15.Q sky130_fd_sc_hd__dlxtp_1
X_312_ net17 net75 VGND VGND VPWR VPWR Inst_W_IO4_ConfigMem.Inst_frame0_bit20.Q sky130_fd_sc_hd__dlxtp_1
Xinput18 FrameData[21] VGND VGND VPWR VPWR net18 sky130_fd_sc_hd__buf_2
Xinput29 FrameData[31] VGND VGND VPWR VPWR net29 sky130_fd_sc_hd__buf_2
X_174_ net46 net99 net92 net83 Inst_W_IO4_ConfigMem.Inst_frame2_bit4.Q Inst_W_IO4_ConfigMem.Inst_frame2_bit5.Q
+ VGND VGND VPWR VPWR Inst_W_IO4_switch_matrix.E2BEGb4 sky130_fd_sc_hd__mux4_1
XFILLER_22_45 VGND VGND VPWR VPWR sky130_fd_sc_hd__decap_3
XFILLER_47_42 VGND VGND VPWR VPWR sky130_fd_sc_hd__decap_3
X_157_ net87 net89 net80 Inst_B_IO_1_bidirectional_frame_config_pass.Q Inst_W_IO4_ConfigMem.Inst_frame1_bit6.Q
+ Inst_W_IO4_ConfigMem.Inst_frame1_bit7.Q VGND VGND VPWR VPWR Inst_W_IO4_switch_matrix.EE4BEG13
+ sky130_fd_sc_hd__mux4_1
X_226_ net28 net61 VGND VGND VPWR VPWR Inst_W_IO4_ConfigMem.Inst_frame3_bit30.Q sky130_fd_sc_hd__dlxtp_1
X_088_ net45 Inst_W_IO4_ConfigMem.Inst_frame0_bit9.Q VGND VGND VPWR VPWR _017_ sky130_fd_sc_hd__nand2_1
XFILLER_40_6 VGND VGND VPWR VPWR sky130_fd_sc_hd__decap_3
XFILLER_19_3 VGND VGND VPWR VPWR sky130_fd_sc_hd__fill_2
XTAP_TAPCELL_ROW_35_214 VGND VPWR sky130_fd_sc_hd__tapvpwrvgnd_1
XFILLER_84_29 VGND VGND VPWR VPWR sky130_fd_sc_hd__fill_1
XFILLER_68_19 VGND VGND VPWR VPWR sky130_fd_sc_hd__decap_3
XFILLER_17_34 VGND VGND VPWR VPWR sky130_fd_sc_hd__decap_3
XFILLER_33_11 VGND VGND VPWR VPWR sky130_fd_sc_hd__decap_3
XFILLER_33_44 VGND VGND VPWR VPWR sky130_fd_sc_hd__decap_3
XFILLER_74_62 VGND VGND VPWR VPWR sky130_fd_sc_hd__fill_1
X_209_ net9 net61 VGND VGND VPWR VPWR Inst_W_IO4_ConfigMem.Inst_frame3_bit13.Q sky130_fd_sc_hd__dlxtp_1
XFILLER_79_29 VGND VGND VPWR VPWR sky130_fd_sc_hd__decap_3
XFILLER_28_44 VGND VGND VPWR VPWR sky130_fd_sc_hd__decap_3
XFILLER_44_21 VGND VGND VPWR VPWR sky130_fd_sc_hd__decap_3
XFILLER_44_32 VGND VGND VPWR VPWR sky130_fd_sc_hd__fill_2
XFILLER_44_43 VGND VGND VPWR VPWR sky130_fd_sc_hd__decap_3
XFILLER_60_53 VGND VGND VPWR VPWR sky130_fd_sc_hd__decap_3
XPHY_EDGE_ROW_13_Right_13 VGND VGND VPWR VPWR sky130_fd_sc_hd__decap_3
XPHY_EDGE_ROW_22_Right_22 VGND VGND VPWR VPWR sky130_fd_sc_hd__decap_3
XPHY_EDGE_ROW_31_Right_31 VGND VGND VPWR VPWR sky130_fd_sc_hd__decap_3
XPHY_EDGE_ROW_40_Right_40 VGND VGND VPWR VPWR sky130_fd_sc_hd__decap_3
XFILLER_39_43 VGND VGND VPWR VPWR sky130_fd_sc_hd__decap_3
XFILLER_58_7 VGND VGND VPWR VPWR sky130_fd_sc_hd__decap_3
X_190_ net23 net60 VGND VGND VPWR VPWR net116 sky130_fd_sc_hd__dlxtp_1
XFILLER_82_62 VGND VGND VPWR VPWR sky130_fd_sc_hd__decap_3
X_388_ net8 VGND VGND VPWR VPWR net181 sky130_fd_sc_hd__clkbuf_1
Xoutput106 net125 VGND VGND VPWR VPWR D_T_top sky130_fd_sc_hd__buf_2
Xoutput117 net136 VGND VGND VPWR VPWR E2BEG[2] sky130_fd_sc_hd__buf_2
Xoutput128 net147 VGND VGND VPWR VPWR E2BEGb[5] sky130_fd_sc_hd__buf_2
XFILLER_49_3 VGND VGND VPWR VPWR sky130_fd_sc_hd__fill_1
Xoutput139 net158 VGND VGND VPWR VPWR E6BEG[6] sky130_fd_sc_hd__buf_2
XTAP_TAPCELL_ROW_80_259 VGND VPWR sky130_fd_sc_hd__tapvpwrvgnd_1
X_242_ net10 net68 VGND VGND VPWR VPWR Inst_W_IO4_ConfigMem.Inst_frame2_bit14.Q sky130_fd_sc_hd__dlxtp_1
X_311_ net15 net76 VGND VGND VPWR VPWR Inst_W_IO4_ConfigMem.Inst_frame0_bit19.Q sky130_fd_sc_hd__dlxtp_1
X_173_ net45 net98 net91 net82 Inst_W_IO4_ConfigMem.Inst_frame2_bit6.Q Inst_W_IO4_ConfigMem.Inst_frame2_bit7.Q
+ VGND VGND VPWR VPWR Inst_W_IO4_switch_matrix.E2BEGb5 sky130_fd_sc_hd__mux4_1
XFILLER_52_32 VGND VGND VPWR VPWR sky130_fd_sc_hd__decap_3
Xinput19 FrameData[22] VGND VGND VPWR VPWR net19 sky130_fd_sc_hd__buf_2
XFILLER_47_54 VGND VGND VPWR VPWR sky130_fd_sc_hd__fill_2
XFILLER_8_15 VGND VGND VPWR VPWR sky130_fd_sc_hd__decap_3
XFILLER_63_42 VGND VGND VPWR VPWR sky130_fd_sc_hd__decap_3
XPHY_EDGE_ROW_69_Right_69 VGND VGND VPWR VPWR sky130_fd_sc_hd__decap_3
XFILLER_8_59 VGND VGND VPWR VPWR sky130_fd_sc_hd__decap_3
X_087_ Inst_W_IO4_ConfigMem.Inst_frame0_bit9.Q net47 Inst_W_IO4_ConfigMem.Inst_frame0_bit10.Q
+ VGND VGND VPWR VPWR _016_ sky130_fd_sc_hd__o21ai_1
X_225_ net26 net62 VGND VGND VPWR VPWR Inst_W_IO4_ConfigMem.Inst_frame3_bit29.Q sky130_fd_sc_hd__dlxtp_1
X_156_ net53 net55 net57 Inst_C_IO_1_bidirectional_frame_config_pass.Q Inst_W_IO4_ConfigMem.Inst_frame1_bit8.Q
+ Inst_W_IO4_ConfigMem.Inst_frame1_bit9.Q VGND VGND VPWR VPWR Inst_W_IO4_switch_matrix.EE4BEG14
+ sky130_fd_sc_hd__mux4_1
XFILLER_88_61 VGND VGND VPWR VPWR sky130_fd_sc_hd__decap_3
XPHY_EDGE_ROW_78_Right_78 VGND VGND VPWR VPWR sky130_fd_sc_hd__decap_3
XPHY_EDGE_ROW_87_Right_87 VGND VGND VPWR VPWR sky130_fd_sc_hd__decap_3
XTAP_TAPCELL_ROW_50_229 VGND VPWR sky130_fd_sc_hd__tapvpwrvgnd_1
XFILLER_84_19 VGND VGND VPWR VPWR sky130_fd_sc_hd__decap_3
XFILLER_17_57 VGND VGND VPWR VPWR sky130_fd_sc_hd__decap_3
XFILLER_33_23 VGND VGND VPWR VPWR sky130_fd_sc_hd__decap_3
XPHY_EDGE_ROW_4_Left_93 VGND VGND VPWR VPWR sky130_fd_sc_hd__decap_3
X_139_ net51 net52 net53 net54 Inst_W_IO4_ConfigMem.Inst_frame0_bit4.Q Inst_W_IO4_ConfigMem.Inst_frame0_bit5.Q
+ VGND VGND VPWR VPWR _061_ sky130_fd_sc_hd__mux4_1
X_208_ net8 net61 VGND VGND VPWR VPWR Inst_W_IO4_ConfigMem.Inst_frame3_bit12.Q sky130_fd_sc_hd__dlxtp_1
XFILLER_31_3 VGND VGND VPWR VPWR sky130_fd_sc_hd__fill_2
XFILLER_0_60 VGND VGND VPWR VPWR sky130_fd_sc_hd__decap_3
XFILLER_28_56 VGND VGND VPWR VPWR sky130_fd_sc_hd__decap_3
XFILLER_60_21 VGND VGND VPWR VPWR sky130_fd_sc_hd__decap_3
XFILLER_5_49 VGND VGND VPWR VPWR sky130_fd_sc_hd__decap_3
XFILLER_60_32 VGND VGND VPWR VPWR sky130_fd_sc_hd__decap_3
XFILLER_39_11 VGND VGND VPWR VPWR sky130_fd_sc_hd__decap_3
XFILLER_39_55 VGND VGND VPWR VPWR sky130_fd_sc_hd__fill_1
XTAP_TAPCELL_ROW_86_265 VGND VPWR sky130_fd_sc_hd__tapvpwrvgnd_1
XFILLER_6_70 VGND VGND VPWR VPWR sky130_fd_sc_hd__decap_3
XFILLER_25_57 VGND VGND VPWR VPWR sky130_fd_sc_hd__fill_1
XFILLER_41_45 VGND VGND VPWR VPWR sky130_fd_sc_hd__decap_3
XFILLER_9_3 VGND VGND VPWR VPWR sky130_fd_sc_hd__fill_2
XFILLER_66_75 VGND VGND VPWR VPWR sky130_fd_sc_hd__fill_2
XFILLER_82_74 VGND VGND VPWR VPWR sky130_fd_sc_hd__decap_3
XFILLER_82_52 VGND VGND VPWR VPWR sky130_fd_sc_hd__decap_3
X_387_ net7 VGND VGND VPWR VPWR net180 sky130_fd_sc_hd__buf_1
Xoutput107 net126 VGND VGND VPWR VPWR D_config_C_bit0 sky130_fd_sc_hd__buf_2
Xoutput118 net137 VGND VGND VPWR VPWR E2BEG[3] sky130_fd_sc_hd__buf_2
Xoutput129 net148 VGND VGND VPWR VPWR E2BEGb[6] sky130_fd_sc_hd__buf_2
X_310_ net14 net76 VGND VGND VPWR VPWR Inst_W_IO4_ConfigMem.Inst_frame0_bit18.Q sky130_fd_sc_hd__dlxtp_1
XFILLER_36_23 VGND VGND VPWR VPWR sky130_fd_sc_hd__decap_3
XFILLER_52_22 VGND VGND VPWR VPWR sky130_fd_sc_hd__decap_3
XTAP_TAPCELL_ROW_56_235 VGND VPWR sky130_fd_sc_hd__tapvpwrvgnd_1
X_172_ net44 net97 net105 net81 Inst_W_IO4_ConfigMem.Inst_frame2_bit8.Q Inst_W_IO4_ConfigMem.Inst_frame2_bit9.Q
+ VGND VGND VPWR VPWR Inst_W_IO4_switch_matrix.E2BEGb6 sky130_fd_sc_hd__mux4_1
X_241_ net9 net65 VGND VGND VPWR VPWR Inst_W_IO4_ConfigMem.Inst_frame2_bit13.Q sky130_fd_sc_hd__dlxtp_1
XFILLER_61_3 VGND VGND VPWR VPWR sky130_fd_sc_hd__fill_2
XFILLER_22_25 VGND VGND VPWR VPWR sky130_fd_sc_hd__decap_3
XFILLER_22_36 VGND VGND VPWR VPWR sky130_fd_sc_hd__decap_3
XFILLER_47_66 VGND VGND VPWR VPWR sky130_fd_sc_hd__decap_3
XFILLER_8_38 VGND VGND VPWR VPWR sky130_fd_sc_hd__fill_2
XFILLER_8_27 VGND VGND VPWR VPWR sky130_fd_sc_hd__fill_1
X_224_ net25 net62 VGND VGND VPWR VPWR Inst_W_IO4_ConfigMem.Inst_frame3_bit28.Q sky130_fd_sc_hd__dlxtp_1
XFILLER_63_10 VGND VGND VPWR VPWR sky130_fd_sc_hd__decap_3
XFILLER_12_80 VGND VGND VPWR VPWR sky130_fd_sc_hd__fill_1
X_086_ Inst_W_IO4_ConfigMem.Inst_frame0_bit9.Q Inst_W_IO4_ConfigMem.Inst_frame0_bit10.Q
+ net43 VGND VGND VPWR VPWR _015_ sky130_fd_sc_hd__or3b_1
X_155_ net54 net59 net56 Inst_D_IO_1_bidirectional_frame_config_pass.Q Inst_W_IO4_ConfigMem.Inst_frame1_bit11.Q
+ Inst_W_IO4_ConfigMem.Inst_frame1_bit10.Q VGND VGND VPWR VPWR Inst_W_IO4_switch_matrix.EE4BEG15
+ sky130_fd_sc_hd__mux4_1
XFILLER_88_51 VGND VGND VPWR VPWR sky130_fd_sc_hd__fill_1
XTAP_TAPCELL_ROW_11_190 VGND VPWR sky130_fd_sc_hd__tapvpwrvgnd_1
XFILLER_17_47 VGND VGND VPWR VPWR sky130_fd_sc_hd__decap_3
XFILLER_17_25 VGND VGND VPWR VPWR sky130_fd_sc_hd__decap_3
XTAP_TAPCELL_ROW_26_205 VGND VPWR sky130_fd_sc_hd__tapvpwrvgnd_1
XFILLER_33_57 VGND VGND VPWR VPWR sky130_fd_sc_hd__fill_1
XFILLER_33_79 VGND VGND VPWR VPWR sky130_fd_sc_hd__fill_2
XFILLER_58_10 VGND VGND VPWR VPWR sky130_fd_sc_hd__decap_3
XFILLER_58_32 VGND VGND VPWR VPWR sky130_fd_sc_hd__fill_2
XFILLER_74_53 VGND VGND VPWR VPWR sky130_fd_sc_hd__decap_3
X_207_ net7 net63 VGND VGND VPWR VPWR Inst_W_IO4_ConfigMem.Inst_frame3_bit11.Q sky130_fd_sc_hd__dlxtp_1
X_069_ Inst_W_IO4_ConfigMem.Inst_frame0_bit28.Q VGND VGND VPWR VPWR _005_ sky130_fd_sc_hd__inv_1
X_138_ _010_ _059_ Inst_W_IO4_ConfigMem.Inst_frame0_bit7.Q VGND VGND VPWR VPWR _060_
+ sky130_fd_sc_hd__o21a_1
XFILLER_0_50 VGND VGND VPWR VPWR sky130_fd_sc_hd__decap_3
XFILLER_0_72 VGND VGND VPWR VPWR sky130_fd_sc_hd__decap_3
XFILLER_69_20 VGND VGND VPWR VPWR sky130_fd_sc_hd__decap_3
XFILLER_85_63 VGND VGND VPWR VPWR sky130_fd_sc_hd__decap_3
XFILLER_85_52 VGND VGND VPWR VPWR sky130_fd_sc_hd__fill_1
XPHY_EDGE_ROW_7_Right_7 VGND VGND VPWR VPWR sky130_fd_sc_hd__decap_3
XFILLER_14_26 VGND VGND VPWR VPWR sky130_fd_sc_hd__fill_2
XPHY_EDGE_ROW_15_Left_104 VGND VGND VPWR VPWR sky130_fd_sc_hd__decap_3
XPHY_EDGE_ROW_24_Left_113 VGND VGND VPWR VPWR sky130_fd_sc_hd__decap_3
XFILLER_39_23 VGND VGND VPWR VPWR sky130_fd_sc_hd__fill_2
XFILLER_55_55 VGND VGND VPWR VPWR sky130_fd_sc_hd__fill_1
XPHY_EDGE_ROW_33_Left_122 VGND VGND VPWR VPWR sky130_fd_sc_hd__decap_3
XPHY_EDGE_ROW_42_Left_131 VGND VGND VPWR VPWR sky130_fd_sc_hd__decap_3
XPHY_EDGE_ROW_51_Left_140 VGND VGND VPWR VPWR sky130_fd_sc_hd__decap_3
XFILLER_66_21 VGND VGND VPWR VPWR sky130_fd_sc_hd__decap_3
XFILLER_15_80 VGND VGND VPWR VPWR sky130_fd_sc_hd__fill_1
X_386_ net6 VGND VGND VPWR VPWR net179 sky130_fd_sc_hd__clkbuf_2
Xoutput108 net127 VGND VGND VPWR VPWR D_config_C_bit1 sky130_fd_sc_hd__buf_2
Xoutput119 net138 VGND VGND VPWR VPWR E2BEG[4] sky130_fd_sc_hd__buf_2
XFILLER_63_7 VGND VGND VPWR VPWR sky130_fd_sc_hd__decap_3
Xoutput90 net109 VGND VGND VPWR VPWR A_config_C_bit1 sky130_fd_sc_hd__buf_2
XFILLER_36_35 VGND VGND VPWR VPWR sky130_fd_sc_hd__decap_3
X_240_ net8 net65 VGND VGND VPWR VPWR Inst_W_IO4_ConfigMem.Inst_frame2_bit12.Q sky130_fd_sc_hd__dlxtp_1
X_171_ net43 net90 net104 net78 Inst_W_IO4_ConfigMem.Inst_frame2_bit10.Q Inst_W_IO4_ConfigMem.Inst_frame2_bit11.Q
+ VGND VGND VPWR VPWR Inst_W_IO4_switch_matrix.E2BEGb7 sky130_fd_sc_hd__mux4_1
XFILLER_77_20 VGND VGND VPWR VPWR sky130_fd_sc_hd__decap_3
X_369_ Inst_W_IO4_switch_matrix.EE4BEG9 VGND VGND VPWR VPWR net177 sky130_fd_sc_hd__buf_1
XFILLER_22_48 VGND VGND VPWR VPWR sky130_fd_sc_hd__fill_2
XFILLER_47_45 VGND VGND VPWR VPWR sky130_fd_sc_hd__decap_3
X_223_ net24 net62 VGND VGND VPWR VPWR Inst_W_IO4_ConfigMem.Inst_frame3_bit27.Q sky130_fd_sc_hd__dlxtp_1
XFILLER_88_41 VGND VGND VPWR VPWR sky130_fd_sc_hd__fill_1
X_085_ _000_ _012_ _013_ Inst_W_IO4_ConfigMem.Inst_frame0_bit8.Q VGND VGND VPWR VPWR
+ _014_ sky130_fd_sc_hd__a211oi_1
XFILLER_40_9 VGND VGND VPWR VPWR sky130_fd_sc_hd__decap_3
X_154_ net41 net1 net92 net3 Inst_W_IO4_ConfigMem.Inst_frame1_bit13.Q Inst_W_IO4_ConfigMem.Inst_frame1_bit12.Q
+ VGND VGND VPWR VPWR Inst_W_IO4_switch_matrix.E6BEG0 sky130_fd_sc_hd__mux4_1
XFILLER_17_37 VGND VGND VPWR VPWR sky130_fd_sc_hd__fill_1
XFILLER_33_14 VGND VGND VPWR VPWR sky130_fd_sc_hd__decap_3
XFILLER_33_47 VGND VGND VPWR VPWR sky130_fd_sc_hd__decap_3
XFILLER_58_22 VGND VGND VPWR VPWR sky130_fd_sc_hd__decap_3
XTAP_TAPCELL_ROW_2_181 VGND VPWR sky130_fd_sc_hd__tapvpwrvgnd_1
XFILLER_74_10 VGND VGND VPWR VPWR sky130_fd_sc_hd__fill_1
X_137_ net47 net48 net49 net50 Inst_W_IO4_ConfigMem.Inst_frame0_bit4.Q Inst_W_IO4_ConfigMem.Inst_frame0_bit5.Q
+ VGND VGND VPWR VPWR _059_ sky130_fd_sc_hd__mux4_1
X_206_ net6 net63 VGND VGND VPWR VPWR Inst_W_IO4_ConfigMem.Inst_frame3_bit10.Q sky130_fd_sc_hd__dlxtp_1
X_068_ Inst_W_IO4_ConfigMem.Inst_frame0_bit27.Q VGND VGND VPWR VPWR _004_ sky130_fd_sc_hd__inv_1
XFILLER_28_47 VGND VGND VPWR VPWR sky130_fd_sc_hd__decap_3
XFILLER_44_24 VGND VGND VPWR VPWR sky130_fd_sc_hd__decap_3
XFILLER_44_46 VGND VGND VPWR VPWR sky130_fd_sc_hd__decap_3
XFILLER_60_56 VGND VGND VPWR VPWR sky130_fd_sc_hd__fill_2
XFILLER_69_10 VGND VGND VPWR VPWR sky130_fd_sc_hd__decap_3
XFILLER_69_54 VGND VGND VPWR VPWR sky130_fd_sc_hd__fill_2
XFILLER_30_37 VGND VGND VPWR VPWR sky130_fd_sc_hd__fill_1
XFILLER_39_46 VGND VGND VPWR VPWR sky130_fd_sc_hd__decap_3
XFILLER_39_57 VGND VGND VPWR VPWR sky130_fd_sc_hd__decap_3
XTAP_TAPCELL_ROW_77_256 VGND VPWR sky130_fd_sc_hd__tapvpwrvgnd_1
XFILLER_84_3 VGND VGND VPWR VPWR sky130_fd_sc_hd__fill_2
XFILLER_6_61 VGND VGND VPWR VPWR sky130_fd_sc_hd__decap_3
XFILLER_82_65 VGND VGND VPWR VPWR sky130_fd_sc_hd__decap_3
X_385_ net36 VGND VGND VPWR VPWR net209 sky130_fd_sc_hd__clkbuf_2
XFILLER_82_43 VGND VGND VPWR VPWR sky130_fd_sc_hd__decap_3
Xoutput109 net128 VGND VGND VPWR VPWR D_config_C_bit2 sky130_fd_sc_hd__buf_2
Xoutput91 net110 VGND VGND VPWR VPWR A_config_C_bit2 sky130_fd_sc_hd__buf_2
XTAP_TAPCELL_ROW_18_197 VGND VPWR sky130_fd_sc_hd__tapvpwrvgnd_1
XFILLER_36_69 VGND VGND VPWR VPWR sky130_fd_sc_hd__fill_2
X_170_ net78 net82 net84 net1 Inst_W_IO4_ConfigMem.Inst_frame2_bit12.Q Inst_W_IO4_ConfigMem.Inst_frame2_bit13.Q
+ VGND VGND VPWR VPWR Inst_W_IO4_switch_matrix.EE4BEG0 sky130_fd_sc_hd__mux4_1
XFILLER_52_35 VGND VGND VPWR VPWR sky130_fd_sc_hd__fill_1
XFILLER_52_68 VGND VGND VPWR VPWR sky130_fd_sc_hd__fill_1
XPHY_EDGE_ROW_70_Left_159 VGND VGND VPWR VPWR sky130_fd_sc_hd__decap_3
XTAP_TAPCELL_ROW_47_226 VGND VPWR sky130_fd_sc_hd__tapvpwrvgnd_1
X_368_ Inst_W_IO4_switch_matrix.EE4BEG8 VGND VGND VPWR VPWR net176 sky130_fd_sc_hd__buf_1
X_299_ net34 net74 VGND VGND VPWR VPWR Inst_W_IO4_ConfigMem.Inst_frame0_bit7.Q sky130_fd_sc_hd__dlxtp_1
XFILLER_22_16 VGND VGND VPWR VPWR sky130_fd_sc_hd__decap_3
XTAP_TAPCELL_ROW_61_240 VGND VPWR sky130_fd_sc_hd__tapvpwrvgnd_1
XPHY_EDGE_ROW_29_Right_29 VGND VGND VPWR VPWR sky130_fd_sc_hd__decap_3
XFILLER_47_57 VGND VGND VPWR VPWR sky130_fd_sc_hd__decap_3
XFILLER_63_45 VGND VGND VPWR VPWR sky130_fd_sc_hd__decap_3
XFILLER_8_29 VGND VGND VPWR VPWR sky130_fd_sc_hd__decap_3
XFILLER_8_18 VGND VGND VPWR VPWR sky130_fd_sc_hd__decap_3
X_222_ net23 net62 VGND VGND VPWR VPWR Inst_W_IO4_ConfigMem.Inst_frame3_bit26.Q sky130_fd_sc_hd__dlxtp_1
XPHY_EDGE_ROW_38_Right_38 VGND VGND VPWR VPWR sky130_fd_sc_hd__decap_3
X_153_ net42 Inst_A_IO_1_bidirectional_frame_config_pass.Q net91 Inst_C_IO_1_bidirectional_frame_config_pass.Q
+ Inst_W_IO4_ConfigMem.Inst_frame1_bit15.Q Inst_W_IO4_ConfigMem.Inst_frame1_bit14.Q
+ VGND VGND VPWR VPWR Inst_W_IO4_switch_matrix.E6BEG1 sky130_fd_sc_hd__mux4_1
X_084_ Inst_W_IO4_ConfigMem.Inst_frame0_bit9.Q net46 Inst_W_IO4_ConfigMem.Inst_frame0_bit10.Q
+ VGND VGND VPWR VPWR _013_ sky130_fd_sc_hd__and3b_1
XPHY_EDGE_ROW_47_Right_47 VGND VGND VPWR VPWR sky130_fd_sc_hd__decap_3
XPHY_EDGE_ROW_56_Right_56 VGND VGND VPWR VPWR sky130_fd_sc_hd__decap_3
XPHY_EDGE_ROW_65_Right_65 VGND VGND VPWR VPWR sky130_fd_sc_hd__decap_3
XFILLER_33_26 VGND VGND VPWR VPWR sky130_fd_sc_hd__decap_3
XPHY_EDGE_ROW_74_Right_74 VGND VGND VPWR VPWR sky130_fd_sc_hd__decap_3
XPHY_EDGE_ROW_83_Right_83 VGND VGND VPWR VPWR sky130_fd_sc_hd__decap_3
XFILLER_58_78 VGND VGND VPWR VPWR sky130_fd_sc_hd__decap_3
X_136_ Inst_W_IO4_ConfigMem.Inst_frame0_bit6.Q _057_ VGND VGND VPWR VPWR _058_ sky130_fd_sc_hd__or2_1
X_205_ net36 net62 VGND VGND VPWR VPWR Inst_W_IO4_ConfigMem.Inst_frame3_bit9.Q sky130_fd_sc_hd__dlxtp_1
X_067_ Inst_W_IO4_ConfigMem.Inst_frame0_bit31.Q VGND VGND VPWR VPWR _003_ sky130_fd_sc_hd__inv_1
XFILLER_0_41 VGND VGND VPWR VPWR sky130_fd_sc_hd__decap_3
XFILLER_0_63 VGND VGND VPWR VPWR sky130_fd_sc_hd__decap_3
XFILLER_9_50 VGND VGND VPWR VPWR sky130_fd_sc_hd__decap_3
XTAP_TAPCELL_ROW_31_210 VGND VPWR sky130_fd_sc_hd__tapvpwrvgnd_1
XFILLER_28_59 VGND VGND VPWR VPWR sky130_fd_sc_hd__decap_3
XFILLER_44_58 VGND VGND VPWR VPWR sky130_fd_sc_hd__decap_3
XFILLER_5_19 VGND VGND VPWR VPWR sky130_fd_sc_hd__decap_3
XFILLER_60_24 VGND VGND VPWR VPWR sky130_fd_sc_hd__decap_3
XFILLER_60_35 VGND VGND VPWR VPWR sky130_fd_sc_hd__fill_2
XPHY_EDGE_ROW_8_Left_97 VGND VGND VPWR VPWR sky130_fd_sc_hd__decap_3
X_119_ net43 net45 net44 net46 Inst_W_IO4_ConfigMem.Inst_frame0_bit19.Q Inst_W_IO4_ConfigMem.Inst_frame0_bit18.Q
+ VGND VGND VPWR VPWR _043_ sky130_fd_sc_hd__mux4_1
XFILLER_39_14 VGND VGND VPWR VPWR sky130_fd_sc_hd__decap_3
XFILLER_55_57 VGND VGND VPWR VPWR sky130_fd_sc_hd__decap_3
XFILLER_77_3 VGND VGND VPWR VPWR sky130_fd_sc_hd__fill_2
XFILLER_6_73 VGND VGND VPWR VPWR sky130_fd_sc_hd__decap_3
XFILLER_41_48 VGND VGND VPWR VPWR sky130_fd_sc_hd__decap_3
XFILLER_66_45 VGND VGND VPWR VPWR sky130_fd_sc_hd__decap_3
XFILLER_82_55 VGND VGND VPWR VPWR sky130_fd_sc_hd__fill_1
XFILLER_82_77 VGND VGND VPWR VPWR sky130_fd_sc_hd__decap_3
X_384_ net35 VGND VGND VPWR VPWR net208 sky130_fd_sc_hd__clkbuf_2
Xoutput92 net111 VGND VGND VPWR VPWR A_config_C_bit3 sky130_fd_sc_hd__buf_2
XFILLER_36_26 VGND VGND VPWR VPWR sky130_fd_sc_hd__fill_2
XFILLER_52_25 VGND VGND VPWR VPWR sky130_fd_sc_hd__decap_3
XTAP_TAPCELL_ROW_9_188 VGND VPWR sky130_fd_sc_hd__tapvpwrvgnd_1
X_298_ net33 net74 VGND VGND VPWR VPWR Inst_W_IO4_ConfigMem.Inst_frame0_bit6.Q sky130_fd_sc_hd__dlxtp_1
X_367_ Inst_W_IO4_switch_matrix.EE4BEG7 VGND VGND VPWR VPWR net175 sky130_fd_sc_hd__clkbuf_1
XFILLER_42_80 VGND VGND VPWR VPWR sky130_fd_sc_hd__fill_1
XFILLER_22_39 VGND VGND VPWR VPWR sky130_fd_sc_hd__decap_3
XFILLER_47_69 VGND VGND VPWR VPWR sky130_fd_sc_hd__decap_3
XFILLER_63_13 VGND VGND VPWR VPWR sky130_fd_sc_hd__fill_2
X_083_ net59 net44 Inst_W_IO4_ConfigMem.Inst_frame0_bit9.Q VGND VGND VPWR VPWR _012_
+ sky130_fd_sc_hd__mux2_1
X_221_ net22 net62 VGND VGND VPWR VPWR Inst_W_IO4_ConfigMem.Inst_frame3_bit25.Q sky130_fd_sc_hd__dlxtp_1
X_152_ net103 net96 net1 net3 Inst_W_IO4_ConfigMem.Inst_frame1_bit16.Q Inst_W_IO4_ConfigMem.Inst_frame1_bit17.Q
+ VGND VGND VPWR VPWR Inst_W_IO4_switch_matrix.E6BEG2 sky130_fd_sc_hd__mux4_1
XFILLER_37_80 VGND VGND VPWR VPWR sky130_fd_sc_hd__fill_1
X_419_ FrameStrobe[11] VGND VGND VPWR VPWR net212 sky130_fd_sc_hd__clkbuf_1
XFILLER_17_28 VGND VGND VPWR VPWR sky130_fd_sc_hd__decap_3
XFILLER_58_13 VGND VGND VPWR VPWR sky130_fd_sc_hd__decap_3
XFILLER_74_56 VGND VGND VPWR VPWR sky130_fd_sc_hd__decap_3
X_204_ net35 net62 VGND VGND VPWR VPWR Inst_W_IO4_ConfigMem.Inst_frame3_bit8.Q sky130_fd_sc_hd__dlxtp_1
X_135_ net43 net45 net44 net46 Inst_W_IO4_ConfigMem.Inst_frame0_bit5.Q Inst_W_IO4_ConfigMem.Inst_frame0_bit4.Q
+ VGND VGND VPWR VPWR _057_ sky130_fd_sc_hd__mux4_1
X_066_ Inst_W_IO4_ConfigMem.Inst_frame0_bit24.Q VGND VGND VPWR VPWR _002_ sky130_fd_sc_hd__inv_1
XFILLER_0_20 VGND VGND VPWR VPWR sky130_fd_sc_hd__decap_3
XFILLER_0_53 VGND VGND VPWR VPWR sky130_fd_sc_hd__decap_3
XFILLER_0_75 VGND VGND VPWR VPWR sky130_fd_sc_hd__decap_3
XFILLER_69_23 VGND VGND VPWR VPWR sky130_fd_sc_hd__decap_3
XFILLER_79_7 VGND VGND VPWR VPWR sky130_fd_sc_hd__fill_1
X_118_ _037_ _039_ _042_ _005_ VGND VGND VPWR VPWR net124 sky130_fd_sc_hd__a22o_1
XFILLER_22_3 VGND VGND VPWR VPWR sky130_fd_sc_hd__fill_1
XFILLER_14_29 VGND VGND VPWR VPWR sky130_fd_sc_hd__fill_1
XFILLER_39_37 VGND VGND VPWR VPWR sky130_fd_sc_hd__decap_3
XPHY_EDGE_ROW_11_Left_100 VGND VGND VPWR VPWR sky130_fd_sc_hd__decap_3
XANTENNA_1 net135 VGND VGND VPWR VPWR sky130_fd_sc_hd__diode_2
XTAP_TAPCELL_ROW_68_247 VGND VPWR sky130_fd_sc_hd__tapvpwrvgnd_1
XFILLER_66_24 VGND VGND VPWR VPWR sky130_fd_sc_hd__decap_3
X_383_ net34 VGND VGND VPWR VPWR net207 sky130_fd_sc_hd__clkbuf_1
XTAP_TAPCELL_ROW_82_261 VGND VPWR sky130_fd_sc_hd__tapvpwrvgnd_1
Xoutput93 net112 VGND VGND VPWR VPWR B_I_top sky130_fd_sc_hd__buf_2
XFILLER_36_38 VGND VGND VPWR VPWR sky130_fd_sc_hd__fill_1
XFILLER_52_48 VGND VGND VPWR VPWR sky130_fd_sc_hd__fill_1
XFILLER_77_23 VGND VGND VPWR VPWR sky130_fd_sc_hd__decap_3
X_366_ Inst_W_IO4_switch_matrix.EE4BEG6 VGND VGND VPWR VPWR net174 sky130_fd_sc_hd__clkbuf_1
X_297_ net32 net74 VGND VGND VPWR VPWR Inst_W_IO4_ConfigMem.Inst_frame0_bit5.Q sky130_fd_sc_hd__dlxtp_1
XTAP_TAPCELL_ROW_38_217 VGND VPWR sky130_fd_sc_hd__tapvpwrvgnd_1
XFILLER_47_48 VGND VGND VPWR VPWR sky130_fd_sc_hd__decap_3
X_220_ net21 net62 VGND VGND VPWR VPWR Inst_W_IO4_ConfigMem.Inst_frame3_bit24.Q sky130_fd_sc_hd__dlxtp_1
XTAP_TAPCELL_ROW_52_231 VGND VPWR sky130_fd_sc_hd__tapvpwrvgnd_1
XFILLER_63_36 VGND VGND VPWR VPWR sky130_fd_sc_hd__decap_3
XFILLER_88_11 VGND VGND VPWR VPWR sky130_fd_sc_hd__fill_1
X_151_ net102 net95 Inst_A_IO_1_bidirectional_frame_config_pass.Q Inst_C_IO_1_bidirectional_frame_config_pass.Q
+ Inst_W_IO4_ConfigMem.Inst_frame1_bit18.Q Inst_W_IO4_ConfigMem.Inst_frame1_bit19.Q
+ VGND VGND VPWR VPWR Inst_W_IO4_switch_matrix.E6BEG3 sky130_fd_sc_hd__mux4_1
X_082_ net41 net1 net42 net3 Inst_W_IO4_ConfigMem.Inst_frame3_bit5.Q Inst_W_IO4_ConfigMem.Inst_frame3_bit4.Q
+ VGND VGND VPWR VPWR Inst_W_IO4_switch_matrix.E1BEG0 sky130_fd_sc_hd__mux4_1
XFILLER_88_66 VGND VGND VPWR VPWR sky130_fd_sc_hd__fill_1
X_418_ FrameStrobe[10] VGND VGND VPWR VPWR net211 sky130_fd_sc_hd__clkbuf_1
X_349_ Inst_W_IO4_switch_matrix.E6BEG1 VGND VGND VPWR VPWR net153 sky130_fd_sc_hd__clkbuf_1
XFILLER_33_17 VGND VGND VPWR VPWR sky130_fd_sc_hd__decap_3
XPHY_EDGE_ROW_49_Left_138 VGND VGND VPWR VPWR sky130_fd_sc_hd__decap_3
XPHY_EDGE_ROW_58_Left_147 VGND VGND VPWR VPWR sky130_fd_sc_hd__decap_3
XFILLER_58_25 VGND VGND VPWR VPWR sky130_fd_sc_hd__decap_3
X_203_ net34 net63 VGND VGND VPWR VPWR Inst_W_IO4_ConfigMem.Inst_frame3_bit7.Q sky130_fd_sc_hd__dlxtp_1
XPHY_EDGE_ROW_67_Left_156 VGND VGND VPWR VPWR sky130_fd_sc_hd__decap_3
X_134_ _051_ _053_ _056_ _009_ VGND VGND VPWR VPWR net112 sky130_fd_sc_hd__a22o_1
X_065_ Inst_W_IO4_ConfigMem.Inst_frame0_bit17.Q VGND VGND VPWR VPWR _001_ sky130_fd_sc_hd__inv_1
XPHY_EDGE_ROW_76_Left_165 VGND VGND VPWR VPWR sky130_fd_sc_hd__decap_3
XPHY_EDGE_ROW_85_Left_174 VGND VGND VPWR VPWR sky130_fd_sc_hd__decap_3
XFILLER_0_32 VGND VGND VPWR VPWR sky130_fd_sc_hd__decap_3
XFILLER_9_41 VGND VGND VPWR VPWR sky130_fd_sc_hd__decap_3
Xclkbuf_0_UserCLK UserCLK VGND VGND VPWR VPWR clknet_0_UserCLK sky130_fd_sc_hd__clkbuf_16
XTAP_TAPCELL_ROW_22_201 VGND VPWR sky130_fd_sc_hd__tapvpwrvgnd_1
XFILLER_44_27 VGND VGND VPWR VPWR sky130_fd_sc_hd__fill_1
XFILLER_44_49 VGND VGND VPWR VPWR sky130_fd_sc_hd__decap_3
XFILLER_69_13 VGND VGND VPWR VPWR sky130_fd_sc_hd__decap_3
XFILLER_69_79 VGND VGND VPWR VPWR sky130_fd_sc_hd__fill_2
XFILLER_85_78 VGND VGND VPWR VPWR sky130_fd_sc_hd__decap_3
X_117_ _040_ _041_ Inst_W_IO4_ConfigMem.Inst_frame0_bit27.Q VGND VGND VPWR VPWR _042_
+ sky130_fd_sc_hd__mux2_1
XFILLER_15_3 VGND VGND VPWR VPWR sky130_fd_sc_hd__fill_1
XFILLER_30_29 VGND VGND VPWR VPWR sky130_fd_sc_hd__fill_1
XFILLER_39_49 VGND VGND VPWR VPWR sky130_fd_sc_hd__decap_3
XFILLER_20_62 VGND VGND VPWR VPWR sky130_fd_sc_hd__fill_1
XFILLER_6_64 VGND VGND VPWR VPWR sky130_fd_sc_hd__decap_3
XANTENNA_2 net172 VGND VGND VPWR VPWR sky130_fd_sc_hd__diode_2
XFILLER_82_68 VGND VGND VPWR VPWR sky130_fd_sc_hd__decap_3
XFILLER_82_46 VGND VGND VPWR VPWR sky130_fd_sc_hd__decap_3
XFILLER_15_40 VGND VGND VPWR VPWR sky130_fd_sc_hd__decap_3
X_382_ net33 VGND VGND VPWR VPWR net206 sky130_fd_sc_hd__clkbuf_1
Xoutput94 net113 VGND VGND VPWR VPWR B_T_top sky130_fd_sc_hd__buf_2
XPHY_EDGE_ROW_30_Left_119 VGND VGND VPWR VPWR sky130_fd_sc_hd__decap_3
XFILLER_77_57 VGND VGND VPWR VPWR sky130_fd_sc_hd__decap_3
X_296_ net31 net74 VGND VGND VPWR VPWR Inst_W_IO4_ConfigMem.Inst_frame0_bit4.Q sky130_fd_sc_hd__dlxtp_1
X_365_ Inst_W_IO4_switch_matrix.EE4BEG5 VGND VGND VPWR VPWR net173 sky130_fd_sc_hd__buf_1
XFILLER_54_7 VGND VGND VPWR VPWR sky130_fd_sc_hd__decap_3
XFILLER_3_21 VGND VGND VPWR VPWR sky130_fd_sc_hd__decap_3
XFILLER_22_19 VGND VGND VPWR VPWR sky130_fd_sc_hd__decap_3
XFILLER_47_27 VGND VGND VPWR VPWR sky130_fd_sc_hd__fill_2
XFILLER_63_48 VGND VGND VPWR VPWR sky130_fd_sc_hd__decap_3
X_150_ net41 net1 net99 net3 Inst_W_IO4_ConfigMem.Inst_frame1_bit21.Q Inst_W_IO4_ConfigMem.Inst_frame1_bit20.Q
+ VGND VGND VPWR VPWR Inst_W_IO4_switch_matrix.E6BEG4 sky130_fd_sc_hd__mux4_1
X_081_ net40 net41 Inst_A_IO_1_bidirectional_frame_config_pass.Q Inst_C_IO_1_bidirectional_frame_config_pass.Q
+ Inst_W_IO4_ConfigMem.Inst_frame3_bit6.Q Inst_W_IO4_ConfigMem.Inst_frame3_bit7.Q
+ VGND VGND VPWR VPWR Inst_W_IO4_switch_matrix.E1BEG1 sky130_fd_sc_hd__mux4_1
XPHY_EDGE_ROW_16_Right_16 VGND VGND VPWR VPWR sky130_fd_sc_hd__decap_3
X_279_ net15 net71 VGND VGND VPWR VPWR Inst_W_IO4_ConfigMem.Inst_frame1_bit19.Q sky130_fd_sc_hd__dlxtp_1
X_417_ FrameStrobe[9] VGND VGND VPWR VPWR net229 sky130_fd_sc_hd__clkbuf_1
XPHY_EDGE_ROW_25_Right_25 VGND VGND VPWR VPWR sky130_fd_sc_hd__decap_3
X_348_ Inst_W_IO4_switch_matrix.E6BEG0 VGND VGND VPWR VPWR net150 sky130_fd_sc_hd__buf_1
XFILLER_45_3 VGND VGND VPWR VPWR sky130_fd_sc_hd__fill_2
XPHY_EDGE_ROW_34_Right_34 VGND VGND VPWR VPWR sky130_fd_sc_hd__decap_3
XPHY_EDGE_ROW_43_Right_43 VGND VGND VPWR VPWR sky130_fd_sc_hd__decap_3
XPHY_EDGE_ROW_52_Right_52 VGND VGND VPWR VPWR sky130_fd_sc_hd__decap_3
X_133_ _054_ _055_ Inst_W_IO4_ConfigMem.Inst_frame0_bit13.Q VGND VGND VPWR VPWR _056_
+ sky130_fd_sc_hd__mux2_1
XPHY_EDGE_ROW_61_Right_61 VGND VGND VPWR VPWR sky130_fd_sc_hd__decap_3
X_202_ net33 net63 VGND VGND VPWR VPWR Inst_W_IO4_ConfigMem.Inst_frame3_bit6.Q sky130_fd_sc_hd__dlxtp_1
X_064_ Inst_W_IO4_ConfigMem.Inst_frame0_bit10.Q VGND VGND VPWR VPWR _000_ sky130_fd_sc_hd__inv_1
XPHY_EDGE_ROW_70_Right_70 VGND VGND VPWR VPWR sky130_fd_sc_hd__decap_3
XFILLER_17_7 VGND VGND VPWR VPWR sky130_fd_sc_hd__decap_3
XFILLER_0_11 VGND VGND VPWR VPWR sky130_fd_sc_hd__decap_3
XFILLER_0_44 VGND VGND VPWR VPWR sky130_fd_sc_hd__decap_3
XFILLER_9_53 VGND VGND VPWR VPWR sky130_fd_sc_hd__decap_3
XFILLER_9_20 VGND VGND VPWR VPWR sky130_fd_sc_hd__decap_3
XFILLER_0_66 VGND VGND VPWR VPWR sky130_fd_sc_hd__decap_3
XFILLER_60_27 VGND VGND VPWR VPWR sky130_fd_sc_hd__fill_1
XFILLER_85_68 VGND VGND VPWR VPWR sky130_fd_sc_hd__fill_2
XFILLER_34_50 VGND VGND VPWR VPWR sky130_fd_sc_hd__decap_3
X_116_ net55 net57 net56 net59 Inst_W_IO4_ConfigMem.Inst_frame0_bit26.Q Inst_W_IO4_ConfigMem.Inst_frame0_bit25.Q
+ VGND VGND VPWR VPWR _041_ sky130_fd_sc_hd__mux4_1
XPHY_EDGE_ROW_2_Right_2 VGND VGND VPWR VPWR sky130_fd_sc_hd__decap_3
XFILLER_39_17 VGND VGND VPWR VPWR sky130_fd_sc_hd__decap_3
XFILLER_20_41 VGND VGND VPWR VPWR sky130_fd_sc_hd__decap_3
XFILLER_45_71 VGND VGND VPWR VPWR sky130_fd_sc_hd__fill_2
XFILLER_6_76 VGND VGND VPWR VPWR sky130_fd_sc_hd__decap_3
XANTENNA_3 net179 VGND VGND VPWR VPWR sky130_fd_sc_hd__diode_2
XFILLER_41_29 VGND VGND VPWR VPWR sky130_fd_sc_hd__fill_1
XTAP_TAPCELL_ROW_59_238 VGND VPWR sky130_fd_sc_hd__tapvpwrvgnd_1
XFILLER_15_52 VGND VGND VPWR VPWR sky130_fd_sc_hd__fill_1
X_381_ net32 VGND VGND VPWR VPWR net205 sky130_fd_sc_hd__buf_1
XFILLER_31_51 VGND VGND VPWR VPWR sky130_fd_sc_hd__fill_2
Xoutput95 net114 VGND VGND VPWR VPWR B_config_C_bit0 sky130_fd_sc_hd__buf_2
XTAP_TAPCELL_ROW_73_252 VGND VPWR sky130_fd_sc_hd__tapvpwrvgnd_1
XFILLER_72_80 VGND VGND VPWR VPWR sky130_fd_sc_hd__fill_1
XFILLER_36_29 VGND VGND VPWR VPWR sky130_fd_sc_hd__decap_3
X_364_ Inst_W_IO4_switch_matrix.EE4BEG4 VGND VGND VPWR VPWR net172 sky130_fd_sc_hd__buf_1
X_295_ net30 net37 VGND VGND VPWR VPWR Inst_W_IO4_ConfigMem.Inst_frame0_bit3.Q sky130_fd_sc_hd__dlxtp_1
XFILLER_3_55 VGND VGND VPWR VPWR sky130_fd_sc_hd__fill_1
XTAP_TAPCELL_ROW_14_193 VGND VPWR sky130_fd_sc_hd__tapvpwrvgnd_1
XTAP_TAPCELL_ROW_29_208 VGND VPWR sky130_fd_sc_hd__tapvpwrvgnd_1
X_080_ net39 net40 net2 net4 Inst_W_IO4_ConfigMem.Inst_frame3_bit8.Q Inst_W_IO4_ConfigMem.Inst_frame3_bit9.Q
+ VGND VGND VPWR VPWR Inst_W_IO4_switch_matrix.E1BEG2 sky130_fd_sc_hd__mux4_1
XFILLER_88_46 VGND VGND VPWR VPWR sky130_fd_sc_hd__fill_1
X_416_ FrameStrobe[8] VGND VGND VPWR VPWR net228 sky130_fd_sc_hd__clkbuf_1
XTAP_TAPCELL_ROW_43_222 VGND VPWR sky130_fd_sc_hd__tapvpwrvgnd_1
X_278_ net14 net71 VGND VGND VPWR VPWR Inst_W_IO4_ConfigMem.Inst_frame1_bit18.Q sky130_fd_sc_hd__dlxtp_1
X_347_ Inst_W_IO4_switch_matrix.E2BEGb7 VGND VGND VPWR VPWR net149 sky130_fd_sc_hd__clkbuf_1
XFILLER_38_3 VGND VGND VPWR VPWR sky130_fd_sc_hd__decap_3
XFILLER_58_16 VGND VGND VPWR VPWR sky130_fd_sc_hd__decap_3
XFILLER_74_26 VGND VGND VPWR VPWR sky130_fd_sc_hd__fill_2
XFILLER_74_59 VGND VGND VPWR VPWR sky130_fd_sc_hd__decap_3
X_132_ net55 net57 net56 net59 Inst_W_IO4_ConfigMem.Inst_frame0_bit12.Q Inst_W_IO4_ConfigMem.Inst_frame0_bit11.Q
+ VGND VGND VPWR VPWR _055_ sky130_fd_sc_hd__mux4_1
X_201_ net32 net61 VGND VGND VPWR VPWR Inst_W_IO4_ConfigMem.Inst_frame3_bit5.Q sky130_fd_sc_hd__dlxtp_1
XFILLER_0_23 VGND VGND VPWR VPWR sky130_fd_sc_hd__decap_3
XFILLER_0_78 VGND VGND VPWR VPWR sky130_fd_sc_hd__decap_3
XFILLER_48_71 VGND VGND VPWR VPWR sky130_fd_sc_hd__fill_2
XFILLER_9_32 VGND VGND VPWR VPWR sky130_fd_sc_hd__decap_3
XFILLER_80_80 VGND VGND VPWR VPWR sky130_fd_sc_hd__fill_1
XFILLER_44_18 VGND VGND VPWR VPWR sky130_fd_sc_hd__decap_3
XFILLER_44_29 VGND VGND VPWR VPWR sky130_fd_sc_hd__decap_3
XFILLER_69_26 VGND VGND VPWR VPWR sky130_fd_sc_hd__fill_1
XFILLER_18_52 VGND VGND VPWR VPWR sky130_fd_sc_hd__fill_1
X_115_ net51 net52 net53 net54 Inst_W_IO4_ConfigMem.Inst_frame0_bit25.Q Inst_W_IO4_ConfigMem.Inst_frame0_bit26.Q
+ VGND VGND VPWR VPWR _040_ sky130_fd_sc_hd__mux4_1
XFILLER_6_11 VGND VGND VPWR VPWR sky130_fd_sc_hd__decap_3
XANTENNA_4 net196 VGND VGND VPWR VPWR sky130_fd_sc_hd__diode_2
XFILLER_66_27 VGND VGND VPWR VPWR sky130_fd_sc_hd__fill_1
XFILLER_82_26 VGND VGND VPWR VPWR sky130_fd_sc_hd__fill_2
XFILLER_82_59 VGND VGND VPWR VPWR sky130_fd_sc_hd__decap_3
XFILLER_15_31 VGND VGND VPWR VPWR sky130_fd_sc_hd__decap_3
X_380_ net31 VGND VGND VPWR VPWR net204 sky130_fd_sc_hd__clkbuf_2
Xoutput96 net115 VGND VGND VPWR VPWR B_config_C_bit1 sky130_fd_sc_hd__buf_2
.ends
