* NGSPICE file created from OpenRAM.ext - technology: sky130A

* Black-box entry subcircuit for sky130_fd_sc_hd__decap_3 abstract view
.subckt sky130_fd_sc_hd__decap_3 VGND VNB VPB VPWR
.ends

* Black-box entry subcircuit for sky130_fd_sc_hd__mux4_1 abstract view
.subckt sky130_fd_sc_hd__mux4_1 A0 A1 A2 A3 S0 S1 VGND VNB VPB VPWR X
.ends

* Black-box entry subcircuit for sky130_fd_sc_hd__a31o_1 abstract view
.subckt sky130_fd_sc_hd__a31o_1 A1 A2 A3 B1 VGND VNB VPB VPWR X
.ends

* Black-box entry subcircuit for sky130_fd_sc_hd__fill_1 abstract view
.subckt sky130_fd_sc_hd__fill_1 VGND VNB VPB VPWR
.ends

* Black-box entry subcircuit for sky130_fd_sc_hd__fill_2 abstract view
.subckt sky130_fd_sc_hd__fill_2 VGND VNB VPB VPWR
.ends

* Black-box entry subcircuit for sky130_fd_sc_hd__clkbuf_2 abstract view
.subckt sky130_fd_sc_hd__clkbuf_2 A VGND VNB VPB VPWR X
.ends

* Black-box entry subcircuit for sky130_fd_sc_hd__dlxtp_1 abstract view
.subckt sky130_fd_sc_hd__dlxtp_1 D GATE VGND VNB VPB VPWR Q
.ends

* Black-box entry subcircuit for sky130_fd_sc_hd__buf_2 abstract view
.subckt sky130_fd_sc_hd__buf_2 A VGND VNB VPB VPWR X
.ends

* Black-box entry subcircuit for sky130_fd_sc_hd__buf_4 abstract view
.subckt sky130_fd_sc_hd__buf_4 A VGND VNB VPB VPWR X
.ends

* Black-box entry subcircuit for sky130_fd_sc_hd__tapvpwrvgnd_1 abstract view
.subckt sky130_fd_sc_hd__tapvpwrvgnd_1 VGND VPWR
.ends

* Black-box entry subcircuit for sky130_fd_sc_hd__mux2_1 abstract view
.subckt sky130_fd_sc_hd__mux2_1 A0 A1 S VGND VNB VPB VPWR X
.ends

* Black-box entry subcircuit for sky130_fd_sc_hd__clkbuf_1 abstract view
.subckt sky130_fd_sc_hd__clkbuf_1 A VGND VNB VPB VPWR X
.ends

* Black-box entry subcircuit for sky130_fd_sc_hd__a21bo_1 abstract view
.subckt sky130_fd_sc_hd__a21bo_1 A1 A2 B1_N VGND VNB VPB VPWR X
.ends

* Black-box entry subcircuit for sky130_fd_sc_hd__o21a_1 abstract view
.subckt sky130_fd_sc_hd__o21a_1 A1 A2 B1 VGND VNB VPB VPWR X
.ends

* Black-box entry subcircuit for sky130_fd_sc_hd__nand2_1 abstract view
.subckt sky130_fd_sc_hd__nand2_1 A B VGND VNB VPB VPWR Y
.ends

* Black-box entry subcircuit for sky130_fd_sc_hd__clkbuf_4 abstract view
.subckt sky130_fd_sc_hd__clkbuf_4 A VGND VNB VPB VPWR X
.ends

* Black-box entry subcircuit for sky130_fd_sc_hd__buf_1 abstract view
.subckt sky130_fd_sc_hd__buf_1 A VGND VNB VPB VPWR X
.ends

* Black-box entry subcircuit for sky130_fd_sc_hd__mux4_2 abstract view
.subckt sky130_fd_sc_hd__mux4_2 A0 A1 A2 A3 S0 S1 VGND VNB VPB VPWR X
.ends

* Black-box entry subcircuit for sky130_fd_sc_hd__o21ba_1 abstract view
.subckt sky130_fd_sc_hd__o21ba_1 A1 A2 B1_N VGND VNB VPB VPWR X
.ends

* Black-box entry subcircuit for sky130_fd_sc_hd__buf_6 abstract view
.subckt sky130_fd_sc_hd__buf_6 A VGND VNB VPB VPWR X
.ends

* Black-box entry subcircuit for sky130_fd_sc_hd__or3b_1 abstract view
.subckt sky130_fd_sc_hd__or3b_1 A B C_N VGND VNB VPB VPWR X
.ends

* Black-box entry subcircuit for sky130_fd_sc_hd__nor2_1 abstract view
.subckt sky130_fd_sc_hd__nor2_1 A B VGND VNB VPB VPWR Y
.ends

* Black-box entry subcircuit for sky130_fd_sc_hd__and2b_1 abstract view
.subckt sky130_fd_sc_hd__and2b_1 A_N B VGND VNB VPB VPWR X
.ends

* Black-box entry subcircuit for sky130_fd_sc_hd__a2bb2o_1 abstract view
.subckt sky130_fd_sc_hd__a2bb2o_1 A1_N A2_N B1 B2 VGND VNB VPB VPWR X
.ends

* Black-box entry subcircuit for sky130_fd_sc_hd__dlymetal6s2s_1 abstract view
.subckt sky130_fd_sc_hd__dlymetal6s2s_1 A VGND VNB VPB VPWR X
.ends

* Black-box entry subcircuit for sky130_fd_sc_hd__a22o_1 abstract view
.subckt sky130_fd_sc_hd__a22o_1 A1 A2 B1 B2 VGND VNB VPB VPWR X
.ends

* Black-box entry subcircuit for sky130_fd_sc_hd__o22a_1 abstract view
.subckt sky130_fd_sc_hd__o22a_1 A1 A2 B1 B2 VGND VNB VPB VPWR X
.ends

* Black-box entry subcircuit for sky130_fd_sc_hd__a221o_1 abstract view
.subckt sky130_fd_sc_hd__a221o_1 A1 A2 B1 B2 C1 VGND VNB VPB VPWR X
.ends

* Black-box entry subcircuit for sky130_fd_sc_hd__a211o_1 abstract view
.subckt sky130_fd_sc_hd__a211o_1 A1 A2 B1 C1 VGND VNB VPB VPWR X
.ends

* Black-box entry subcircuit for sky130_fd_sc_hd__a21o_1 abstract view
.subckt sky130_fd_sc_hd__a21o_1 A1 A2 B1 VGND VNB VPB VPWR X
.ends

* Black-box entry subcircuit for sky130_fd_sc_hd__or3b_2 abstract view
.subckt sky130_fd_sc_hd__or3b_2 A B C_N VGND VNB VPB VPWR X
.ends

* Black-box entry subcircuit for sky130_fd_sc_hd__a31o_2 abstract view
.subckt sky130_fd_sc_hd__a31o_2 A1 A2 A3 B1 VGND VNB VPB VPWR X
.ends

* Black-box entry subcircuit for sky130_fd_sc_hd__a21oi_1 abstract view
.subckt sky130_fd_sc_hd__a21oi_1 A1 A2 B1 VGND VNB VPB VPWR Y
.ends

* Black-box entry subcircuit for sky130_fd_sc_hd__inv_2 abstract view
.subckt sky130_fd_sc_hd__inv_2 A VGND VNB VPB VPWR Y
.ends

* Black-box entry subcircuit for sky130_fd_sc_hd__clkbuf_16 abstract view
.subckt sky130_fd_sc_hd__clkbuf_16 A VGND VNB VPB VPWR X
.ends

* Black-box entry subcircuit for sky130_fd_sc_hd__and3b_1 abstract view
.subckt sky130_fd_sc_hd__and3b_1 A_N B C VGND VNB VPB VPWR X
.ends

* Black-box entry subcircuit for sky130_fd_sc_hd__a2bb2o_2 abstract view
.subckt sky130_fd_sc_hd__a2bb2o_2 A1_N A2_N B1 B2 VGND VNB VPB VPWR X
.ends

* Black-box entry subcircuit for sky130_fd_sc_hd__o211a_1 abstract view
.subckt sky130_fd_sc_hd__o211a_1 A1 A2 B1 C1 VGND VNB VPB VPWR X
.ends

* Black-box entry subcircuit for sky130_fd_sc_hd__inv_1 abstract view
.subckt sky130_fd_sc_hd__inv_1 A VGND VNB VPB VPWR Y
.ends

* Black-box entry subcircuit for sky130_fd_sc_hd__or2_1 abstract view
.subckt sky130_fd_sc_hd__or2_1 A B VGND VNB VPB VPWR X
.ends

* Black-box entry subcircuit for sky130_fd_sc_hd__nand2b_1 abstract view
.subckt sky130_fd_sc_hd__nand2b_1 A_N B VGND VNB VPB VPWR Y
.ends

* Black-box entry subcircuit for sky130_fd_sc_hd__o311a_1 abstract view
.subckt sky130_fd_sc_hd__o311a_1 A1 A2 A3 B1 C1 VGND VNB VPB VPWR X
.ends

* Black-box entry subcircuit for sky130_fd_sc_hd__o21ai_1 abstract view
.subckt sky130_fd_sc_hd__o21ai_1 A1 A2 B1 VGND VNB VPB VPWR Y
.ends

* Black-box entry subcircuit for sky130_fd_sc_hd__o31ai_1 abstract view
.subckt sky130_fd_sc_hd__o31ai_1 A1 A2 A3 B1 VGND VNB VPB VPWR Y
.ends

.subckt OpenRAM ADDR_A_SRAM0 ADDR_A_SRAM1 ADDR_A_SRAM2 ADDR_A_SRAM3 ADDR_A_SRAM4 ADDR_A_SRAM5
+ ADDR_A_SRAM6 ADDR_A_SRAM7 ADDR_B_SRAM0 ADDR_B_SRAM1 ADDR_B_SRAM2 ADDR_B_SRAM3 ADDR_B_SRAM4
+ ADDR_B_SRAM5 ADDR_B_SRAM6 ADDR_B_SRAM7 CLK_A_SRAM CLK_B_SRAM CONFIGURED_top CSB_A_SRAM
+ CSB_B_SRAM DIN_A_SRAM0 DIN_A_SRAM1 DIN_A_SRAM10 DIN_A_SRAM11 DIN_A_SRAM12 DIN_A_SRAM13
+ DIN_A_SRAM14 DIN_A_SRAM15 DIN_A_SRAM16 DIN_A_SRAM17 DIN_A_SRAM18 DIN_A_SRAM19 DIN_A_SRAM2
+ DIN_A_SRAM20 DIN_A_SRAM21 DIN_A_SRAM22 DIN_A_SRAM23 DIN_A_SRAM24 DIN_A_SRAM25 DIN_A_SRAM26
+ DIN_A_SRAM27 DIN_A_SRAM28 DIN_A_SRAM29 DIN_A_SRAM3 DIN_A_SRAM30 DIN_A_SRAM31 DIN_A_SRAM4
+ DIN_A_SRAM5 DIN_A_SRAM6 DIN_A_SRAM7 DIN_A_SRAM8 DIN_A_SRAM9 DOUT_A_SRAM0 DOUT_A_SRAM1
+ DOUT_A_SRAM10 DOUT_A_SRAM11 DOUT_A_SRAM12 DOUT_A_SRAM13 DOUT_A_SRAM14 DOUT_A_SRAM15
+ DOUT_A_SRAM16 DOUT_A_SRAM17 DOUT_A_SRAM18 DOUT_A_SRAM19 DOUT_A_SRAM2 DOUT_A_SRAM20
+ DOUT_A_SRAM21 DOUT_A_SRAM22 DOUT_A_SRAM23 DOUT_A_SRAM24 DOUT_A_SRAM25 DOUT_A_SRAM26
+ DOUT_A_SRAM27 DOUT_A_SRAM28 DOUT_A_SRAM29 DOUT_A_SRAM3 DOUT_A_SRAM30 DOUT_A_SRAM31
+ DOUT_A_SRAM4 DOUT_A_SRAM5 DOUT_A_SRAM6 DOUT_A_SRAM7 DOUT_A_SRAM8 DOUT_A_SRAM9 DOUT_B_SRAM0
+ DOUT_B_SRAM1 DOUT_B_SRAM10 DOUT_B_SRAM11 DOUT_B_SRAM12 DOUT_B_SRAM13 DOUT_B_SRAM14
+ DOUT_B_SRAM15 DOUT_B_SRAM16 DOUT_B_SRAM17 DOUT_B_SRAM18 DOUT_B_SRAM19 DOUT_B_SRAM2
+ DOUT_B_SRAM20 DOUT_B_SRAM21 DOUT_B_SRAM22 DOUT_B_SRAM23 DOUT_B_SRAM24 DOUT_B_SRAM25
+ DOUT_B_SRAM26 DOUT_B_SRAM27 DOUT_B_SRAM28 DOUT_B_SRAM29 DOUT_B_SRAM3 DOUT_B_SRAM30
+ DOUT_B_SRAM31 DOUT_B_SRAM4 DOUT_B_SRAM5 DOUT_B_SRAM6 DOUT_B_SRAM7 DOUT_B_SRAM8 DOUT_B_SRAM9
+ Tile_X0Y0_E1END[0] Tile_X0Y0_E1END[1] Tile_X0Y0_E1END[2] Tile_X0Y0_E1END[3] Tile_X0Y0_E2END[0]
+ Tile_X0Y0_E2END[1] Tile_X0Y0_E2END[2] Tile_X0Y0_E2END[3] Tile_X0Y0_E2END[4] Tile_X0Y0_E2END[5]
+ Tile_X0Y0_E2END[6] Tile_X0Y0_E2END[7] Tile_X0Y0_E2MID[0] Tile_X0Y0_E2MID[1] Tile_X0Y0_E2MID[2]
+ Tile_X0Y0_E2MID[3] Tile_X0Y0_E2MID[4] Tile_X0Y0_E2MID[5] Tile_X0Y0_E2MID[6] Tile_X0Y0_E2MID[7]
+ Tile_X0Y0_E6END[0] Tile_X0Y0_E6END[10] Tile_X0Y0_E6END[11] Tile_X0Y0_E6END[1] Tile_X0Y0_E6END[2]
+ Tile_X0Y0_E6END[3] Tile_X0Y0_E6END[4] Tile_X0Y0_E6END[5] Tile_X0Y0_E6END[6] Tile_X0Y0_E6END[7]
+ Tile_X0Y0_E6END[8] Tile_X0Y0_E6END[9] Tile_X0Y0_EE4END[0] Tile_X0Y0_EE4END[10] Tile_X0Y0_EE4END[11]
+ Tile_X0Y0_EE4END[12] Tile_X0Y0_EE4END[13] Tile_X0Y0_EE4END[14] Tile_X0Y0_EE4END[15]
+ Tile_X0Y0_EE4END[1] Tile_X0Y0_EE4END[2] Tile_X0Y0_EE4END[3] Tile_X0Y0_EE4END[4]
+ Tile_X0Y0_EE4END[5] Tile_X0Y0_EE4END[6] Tile_X0Y0_EE4END[7] Tile_X0Y0_EE4END[8]
+ Tile_X0Y0_EE4END[9] Tile_X0Y0_FrameData[0] Tile_X0Y0_FrameData[10] Tile_X0Y0_FrameData[11]
+ Tile_X0Y0_FrameData[12] Tile_X0Y0_FrameData[13] Tile_X0Y0_FrameData[14] Tile_X0Y0_FrameData[15]
+ Tile_X0Y0_FrameData[16] Tile_X0Y0_FrameData[17] Tile_X0Y0_FrameData[18] Tile_X0Y0_FrameData[19]
+ Tile_X0Y0_FrameData[1] Tile_X0Y0_FrameData[20] Tile_X0Y0_FrameData[21] Tile_X0Y0_FrameData[22]
+ Tile_X0Y0_FrameData[23] Tile_X0Y0_FrameData[24] Tile_X0Y0_FrameData[25] Tile_X0Y0_FrameData[26]
+ Tile_X0Y0_FrameData[27] Tile_X0Y0_FrameData[28] Tile_X0Y0_FrameData[29] Tile_X0Y0_FrameData[2]
+ Tile_X0Y0_FrameData[30] Tile_X0Y0_FrameData[31] Tile_X0Y0_FrameData[3] Tile_X0Y0_FrameData[4]
+ Tile_X0Y0_FrameData[5] Tile_X0Y0_FrameData[6] Tile_X0Y0_FrameData[7] Tile_X0Y0_FrameData[8]
+ Tile_X0Y0_FrameData[9] Tile_X0Y0_FrameData_O[0] Tile_X0Y0_FrameData_O[10] Tile_X0Y0_FrameData_O[11]
+ Tile_X0Y0_FrameData_O[12] Tile_X0Y0_FrameData_O[13] Tile_X0Y0_FrameData_O[14] Tile_X0Y0_FrameData_O[15]
+ Tile_X0Y0_FrameData_O[16] Tile_X0Y0_FrameData_O[17] Tile_X0Y0_FrameData_O[18] Tile_X0Y0_FrameData_O[19]
+ Tile_X0Y0_FrameData_O[1] Tile_X0Y0_FrameData_O[20] Tile_X0Y0_FrameData_O[21] Tile_X0Y0_FrameData_O[22]
+ Tile_X0Y0_FrameData_O[23] Tile_X0Y0_FrameData_O[24] Tile_X0Y0_FrameData_O[25] Tile_X0Y0_FrameData_O[26]
+ Tile_X0Y0_FrameData_O[27] Tile_X0Y0_FrameData_O[28] Tile_X0Y0_FrameData_O[29] Tile_X0Y0_FrameData_O[2]
+ Tile_X0Y0_FrameData_O[30] Tile_X0Y0_FrameData_O[31] Tile_X0Y0_FrameData_O[3] Tile_X0Y0_FrameData_O[4]
+ Tile_X0Y0_FrameData_O[5] Tile_X0Y0_FrameData_O[6] Tile_X0Y0_FrameData_O[7] Tile_X0Y0_FrameData_O[8]
+ Tile_X0Y0_FrameData_O[9] Tile_X0Y0_FrameStrobe_O[0] Tile_X0Y0_FrameStrobe_O[10]
+ Tile_X0Y0_FrameStrobe_O[11] Tile_X0Y0_FrameStrobe_O[12] Tile_X0Y0_FrameStrobe_O[13]
+ Tile_X0Y0_FrameStrobe_O[14] Tile_X0Y0_FrameStrobe_O[15] Tile_X0Y0_FrameStrobe_O[16]
+ Tile_X0Y0_FrameStrobe_O[17] Tile_X0Y0_FrameStrobe_O[18] Tile_X0Y0_FrameStrobe_O[19]
+ Tile_X0Y0_FrameStrobe_O[1] Tile_X0Y0_FrameStrobe_O[2] Tile_X0Y0_FrameStrobe_O[3]
+ Tile_X0Y0_FrameStrobe_O[4] Tile_X0Y0_FrameStrobe_O[5] Tile_X0Y0_FrameStrobe_O[6]
+ Tile_X0Y0_FrameStrobe_O[7] Tile_X0Y0_FrameStrobe_O[8] Tile_X0Y0_FrameStrobe_O[9]
+ Tile_X0Y0_N1BEG[0] Tile_X0Y0_N1BEG[1] Tile_X0Y0_N1BEG[2] Tile_X0Y0_N1BEG[3] Tile_X0Y0_N2BEG[0]
+ Tile_X0Y0_N2BEG[1] Tile_X0Y0_N2BEG[2] Tile_X0Y0_N2BEG[3] Tile_X0Y0_N2BEG[4] Tile_X0Y0_N2BEG[5]
+ Tile_X0Y0_N2BEG[6] Tile_X0Y0_N2BEG[7] Tile_X0Y0_N2BEGb[0] Tile_X0Y0_N2BEGb[1] Tile_X0Y0_N2BEGb[2]
+ Tile_X0Y0_N2BEGb[3] Tile_X0Y0_N2BEGb[4] Tile_X0Y0_N2BEGb[5] Tile_X0Y0_N2BEGb[6]
+ Tile_X0Y0_N2BEGb[7] Tile_X0Y0_N4BEG[0] Tile_X0Y0_N4BEG[10] Tile_X0Y0_N4BEG[11] Tile_X0Y0_N4BEG[12]
+ Tile_X0Y0_N4BEG[13] Tile_X0Y0_N4BEG[14] Tile_X0Y0_N4BEG[15] Tile_X0Y0_N4BEG[1] Tile_X0Y0_N4BEG[2]
+ Tile_X0Y0_N4BEG[3] Tile_X0Y0_N4BEG[4] Tile_X0Y0_N4BEG[5] Tile_X0Y0_N4BEG[6] Tile_X0Y0_N4BEG[7]
+ Tile_X0Y0_N4BEG[8] Tile_X0Y0_N4BEG[9] Tile_X0Y0_S1END[0] Tile_X0Y0_S1END[1] Tile_X0Y0_S1END[2]
+ Tile_X0Y0_S1END[3] Tile_X0Y0_S2END[0] Tile_X0Y0_S2END[1] Tile_X0Y0_S2END[2] Tile_X0Y0_S2END[3]
+ Tile_X0Y0_S2END[4] Tile_X0Y0_S2END[5] Tile_X0Y0_S2END[6] Tile_X0Y0_S2END[7] Tile_X0Y0_S2MID[0]
+ Tile_X0Y0_S2MID[1] Tile_X0Y0_S2MID[2] Tile_X0Y0_S2MID[3] Tile_X0Y0_S2MID[4] Tile_X0Y0_S2MID[5]
+ Tile_X0Y0_S2MID[6] Tile_X0Y0_S2MID[7] Tile_X0Y0_S4END[0] Tile_X0Y0_S4END[10] Tile_X0Y0_S4END[11]
+ Tile_X0Y0_S4END[12] Tile_X0Y0_S4END[13] Tile_X0Y0_S4END[14] Tile_X0Y0_S4END[15]
+ Tile_X0Y0_S4END[1] Tile_X0Y0_S4END[2] Tile_X0Y0_S4END[3] Tile_X0Y0_S4END[4] Tile_X0Y0_S4END[5]
+ Tile_X0Y0_S4END[6] Tile_X0Y0_S4END[7] Tile_X0Y0_S4END[8] Tile_X0Y0_S4END[9] Tile_X0Y0_UserCLKo
+ Tile_X0Y0_W1BEG[0] Tile_X0Y0_W1BEG[1] Tile_X0Y0_W1BEG[2] Tile_X0Y0_W1BEG[3] Tile_X0Y0_W2BEG[0]
+ Tile_X0Y0_W2BEG[1] Tile_X0Y0_W2BEG[2] Tile_X0Y0_W2BEG[3] Tile_X0Y0_W2BEG[4] Tile_X0Y0_W2BEG[5]
+ Tile_X0Y0_W2BEG[6] Tile_X0Y0_W2BEG[7] Tile_X0Y0_W2BEGb[0] Tile_X0Y0_W2BEGb[1] Tile_X0Y0_W2BEGb[2]
+ Tile_X0Y0_W2BEGb[3] Tile_X0Y0_W2BEGb[4] Tile_X0Y0_W2BEGb[5] Tile_X0Y0_W2BEGb[6]
+ Tile_X0Y0_W2BEGb[7] Tile_X0Y0_W6BEG[0] Tile_X0Y0_W6BEG[10] Tile_X0Y0_W6BEG[11] Tile_X0Y0_W6BEG[1]
+ Tile_X0Y0_W6BEG[2] Tile_X0Y0_W6BEG[3] Tile_X0Y0_W6BEG[4] Tile_X0Y0_W6BEG[5] Tile_X0Y0_W6BEG[6]
+ Tile_X0Y0_W6BEG[7] Tile_X0Y0_W6BEG[8] Tile_X0Y0_W6BEG[9] Tile_X0Y0_WW4BEG[0] Tile_X0Y0_WW4BEG[10]
+ Tile_X0Y0_WW4BEG[11] Tile_X0Y0_WW4BEG[12] Tile_X0Y0_WW4BEG[13] Tile_X0Y0_WW4BEG[14]
+ Tile_X0Y0_WW4BEG[15] Tile_X0Y0_WW4BEG[1] Tile_X0Y0_WW4BEG[2] Tile_X0Y0_WW4BEG[3]
+ Tile_X0Y0_WW4BEG[4] Tile_X0Y0_WW4BEG[5] Tile_X0Y0_WW4BEG[6] Tile_X0Y0_WW4BEG[7]
+ Tile_X0Y0_WW4BEG[8] Tile_X0Y0_WW4BEG[9] Tile_X0Y1_E1END[0] Tile_X0Y1_E1END[1] Tile_X0Y1_E1END[2]
+ Tile_X0Y1_E1END[3] Tile_X0Y1_E2END[0] Tile_X0Y1_E2END[1] Tile_X0Y1_E2END[2] Tile_X0Y1_E2END[3]
+ Tile_X0Y1_E2END[4] Tile_X0Y1_E2END[5] Tile_X0Y1_E2END[6] Tile_X0Y1_E2END[7] Tile_X0Y1_E2MID[0]
+ Tile_X0Y1_E2MID[1] Tile_X0Y1_E2MID[2] Tile_X0Y1_E2MID[3] Tile_X0Y1_E2MID[4] Tile_X0Y1_E2MID[5]
+ Tile_X0Y1_E2MID[6] Tile_X0Y1_E2MID[7] Tile_X0Y1_E6END[0] Tile_X0Y1_E6END[10] Tile_X0Y1_E6END[11]
+ Tile_X0Y1_E6END[1] Tile_X0Y1_E6END[2] Tile_X0Y1_E6END[3] Tile_X0Y1_E6END[4] Tile_X0Y1_E6END[5]
+ Tile_X0Y1_E6END[6] Tile_X0Y1_E6END[7] Tile_X0Y1_E6END[8] Tile_X0Y1_E6END[9] Tile_X0Y1_EE4END[0]
+ Tile_X0Y1_EE4END[10] Tile_X0Y1_EE4END[11] Tile_X0Y1_EE4END[12] Tile_X0Y1_EE4END[13]
+ Tile_X0Y1_EE4END[14] Tile_X0Y1_EE4END[15] Tile_X0Y1_EE4END[1] Tile_X0Y1_EE4END[2]
+ Tile_X0Y1_EE4END[3] Tile_X0Y1_EE4END[4] Tile_X0Y1_EE4END[5] Tile_X0Y1_EE4END[6]
+ Tile_X0Y1_EE4END[7] Tile_X0Y1_EE4END[8] Tile_X0Y1_EE4END[9] Tile_X0Y1_FrameData[0]
+ Tile_X0Y1_FrameData[10] Tile_X0Y1_FrameData[11] Tile_X0Y1_FrameData[12] Tile_X0Y1_FrameData[13]
+ Tile_X0Y1_FrameData[14] Tile_X0Y1_FrameData[15] Tile_X0Y1_FrameData[16] Tile_X0Y1_FrameData[17]
+ Tile_X0Y1_FrameData[18] Tile_X0Y1_FrameData[19] Tile_X0Y1_FrameData[1] Tile_X0Y1_FrameData[20]
+ Tile_X0Y1_FrameData[21] Tile_X0Y1_FrameData[22] Tile_X0Y1_FrameData[23] Tile_X0Y1_FrameData[24]
+ Tile_X0Y1_FrameData[25] Tile_X0Y1_FrameData[26] Tile_X0Y1_FrameData[27] Tile_X0Y1_FrameData[28]
+ Tile_X0Y1_FrameData[29] Tile_X0Y1_FrameData[2] Tile_X0Y1_FrameData[30] Tile_X0Y1_FrameData[31]
+ Tile_X0Y1_FrameData[3] Tile_X0Y1_FrameData[4] Tile_X0Y1_FrameData[5] Tile_X0Y1_FrameData[6]
+ Tile_X0Y1_FrameData[7] Tile_X0Y1_FrameData[8] Tile_X0Y1_FrameData[9] Tile_X0Y1_FrameData_O[0]
+ Tile_X0Y1_FrameData_O[10] Tile_X0Y1_FrameData_O[11] Tile_X0Y1_FrameData_O[12] Tile_X0Y1_FrameData_O[13]
+ Tile_X0Y1_FrameData_O[14] Tile_X0Y1_FrameData_O[15] Tile_X0Y1_FrameData_O[16] Tile_X0Y1_FrameData_O[17]
+ Tile_X0Y1_FrameData_O[18] Tile_X0Y1_FrameData_O[19] Tile_X0Y1_FrameData_O[1] Tile_X0Y1_FrameData_O[20]
+ Tile_X0Y1_FrameData_O[21] Tile_X0Y1_FrameData_O[22] Tile_X0Y1_FrameData_O[23] Tile_X0Y1_FrameData_O[24]
+ Tile_X0Y1_FrameData_O[25] Tile_X0Y1_FrameData_O[26] Tile_X0Y1_FrameData_O[27] Tile_X0Y1_FrameData_O[28]
+ Tile_X0Y1_FrameData_O[29] Tile_X0Y1_FrameData_O[2] Tile_X0Y1_FrameData_O[30] Tile_X0Y1_FrameData_O[31]
+ Tile_X0Y1_FrameData_O[3] Tile_X0Y1_FrameData_O[4] Tile_X0Y1_FrameData_O[5] Tile_X0Y1_FrameData_O[6]
+ Tile_X0Y1_FrameData_O[7] Tile_X0Y1_FrameData_O[8] Tile_X0Y1_FrameData_O[9] Tile_X0Y1_FrameStrobe[0]
+ Tile_X0Y1_FrameStrobe[10] Tile_X0Y1_FrameStrobe[11] Tile_X0Y1_FrameStrobe[12] Tile_X0Y1_FrameStrobe[13]
+ Tile_X0Y1_FrameStrobe[14] Tile_X0Y1_FrameStrobe[15] Tile_X0Y1_FrameStrobe[16] Tile_X0Y1_FrameStrobe[17]
+ Tile_X0Y1_FrameStrobe[18] Tile_X0Y1_FrameStrobe[19] Tile_X0Y1_FrameStrobe[1] Tile_X0Y1_FrameStrobe[2]
+ Tile_X0Y1_FrameStrobe[3] Tile_X0Y1_FrameStrobe[4] Tile_X0Y1_FrameStrobe[5] Tile_X0Y1_FrameStrobe[6]
+ Tile_X0Y1_FrameStrobe[7] Tile_X0Y1_FrameStrobe[8] Tile_X0Y1_FrameStrobe[9] Tile_X0Y1_N1END[0]
+ Tile_X0Y1_N1END[1] Tile_X0Y1_N1END[2] Tile_X0Y1_N1END[3] Tile_X0Y1_N2END[0] Tile_X0Y1_N2END[1]
+ Tile_X0Y1_N2END[2] Tile_X0Y1_N2END[3] Tile_X0Y1_N2END[4] Tile_X0Y1_N2END[5] Tile_X0Y1_N2END[6]
+ Tile_X0Y1_N2END[7] Tile_X0Y1_N2MID[0] Tile_X0Y1_N2MID[1] Tile_X0Y1_N2MID[2] Tile_X0Y1_N2MID[3]
+ Tile_X0Y1_N2MID[4] Tile_X0Y1_N2MID[5] Tile_X0Y1_N2MID[6] Tile_X0Y1_N2MID[7] Tile_X0Y1_N4END[0]
+ Tile_X0Y1_N4END[10] Tile_X0Y1_N4END[11] Tile_X0Y1_N4END[12] Tile_X0Y1_N4END[13]
+ Tile_X0Y1_N4END[14] Tile_X0Y1_N4END[15] Tile_X0Y1_N4END[1] Tile_X0Y1_N4END[2] Tile_X0Y1_N4END[3]
+ Tile_X0Y1_N4END[4] Tile_X0Y1_N4END[5] Tile_X0Y1_N4END[6] Tile_X0Y1_N4END[7] Tile_X0Y1_N4END[8]
+ Tile_X0Y1_N4END[9] Tile_X0Y1_S1BEG[0] Tile_X0Y1_S1BEG[1] Tile_X0Y1_S1BEG[2] Tile_X0Y1_S1BEG[3]
+ Tile_X0Y1_S2BEG[0] Tile_X0Y1_S2BEG[1] Tile_X0Y1_S2BEG[2] Tile_X0Y1_S2BEG[3] Tile_X0Y1_S2BEG[4]
+ Tile_X0Y1_S2BEG[5] Tile_X0Y1_S2BEG[6] Tile_X0Y1_S2BEG[7] Tile_X0Y1_S2BEGb[0] Tile_X0Y1_S2BEGb[1]
+ Tile_X0Y1_S2BEGb[2] Tile_X0Y1_S2BEGb[3] Tile_X0Y1_S2BEGb[4] Tile_X0Y1_S2BEGb[5]
+ Tile_X0Y1_S2BEGb[6] Tile_X0Y1_S2BEGb[7] Tile_X0Y1_S4BEG[0] Tile_X0Y1_S4BEG[10] Tile_X0Y1_S4BEG[11]
+ Tile_X0Y1_S4BEG[12] Tile_X0Y1_S4BEG[13] Tile_X0Y1_S4BEG[14] Tile_X0Y1_S4BEG[15]
+ Tile_X0Y1_S4BEG[1] Tile_X0Y1_S4BEG[2] Tile_X0Y1_S4BEG[3] Tile_X0Y1_S4BEG[4] Tile_X0Y1_S4BEG[5]
+ Tile_X0Y1_S4BEG[6] Tile_X0Y1_S4BEG[7] Tile_X0Y1_S4BEG[8] Tile_X0Y1_S4BEG[9] Tile_X0Y1_UserCLK
+ Tile_X0Y1_W1BEG[0] Tile_X0Y1_W1BEG[1] Tile_X0Y1_W1BEG[2] Tile_X0Y1_W1BEG[3] Tile_X0Y1_W2BEG[0]
+ Tile_X0Y1_W2BEG[1] Tile_X0Y1_W2BEG[2] Tile_X0Y1_W2BEG[3] Tile_X0Y1_W2BEG[4] Tile_X0Y1_W2BEG[5]
+ Tile_X0Y1_W2BEG[6] Tile_X0Y1_W2BEG[7] Tile_X0Y1_W2BEGb[0] Tile_X0Y1_W2BEGb[1] Tile_X0Y1_W2BEGb[2]
+ Tile_X0Y1_W2BEGb[3] Tile_X0Y1_W2BEGb[4] Tile_X0Y1_W2BEGb[5] Tile_X0Y1_W2BEGb[6]
+ Tile_X0Y1_W2BEGb[7] Tile_X0Y1_W6BEG[0] Tile_X0Y1_W6BEG[10] Tile_X0Y1_W6BEG[11] Tile_X0Y1_W6BEG[1]
+ Tile_X0Y1_W6BEG[2] Tile_X0Y1_W6BEG[3] Tile_X0Y1_W6BEG[4] Tile_X0Y1_W6BEG[5] Tile_X0Y1_W6BEG[6]
+ Tile_X0Y1_W6BEG[7] Tile_X0Y1_W6BEG[8] Tile_X0Y1_W6BEG[9] Tile_X0Y1_WW4BEG[0] Tile_X0Y1_WW4BEG[10]
+ Tile_X0Y1_WW4BEG[11] Tile_X0Y1_WW4BEG[12] Tile_X0Y1_WW4BEG[13] Tile_X0Y1_WW4BEG[14]
+ Tile_X0Y1_WW4BEG[15] Tile_X0Y1_WW4BEG[1] Tile_X0Y1_WW4BEG[2] Tile_X0Y1_WW4BEG[3]
+ Tile_X0Y1_WW4BEG[4] Tile_X0Y1_WW4BEG[5] Tile_X0Y1_WW4BEG[6] Tile_X0Y1_WW4BEG[7]
+ Tile_X0Y1_WW4BEG[8] Tile_X0Y1_WW4BEG[9] VGND VPWR WEB_A_SRAM WMASK_A_SRAM0 WMASK_A_SRAM1
+ WMASK_A_SRAM2 WMASK_A_SRAM3
XFILLER_100_127 VGND VGND VPWR VPWR sky130_fd_sc_hd__decap_3
X_0367_ Tile_X0Y0_OpenRAM_top.Inst_OpenRAM_top_switch_matrix.N1END1 net11 net147 net43
+ Tile_X0Y0_OpenRAM_top.Inst_OpenRAM_top_ConfigMem.Inst_frame6_bit23.Q Tile_X0Y0_OpenRAM_top.Inst_OpenRAM_top_ConfigMem.Inst_frame6_bit22.Q
+ VGND VGND VPWR VPWR Tile_X0Y0_OpenRAM_top.Inst_OpenRAM_top_switch_matrix.W1BEG1
+ sky130_fd_sc_hd__mux4_1
XFILLER_36_19 VGND VGND VPWR VPWR sky130_fd_sc_hd__decap_3
XFILLER_54_203 VGND VGND VPWR VPWR sky130_fd_sc_hd__decap_3
X_0298_ _0019_ Tile_X0Y1_OpenRAM_bot.Inst_OpenRAM_bot_ConfigMem.Inst_frame0_bit27.Q
+ _0063_ _0065_ VGND VGND VPWR VPWR _0066_ sky130_fd_sc_hd__a31o_1
XFILLER_22_100 VGND VGND VPWR VPWR sky130_fd_sc_hd__decap_3
XFILLER_168_18 VGND VGND VPWR VPWR sky130_fd_sc_hd__decap_3
XFILLER_167_116 VGND VGND VPWR VPWR sky130_fd_sc_hd__decap_3
XFILLER_22_188 VGND VGND VPWR VPWR sky130_fd_sc_hd__decap_3
XFILLER_175_193 VGND VGND VPWR VPWR sky130_fd_sc_hd__decap_3
XFILLER_108_227 VGND VGND VPWR VPWR sky130_fd_sc_hd__decap_3
XFILLER_123_208 VGND VGND VPWR VPWR sky130_fd_sc_hd__decap_3
XFILLER_117_11 VGND VGND VPWR VPWR sky130_fd_sc_hd__decap_3
XFILLER_117_44 VGND VGND VPWR VPWR sky130_fd_sc_hd__decap_3
XFILLER_89_111 VGND VGND VPWR VPWR sky130_fd_sc_hd__fill_1
XFILLER_89_122 VGND VGND VPWR VPWR sky130_fd_sc_hd__decap_3
XFILLER_117_66 VGND VGND VPWR VPWR sky130_fd_sc_hd__decap_3
XFILLER_77_15 VGND VGND VPWR VPWR sky130_fd_sc_hd__decap_3
XFILLER_89_155 VGND VGND VPWR VPWR sky130_fd_sc_hd__decap_3
XFILLER_77_48 VGND VGND VPWR VPWR sky130_fd_sc_hd__decap_3
XFILLER_89_188 VGND VGND VPWR VPWR sky130_fd_sc_hd__decap_3
XFILLER_133_32 VGND VGND VPWR VPWR sky130_fd_sc_hd__decap_3
XFILLER_172_3 VGND VGND VPWR VPWR sky130_fd_sc_hd__decap_3
XFILLER_45_225 VGND VGND VPWR VPWR sky130_fd_sc_hd__decap_3
XFILLER_93_36 VGND VGND VPWR VPWR sky130_fd_sc_hd__decap_3
XFILLER_26_41 VGND VGND VPWR VPWR sky130_fd_sc_hd__fill_2
XPHY_EDGE_ROW_116_Left_299 VGND VGND VPWR VPWR sky130_fd_sc_hd__decap_3
XFILLER_26_85 VGND VGND VPWR VPWR sky130_fd_sc_hd__decap_3
XFILLER_13_199 VGND VGND VPWR VPWR sky130_fd_sc_hd__decap_3
XFILLER_9_137 VGND VGND VPWR VPWR sky130_fd_sc_hd__decap_3
XFILLER_42_62 VGND VGND VPWR VPWR sky130_fd_sc_hd__decap_3
XFILLER_173_119 VGND VGND VPWR VPWR sky130_fd_sc_hd__decap_3
XFILLER_173_108 VGND VGND VPWR VPWR sky130_fd_sc_hd__decap_3
XFILLER_166_171 VGND VGND VPWR VPWR sky130_fd_sc_hd__decap_3
XFILLER_174_50 VGND VGND VPWR VPWR sky130_fd_sc_hd__decap_3
XFILLER_174_83 VGND VGND VPWR VPWR sky130_fd_sc_hd__fill_1
XFILLER_3_12 VGND VGND VPWR VPWR sky130_fd_sc_hd__decap_3
XFILLER_174_94 VGND VGND VPWR VPWR sky130_fd_sc_hd__decap_3
XFILLER_3_45 VGND VGND VPWR VPWR sky130_fd_sc_hd__decap_3
X_1270_ net118 VGND VGND VPWR VPWR net421 sky130_fd_sc_hd__clkbuf_2
XFILLER_3_78 VGND VGND VPWR VPWR sky130_fd_sc_hd__decap_3
XFILLER_95_169 VGND VGND VPWR VPWR sky130_fd_sc_hd__decap_3
XFILLER_51_217 VGND VGND VPWR VPWR sky130_fd_sc_hd__decap_3
XFILLER_149_149 VGND VGND VPWR VPWR sky130_fd_sc_hd__decap_3
X_0985_ net226 net333 VGND VGND VPWR VPWR Tile_X0Y1_OpenRAM_bot.Inst_OpenRAM_bot_ConfigMem.Inst_frame0_bit13.Q
+ sky130_fd_sc_hd__dlxtp_1
Xoutput401 net484 VGND VGND VPWR VPWR Tile_X0Y0_N2BEGb[3] sky130_fd_sc_hd__buf_2
XFILLER_172_141 VGND VGND VPWR VPWR sky130_fd_sc_hd__decap_3
XFILLER_172_130 VGND VGND VPWR VPWR sky130_fd_sc_hd__decap_3
XFILLER_8_192 VGND VGND VPWR VPWR sky130_fd_sc_hd__decap_3
Xoutput412 net495 VGND VGND VPWR VPWR Tile_X0Y0_N4BEG[15] sky130_fd_sc_hd__buf_2
XFILLER_172_174 VGND VGND VPWR VPWR sky130_fd_sc_hd__decap_3
Xoutput434 net517 VGND VGND VPWR VPWR Tile_X0Y0_W2BEG[7] sky130_fd_sc_hd__buf_2
Xoutput423 net506 VGND VGND VPWR VPWR Tile_X0Y0_W1BEG[0] sky130_fd_sc_hd__buf_2
Xoutput478 net561 VGND VGND VPWR VPWR Tile_X0Y1_FrameData_O[16] sky130_fd_sc_hd__buf_2
Xoutput445 net528 VGND VGND VPWR VPWR Tile_X0Y0_W6BEG[11] sky130_fd_sc_hd__buf_2
Xoutput456 net539 VGND VGND VPWR VPWR Tile_X0Y0_WW4BEG[10] sky130_fd_sc_hd__buf_2
Xoutput467 net550 VGND VGND VPWR VPWR Tile_X0Y0_WW4BEG[6] sky130_fd_sc_hd__buf_2
Xoutput489 net572 VGND VGND VPWR VPWR Tile_X0Y1_FrameData_O[26] sky130_fd_sc_hd__buf_2
X_1468_ Tile_X0Y1_OpenRAM_bot.Inst_OpenRAM_bot_switch_matrix.W2BEG2 VGND VGND VPWR
+ VPWR net628 sky130_fd_sc_hd__clkbuf_2
X_0419_ net15 Tile_X0Y0_OpenRAM_top.Inst_OpenRAM_top_switch_matrix.J_NS4_BEG11 Tile_X0Y0_OpenRAM_top.Inst_OpenRAM_top_switch_matrix.J_NS4_BEG7
+ net259 Tile_X0Y0_OpenRAM_top.Inst_OpenRAM_top_ConfigMem.Inst_frame3_bit5.Q Tile_X0Y0_OpenRAM_top.Inst_OpenRAM_top_ConfigMem.Inst_frame3_bit4.Q
+ VGND VGND VPWR VPWR Tile_X0Y0_OpenRAM_top.Inst_OpenRAM_top_switch_matrix.W6BEG4
+ sky130_fd_sc_hd__mux4_1
X_1399_ net249 VGND VGND VPWR VPWR net581 sky130_fd_sc_hd__buf_4
XFILLER_103_24 VGND VGND VPWR VPWR sky130_fd_sc_hd__decap_3
XFILLER_27_203 VGND VGND VPWR VPWR sky130_fd_sc_hd__decap_3
XFILLER_27_225 VGND VGND VPWR VPWR sky130_fd_sc_hd__fill_1
XFILLER_94_180 VGND VGND VPWR VPWR sky130_fd_sc_hd__decap_3
XFILLER_103_57 VGND VGND VPWR VPWR sky130_fd_sc_hd__decap_3
XTAP_TAPCELL_ROW_2_379 VGND VPWR sky130_fd_sc_hd__tapvpwrvgnd_1
XFILLER_179_39 VGND VGND VPWR VPWR sky130_fd_sc_hd__decap_3
XFILLER_10_103 VGND VGND VPWR VPWR sky130_fd_sc_hd__decap_3
XFILLER_155_119 VGND VGND VPWR VPWR sky130_fd_sc_hd__decap_3
XFILLER_155_108 VGND VGND VPWR VPWR sky130_fd_sc_hd__decap_3
XFILLER_12_21 VGND VGND VPWR VPWR sky130_fd_sc_hd__decap_3
XFILLER_10_147 VGND VGND VPWR VPWR sky130_fd_sc_hd__decap_3
XFILLER_10_136 VGND VGND VPWR VPWR sky130_fd_sc_hd__decap_3
XFILLER_148_171 VGND VGND VPWR VPWR sky130_fd_sc_hd__decap_3
XFILLER_6_118 VGND VGND VPWR VPWR sky130_fd_sc_hd__decap_3
XFILLER_128_32 VGND VGND VPWR VPWR sky130_fd_sc_hd__fill_2
XFILLER_12_65 VGND VGND VPWR VPWR sky130_fd_sc_hd__decap_3
XFILLER_163_163 VGND VGND VPWR VPWR sky130_fd_sc_hd__decap_3
XFILLER_163_196 VGND VGND VPWR VPWR sky130_fd_sc_hd__decap_3
XFILLER_88_47 VGND VGND VPWR VPWR sky130_fd_sc_hd__decap_3
XFILLER_144_42 VGND VGND VPWR VPWR sky130_fd_sc_hd__decap_3
XFILLER_77_103 VGND VGND VPWR VPWR sky130_fd_sc_hd__decap_3
XFILLER_144_75 VGND VGND VPWR VPWR sky130_fd_sc_hd__decap_3
XFILLER_77_125 VGND VGND VPWR VPWR sky130_fd_sc_hd__decap_3
XFILLER_77_169 VGND VGND VPWR VPWR sky130_fd_sc_hd__decap_3
XPHY_EDGE_ROW_124_Left_307 VGND VGND VPWR VPWR sky130_fd_sc_hd__decap_3
XFILLER_18_203 VGND VGND VPWR VPWR sky130_fd_sc_hd__decap_3
XFILLER_37_51 VGND VGND VPWR VPWR sky130_fd_sc_hd__decap_3
XFILLER_92_139 VGND VGND VPWR VPWR sky130_fd_sc_hd__fill_1
XFILLER_160_41 VGND VGND VPWR VPWR sky130_fd_sc_hd__decap_3
XFILLER_37_84 VGND VGND VPWR VPWR sky130_fd_sc_hd__decap_3
XFILLER_160_85 VGND VGND VPWR VPWR sky130_fd_sc_hd__decap_3
XFILLER_33_217 VGND VGND VPWR VPWR sky130_fd_sc_hd__decap_3
XTAP_TAPCELL_ROW_16_437 VGND VPWR sky130_fd_sc_hd__tapvpwrvgnd_1
XTAP_TAPCELL_ROW_56_595 VGND VPWR sky130_fd_sc_hd__tapvpwrvgnd_1
XTAP_TAPCELL_ROW_158_1002 VGND VPWR sky130_fd_sc_hd__tapvpwrvgnd_1
XFILLER_53_72 VGND VGND VPWR VPWR sky130_fd_sc_hd__decap_3
XFILLER_169_72 VGND VGND VPWR VPWR sky130_fd_sc_hd__decap_3
XFILLER_139_160 VGND VGND VPWR VPWR sky130_fd_sc_hd__decap_3
XPHY_EDGE_ROW_133_Left_316 VGND VGND VPWR VPWR sky130_fd_sc_hd__decap_3
X_0770_ net121 net317 VGND VGND VPWR VPWR Tile_X0Y0_OpenRAM_top.Inst_OpenRAM_top_ConfigMem.Inst_frame2_bit16.Q
+ sky130_fd_sc_hd__dlxtp_1
XFILLER_154_141 VGND VGND VPWR VPWR sky130_fd_sc_hd__decap_3
XFILLER_5_140 VGND VGND VPWR VPWR sky130_fd_sc_hd__decap_3
XFILLER_154_174 VGND VGND VPWR VPWR sky130_fd_sc_hd__decap_3
XFILLER_5_184 VGND VGND VPWR VPWR sky130_fd_sc_hd__decap_3
XFILLER_68_114 VGND VGND VPWR VPWR sky130_fd_sc_hd__decap_3
XFILLER_78_91 VGND VGND VPWR VPWR sky130_fd_sc_hd__fill_2
X_1322_ Tile_X0Y0_OpenRAM_top.Inst_OpenRAM_top_switch_matrix.N2BEGb1 VGND VGND VPWR
+ VPWR net482 sky130_fd_sc_hd__buf_4
XPHY_EDGE_ROW_142_Left_325 VGND VGND VPWR VPWR sky130_fd_sc_hd__decap_3
X_1253_ net233 net265 VGND VGND VPWR VPWR Tile_X0Y1_OpenRAM_bot.Inst_OpenRAM_bot_ConfigMem.Inst_frame8_bit1.Q
+ sky130_fd_sc_hd__dlxtp_1
XFILLER_68_147 VGND VGND VPWR VPWR sky130_fd_sc_hd__decap_3
XTAP_TAPCELL_ROW_39_529 VGND VPWR sky130_fd_sc_hd__tapvpwrvgnd_1
XTAP_TAPCELL_ROW_79_687 VGND VPWR sky130_fd_sc_hd__tapvpwrvgnd_1
XFILLER_83_128 VGND VGND VPWR VPWR sky130_fd_sc_hd__decap_3
X_1184_ net250 net281 VGND VGND VPWR VPWR Tile_X0Y1_OpenRAM_bot.Inst_OpenRAM_bot_ConfigMem.Inst_frame6_bit6.Q
+ sky130_fd_sc_hd__dlxtp_1
XFILLER_24_206 VGND VGND VPWR VPWR sky130_fd_sc_hd__decap_3
XFILLER_91_172 VGND VGND VPWR VPWR sky130_fd_sc_hd__decap_3
XFILLER_177_211 VGND VGND VPWR VPWR sky130_fd_sc_hd__decap_3
XPHY_EDGE_ROW_151_Left_334 VGND VGND VPWR VPWR sky130_fd_sc_hd__decap_3
X_0968_ net245 net330 VGND VGND VPWR VPWR Tile_X0Y1_OpenRAM_bot.Inst_OpenRAM_bot_ConfigMem.Inst_frame0_bit30.Q
+ sky130_fd_sc_hd__dlxtp_1
X_0899_ net120 net282 VGND VGND VPWR VPWR Tile_X0Y0_OpenRAM_top.Inst_OpenRAM_top_ConfigMem.Inst_frame6_bit15.Q
+ sky130_fd_sc_hd__dlxtp_1
XFILLER_160_144 VGND VGND VPWR VPWR sky130_fd_sc_hd__decap_3
XFILLER_160_133 VGND VGND VPWR VPWR sky130_fd_sc_hd__decap_3
XFILLER_160_177 VGND VGND VPWR VPWR sky130_fd_sc_hd__decap_3
Xoutput286 net369 VGND VGND VPWR VPWR ADDR_A_SRAM4 sky130_fd_sc_hd__buf_2
XFILLER_181_18 VGND VGND VPWR VPWR sky130_fd_sc_hd__decap_3
XPHY_EDGE_ROW_160_Left_343 VGND VGND VPWR VPWR sky130_fd_sc_hd__decap_3
Xoutput297 net380 VGND VGND VPWR VPWR ADDR_B_SRAM7 sky130_fd_sc_hd__buf_2
XFILLER_59_158 VGND VGND VPWR VPWR sky130_fd_sc_hd__decap_3
XFILLER_67_191 VGND VGND VPWR VPWR sky130_fd_sc_hd__decap_3
XFILLER_82_150 VGND VGND VPWR VPWR sky130_fd_sc_hd__fill_2
XFILLER_15_228 VGND VGND VPWR VPWR sky130_fd_sc_hd__fill_2
XFILLER_82_194 VGND VGND VPWR VPWR sky130_fd_sc_hd__fill_2
XFILLER_168_200 VGND VGND VPWR VPWR sky130_fd_sc_hd__decap_3
XFILLER_130_88 VGND VGND VPWR VPWR sky130_fd_sc_hd__decap_3
XFILLER_130_77 VGND VGND VPWR VPWR sky130_fd_sc_hd__decap_3
XTAP_TAPCELL_ROW_105_791 VGND VPWR sky130_fd_sc_hd__tapvpwrvgnd_1
XFILLER_30_209 VGND VGND VPWR VPWR sky130_fd_sc_hd__decap_3
XFILLER_135_3 VGND VGND VPWR VPWR sky130_fd_sc_hd__fill_1
XFILLER_23_42 VGND VGND VPWR VPWR sky130_fd_sc_hd__decap_3
XFILLER_139_42 VGND VGND VPWR VPWR sky130_fd_sc_hd__decap_3
XPHY_EDGE_ROW_137_Right_137 VGND VGND VPWR VPWR sky130_fd_sc_hd__decap_3
XFILLER_139_97 VGND VGND VPWR VPWR sky130_fd_sc_hd__decap_3
XFILLER_139_75 VGND VGND VPWR VPWR sky130_fd_sc_hd__fill_1
XFILLER_136_141 VGND VGND VPWR VPWR sky130_fd_sc_hd__decap_3
XFILLER_99_24 VGND VGND VPWR VPWR sky130_fd_sc_hd__decap_3
XFILLER_151_111 VGND VGND VPWR VPWR sky130_fd_sc_hd__fill_1
XFILLER_136_174 VGND VGND VPWR VPWR sky130_fd_sc_hd__fill_1
XFILLER_99_57 VGND VGND VPWR VPWR sky130_fd_sc_hd__decap_3
XFILLER_2_121 VGND VGND VPWR VPWR sky130_fd_sc_hd__decap_3
XFILLER_155_63 VGND VGND VPWR VPWR sky130_fd_sc_hd__decap_3
XFILLER_155_52 VGND VGND VPWR VPWR sky130_fd_sc_hd__decap_3
XFILLER_2_165 VGND VGND VPWR VPWR sky130_fd_sc_hd__decap_3
XFILLER_155_96 VGND VGND VPWR VPWR sky130_fd_sc_hd__decap_3
XFILLER_48_50 VGND VGND VPWR VPWR sky130_fd_sc_hd__decap_3
XFILLER_171_51 VGND VGND VPWR VPWR sky130_fd_sc_hd__decap_3
XFILLER_48_83 VGND VGND VPWR VPWR sky130_fd_sc_hd__fill_1
XFILLER_171_84 VGND VGND VPWR VPWR sky130_fd_sc_hd__decap_3
XTAP_TAPCELL_ROW_128_883 VGND VPWR sky130_fd_sc_hd__tapvpwrvgnd_1
XFILLER_58_180 VGND VGND VPWR VPWR sky130_fd_sc_hd__decap_3
XFILLER_0_57 VGND VGND VPWR VPWR sky130_fd_sc_hd__decap_3
XFILLER_73_161 VGND VGND VPWR VPWR sky130_fd_sc_hd__decap_3
XFILLER_64_60 VGND VGND VPWR VPWR sky130_fd_sc_hd__fill_1
XFILLER_64_82 VGND VGND VPWR VPWR sky130_fd_sc_hd__fill_2
XFILLER_73_172 VGND VGND VPWR VPWR sky130_fd_sc_hd__decap_3
XFILLER_73_194 VGND VGND VPWR VPWR sky130_fd_sc_hd__decap_3
XFILLER_159_222 VGND VGND VPWR VPWR sky130_fd_sc_hd__fill_2
XFILLER_9_33 VGND VGND VPWR VPWR sky130_fd_sc_hd__decap_3
XFILLER_174_203 VGND VGND VPWR VPWR sky130_fd_sc_hd__decap_3
XFILLER_9_66 VGND VGND VPWR VPWR sky130_fd_sc_hd__decap_3
X_0822_ net134 net303 VGND VGND VPWR VPWR Tile_X0Y0_OpenRAM_top.Inst_OpenRAM_top_ConfigMem.Inst_frame4_bit28.Q
+ sky130_fd_sc_hd__dlxtp_1
XPHY_EDGE_ROW_104_Right_104 VGND VGND VPWR VPWR sky130_fd_sc_hd__decap_3
XFILLER_9_99 VGND VGND VPWR VPWR sky130_fd_sc_hd__decap_3
XTAP_TAPCELL_ROW_171_1054 VGND VPWR sky130_fd_sc_hd__tapvpwrvgnd_1
X_0753_ net125 net329 VGND VGND VPWR VPWR Tile_X0Y0_OpenRAM_top.Inst_OpenRAM_top_ConfigMem.Inst_frame1_bit1.Q
+ sky130_fd_sc_hd__dlxtp_1
XFILLER_142_144 VGND VGND VPWR VPWR sky130_fd_sc_hd__decap_3
XFILLER_142_111 VGND VGND VPWR VPWR sky130_fd_sc_hd__decap_3
XFILLER_50_3 VGND VGND VPWR VPWR sky130_fd_sc_hd__fill_1
X_0684_ net189 net192 Tile_X0Y1_OpenRAM_bot.Inst_OpenRAM_bot_ConfigMem.Inst_frame3_bit12.Q
+ VGND VGND VPWR VPWR _0221_ sky130_fd_sc_hd__mux2_1
XFILLER_142_177 VGND VGND VPWR VPWR sky130_fd_sc_hd__decap_3
XFILLER_88_209 VGND VGND VPWR VPWR sky130_fd_sc_hd__decap_3
XFILLER_89_90 VGND VGND VPWR VPWR sky130_fd_sc_hd__decap_3
X_1305_ Tile_X0Y1_FrameStrobe[16] VGND VGND VPWR VPWR net456 sky130_fd_sc_hd__clkbuf_1
XFILLER_96_231 VGND VGND VPWR VPWR sky130_fd_sc_hd__decap_3
XFILLER_49_191 VGND VGND VPWR VPWR sky130_fd_sc_hd__decap_3
X_1236_ net231 net266 VGND VGND VPWR VPWR Tile_X0Y1_OpenRAM_bot.Inst_OpenRAM_bot_ConfigMem.Inst_frame8_bit18.Q
+ sky130_fd_sc_hd__dlxtp_1
X_1167_ net237 net278 VGND VGND VPWR VPWR Tile_X0Y1_OpenRAM_bot.Inst_OpenRAM_bot_ConfigMem.Inst_frame6_bit23.Q
+ sky130_fd_sc_hd__dlxtp_1
XFILLER_64_161 VGND VGND VPWR VPWR sky130_fd_sc_hd__decap_3
XTAP_TAPCELL_ROW_35_510 VGND VPWR sky130_fd_sc_hd__tapvpwrvgnd_1
XFILLER_64_172 VGND VGND VPWR VPWR sky130_fd_sc_hd__decap_3
X_1098_ net242 net297 VGND VGND VPWR VPWR Tile_X0Y1_OpenRAM_bot.Inst_OpenRAM_bot_ConfigMem.Inst_frame4_bit28.Q
+ sky130_fd_sc_hd__dlxtp_1
XFILLER_100_58 VGND VGND VPWR VPWR sky130_fd_sc_hd__decap_3
XFILLER_176_29 VGND VGND VPWR VPWR sky130_fd_sc_hd__decap_3
XFILLER_176_18 VGND VGND VPWR VPWR sky130_fd_sc_hd__decap_3
XFILLER_165_225 VGND VGND VPWR VPWR sky130_fd_sc_hd__decap_3
XFILLER_165_214 VGND VGND VPWR VPWR sky130_fd_sc_hd__decap_3
XFILLER_60_29 VGND VGND VPWR VPWR sky130_fd_sc_hd__fill_2
XFILLER_118_141 VGND VGND VPWR VPWR sky130_fd_sc_hd__decap_3
XFILLER_180_206 VGND VGND VPWR VPWR sky130_fd_sc_hd__decap_3
XFILLER_118_174 VGND VGND VPWR VPWR sky130_fd_sc_hd__decap_3
XFILLER_133_166 VGND VGND VPWR VPWR sky130_fd_sc_hd__fill_2
XFILLER_125_33 VGND VGND VPWR VPWR sky130_fd_sc_hd__decap_3
XFILLER_125_99 VGND VGND VPWR VPWR sky130_fd_sc_hd__decap_3
XFILLER_47_128 VGND VGND VPWR VPWR sky130_fd_sc_hd__decap_3
XTAP_TAPCELL_ROW_58_602 VGND VPWR sky130_fd_sc_hd__tapvpwrvgnd_1
XFILLER_141_43 VGND VGND VPWR VPWR sky130_fd_sc_hd__decap_3
XFILLER_18_64 VGND VGND VPWR VPWR sky130_fd_sc_hd__fill_1
XFILLER_141_87 VGND VGND VPWR VPWR sky130_fd_sc_hd__decap_3
XFILLER_55_172 VGND VGND VPWR VPWR sky130_fd_sc_hd__decap_3
XFILLER_156_203 VGND VGND VPWR VPWR sky130_fd_sc_hd__decap_3
XFILLER_11_220 VGND VGND VPWR VPWR sky130_fd_sc_hd__decap_3
XFILLER_34_85 VGND VGND VPWR VPWR sky130_fd_sc_hd__decap_3
XTAP_TAPCELL_ROW_41_535 VGND VPWR sky130_fd_sc_hd__tapvpwrvgnd_1
XFILLER_70_197 VGND VGND VPWR VPWR sky130_fd_sc_hd__decap_3
XFILLER_7_202 VGND VGND VPWR VPWR sky130_fd_sc_hd__decap_3
XFILLER_171_228 VGND VGND VPWR VPWR sky130_fd_sc_hd__fill_2
XFILLER_171_217 VGND VGND VPWR VPWR sky130_fd_sc_hd__decap_3
XFILLER_124_100 VGND VGND VPWR VPWR sky130_fd_sc_hd__decap_3
XFILLER_109_152 VGND VGND VPWR VPWR sky130_fd_sc_hd__fill_1
XFILLER_50_62 VGND VGND VPWR VPWR sky130_fd_sc_hd__decap_3
XFILLER_166_73 VGND VGND VPWR VPWR sky130_fd_sc_hd__decap_3
XFILLER_124_133 VGND VGND VPWR VPWR sky130_fd_sc_hd__decap_3
XFILLER_109_196 VGND VGND VPWR VPWR sky130_fd_sc_hd__decap_3
XFILLER_124_144 VGND VGND VPWR VPWR sky130_fd_sc_hd__decap_3
XFILLER_59_60 VGND VGND VPWR VPWR sky130_fd_sc_hd__decap_3
XFILLER_59_93 VGND VGND VPWR VPWR sky130_fd_sc_hd__decap_3
XFILLER_38_117 VGND VGND VPWR VPWR sky130_fd_sc_hd__decap_3
XFILLER_93_223 VGND VGND VPWR VPWR sky130_fd_sc_hd__fill_1
X_1021_ net253 net323 VGND VGND VPWR VPWR Tile_X0Y1_OpenRAM_bot.Inst_OpenRAM_bot_ConfigMem.Inst_frame1_bit9.Q
+ sky130_fd_sc_hd__dlxtp_1
XTAP_TAPCELL_ROW_64_627 VGND VPWR sky130_fd_sc_hd__tapvpwrvgnd_1
XFILLER_61_142 VGND VGND VPWR VPWR sky130_fd_sc_hd__decap_3
XFILLER_98_3 VGND VGND VPWR VPWR sky130_fd_sc_hd__decap_3
XTAP_TAPCELL_ROW_72_660 VGND VPWR sky130_fd_sc_hd__tapvpwrvgnd_1
XFILLER_147_225 VGND VGND VPWR VPWR sky130_fd_sc_hd__fill_1
XFILLER_162_228 VGND VGND VPWR VPWR sky130_fd_sc_hd__fill_2
X_0805_ net118 net308 VGND VGND VPWR VPWR Tile_X0Y0_OpenRAM_top.Inst_OpenRAM_top_ConfigMem.Inst_frame3_bit13.Q
+ sky130_fd_sc_hd__dlxtp_1
X_0736_ net123 net327 VGND VGND VPWR VPWR Tile_X0Y0_OpenRAM_top.Inst_OpenRAM_top_ConfigMem.Inst_frame1_bit18.Q
+ sky130_fd_sc_hd__dlxtp_1
XFILLER_115_133 VGND VGND VPWR VPWR sky130_fd_sc_hd__decap_3
XFILLER_115_155 VGND VGND VPWR VPWR sky130_fd_sc_hd__decap_3
XFILLER_130_125 VGND VGND VPWR VPWR sky130_fd_sc_hd__decap_3
XFILLER_130_103 VGND VGND VPWR VPWR sky130_fd_sc_hd__decap_3
XFILLER_115_199 VGND VGND VPWR VPWR sky130_fd_sc_hd__decap_3
X_0667_ Tile_X0Y1_OpenRAM_bot.Inst_OpenRAM_bot_ConfigMem.Inst_frame6_bit3.Q _0205_
+ Tile_X0Y1_OpenRAM_bot.Inst_OpenRAM_bot_ConfigMem.Inst_frame6_bit4.Q VGND VGND VPWR
+ VPWR _0206_ sky130_fd_sc_hd__a21bo_1
X_0598_ net181 _0025_ _0163_ VGND VGND VPWR VPWR _0164_ sky130_fd_sc_hd__o21a_1
XFILLER_69_231 VGND VGND VPWR VPWR sky130_fd_sc_hd__decap_3
XTAP_TAPCELL_ROW_87_719 VGND VPWR sky130_fd_sc_hd__tapvpwrvgnd_1
XFILLER_84_212 VGND VGND VPWR VPWR sky130_fd_sc_hd__fill_2
XFILLER_37_150 VGND VGND VPWR VPWR sky130_fd_sc_hd__decap_3
X_1219_ net247 net272 VGND VGND VPWR VPWR Tile_X0Y1_OpenRAM_bot.Inst_OpenRAM_bot_ConfigMem.Inst_frame7_bit3.Q
+ sky130_fd_sc_hd__dlxtp_1
XTAP_TAPCELL_ROW_95_752 VGND VPWR sky130_fd_sc_hd__tapvpwrvgnd_1
XFILLER_37_172 VGND VGND VPWR VPWR sky130_fd_sc_hd__decap_3
XFILLER_111_24 VGND VGND VPWR VPWR sky130_fd_sc_hd__decap_3
XFILLER_111_57 VGND VGND VPWR VPWR sky130_fd_sc_hd__decap_3
XFILLER_52_164 VGND VGND VPWR VPWR sky130_fd_sc_hd__decap_3
XFILLER_52_197 VGND VGND VPWR VPWR sky130_fd_sc_hd__decap_3
XFILLER_71_39 VGND VGND VPWR VPWR sky130_fd_sc_hd__decap_3
XFILLER_138_203 VGND VGND VPWR VPWR sky130_fd_sc_hd__decap_3
XFILLER_153_228 VGND VGND VPWR VPWR sky130_fd_sc_hd__fill_2
XFILLER_106_100 VGND VGND VPWR VPWR sky130_fd_sc_hd__decap_3
XFILLER_20_32 VGND VGND VPWR VPWR sky130_fd_sc_hd__decap_3
XFILLER_4_227 VGND VGND VPWR VPWR sky130_fd_sc_hd__decap_3
XFILLER_136_32 VGND VGND VPWR VPWR sky130_fd_sc_hd__decap_3
XFILLER_106_144 VGND VGND VPWR VPWR sky130_fd_sc_hd__decap_3
XFILLER_136_65 VGND VGND VPWR VPWR sky130_fd_sc_hd__decap_3
XFILLER_121_158 VGND VGND VPWR VPWR sky130_fd_sc_hd__decap_3
XFILLER_152_53 VGND VGND VPWR VPWR sky130_fd_sc_hd__decap_3
XFILLER_29_63 VGND VGND VPWR VPWR sky130_fd_sc_hd__fill_1
XFILLER_152_97 VGND VGND VPWR VPWR sky130_fd_sc_hd__decap_3
XTAP_TAPCELL_ROW_113_823 VGND VPWR sky130_fd_sc_hd__tapvpwrvgnd_1
XFILLER_43_131 VGND VGND VPWR VPWR sky130_fd_sc_hd__decap_3
XFILLER_43_164 VGND VGND VPWR VPWR sky130_fd_sc_hd__decap_3
XFILLER_43_186 VGND VGND VPWR VPWR sky130_fd_sc_hd__decap_3
XFILLER_45_84 VGND VGND VPWR VPWR sky130_fd_sc_hd__fill_1
XFILLER_129_225 VGND VGND VPWR VPWR sky130_fd_sc_hd__decap_3
XFILLER_101_90 VGND VGND VPWR VPWR sky130_fd_sc_hd__decap_3
XFILLER_84_9 VGND VGND VPWR VPWR sky130_fd_sc_hd__decap_3
XFILLER_61_72 VGND VGND VPWR VPWR sky130_fd_sc_hd__decap_3
XFILLER_177_72 VGND VGND VPWR VPWR sky130_fd_sc_hd__decap_3
XFILLER_144_206 VGND VGND VPWR VPWR sky130_fd_sc_hd__decap_3
XFILLER_6_12 VGND VGND VPWR VPWR sky130_fd_sc_hd__decap_3
XFILLER_6_56 VGND VGND VPWR VPWR sky130_fd_sc_hd__decap_3
X_0521_ net190 net196 net182 net260 Tile_X0Y1_OpenRAM_bot.Inst_OpenRAM_bot_ConfigMem.Inst_frame7_bit19.Q
+ Tile_X0Y1_OpenRAM_bot.Inst_OpenRAM_bot_ConfigMem.Inst_frame7_bit18.Q VGND VGND VPWR
+ VPWR Tile_X0Y1_OpenRAM_bot.Inst_OpenRAM_bot_switch_matrix.S2BEG3 sky130_fd_sc_hd__mux4_1
XFILLER_112_103 VGND VGND VPWR VPWR sky130_fd_sc_hd__decap_3
XFILLER_112_147 VGND VGND VPWR VPWR sky130_fd_sc_hd__decap_3
X_0452_ net72 Tile_X0Y0_OpenRAM_top.Inst_OpenRAM_top_ConfigMem.Inst_frame2_bit28.Q
+ VGND VGND VPWR VPWR _0102_ sky130_fd_sc_hd__nand2_1
X_0383_ net24 net56 net257 Tile_X0Y0_OpenRAM_top.Inst_OpenRAM_top_switch_matrix.J_NS2_BEG5
+ Tile_X0Y0_OpenRAM_top.Inst_OpenRAM_top_ConfigMem.Inst_frame5_bit22.Q Tile_X0Y0_OpenRAM_top.Inst_OpenRAM_top_ConfigMem.Inst_frame5_bit23.Q
+ VGND VGND VPWR VPWR Tile_X0Y0_OpenRAM_top.Inst_OpenRAM_top_switch_matrix.W2BEGb5
+ sky130_fd_sc_hd__mux4_1
XTAP_TAPCELL_ROW_136_915 VGND VPWR sky130_fd_sc_hd__tapvpwrvgnd_1
XFILLER_66_212 VGND VGND VPWR VPWR sky130_fd_sc_hd__decap_3
XFILLER_19_172 VGND VGND VPWR VPWR sky130_fd_sc_hd__decap_3
XFILLER_19_161 VGND VGND VPWR VPWR sky130_fd_sc_hd__decap_3
X_1004_ net240 net324 VGND VGND VPWR VPWR Tile_X0Y1_OpenRAM_bot.Inst_OpenRAM_bot_ConfigMem.Inst_frame1_bit26.Q
+ sky130_fd_sc_hd__dlxtp_1
XFILLER_179_147 VGND VGND VPWR VPWR sky130_fd_sc_hd__decap_3
XFILLER_179_125 VGND VGND VPWR VPWR sky130_fd_sc_hd__decap_3
XFILLER_179_169 VGND VGND VPWR VPWR sky130_fd_sc_hd__decap_3
XFILLER_135_206 VGND VGND VPWR VPWR sky130_fd_sc_hd__decap_3
XFILLER_135_228 VGND VGND VPWR VPWR sky130_fd_sc_hd__fill_2
XFILLER_150_209 VGND VGND VPWR VPWR sky130_fd_sc_hd__decap_3
X_0719_ net139 net336 VGND VGND VPWR VPWR Tile_X0Y0_OpenRAM_top.Inst_OpenRAM_top_ConfigMem.Inst_frame0_bit3.Q
+ sky130_fd_sc_hd__dlxtp_1
XFILLER_1_208 VGND VGND VPWR VPWR sky130_fd_sc_hd__decap_3
XFILLER_106_35 VGND VGND VPWR VPWR sky130_fd_sc_hd__decap_3
XFILLER_103_158 VGND VGND VPWR VPWR sky130_fd_sc_hd__decap_3
XFILLER_106_68 VGND VGND VPWR VPWR sky130_fd_sc_hd__decap_3
XFILLER_103_169 VGND VGND VPWR VPWR sky130_fd_sc_hd__decap_3
XFILLER_57_201 VGND VGND VPWR VPWR sky130_fd_sc_hd__decap_3
XFILLER_82_27 VGND VGND VPWR VPWR sky130_fd_sc_hd__fill_1
XFILLER_82_38 VGND VGND VPWR VPWR sky130_fd_sc_hd__decap_3
XFILLER_25_164 VGND VGND VPWR VPWR sky130_fd_sc_hd__decap_3
XFILLER_25_175 VGND VGND VPWR VPWR sky130_fd_sc_hd__decap_3
XTAP_TAPCELL_ROW_150_973 VGND VPWR sky130_fd_sc_hd__tapvpwrvgnd_1
XFILLER_40_112 VGND VGND VPWR VPWR sky130_fd_sc_hd__decap_3
XFILLER_178_180 VGND VGND VPWR VPWR sky130_fd_sc_hd__decap_3
XFILLER_31_53 VGND VGND VPWR VPWR sky130_fd_sc_hd__decap_3
XFILLER_147_31 VGND VGND VPWR VPWR sky130_fd_sc_hd__decap_3
XFILLER_126_228 VGND VGND VPWR VPWR sky130_fd_sc_hd__fill_2
XFILLER_31_75 VGND VGND VPWR VPWR sky130_fd_sc_hd__decap_3
XFILLER_163_63 VGND VGND VPWR VPWR sky130_fd_sc_hd__decap_3
XFILLER_163_41 VGND VGND VPWR VPWR sky130_fd_sc_hd__decap_3
Xinput120 Tile_X0Y0_FrameData[15] VGND VGND VPWR VPWR net120 sky130_fd_sc_hd__buf_4
Xinput153 Tile_X0Y0_S2END[3] VGND VGND VPWR VPWR net153 sky130_fd_sc_hd__clkbuf_2
Xinput131 Tile_X0Y0_FrameData[25] VGND VGND VPWR VPWR net131 sky130_fd_sc_hd__clkbuf_4
Xinput142 Tile_X0Y0_FrameData[6] VGND VGND VPWR VPWR net142 sky130_fd_sc_hd__buf_2
Xinput164 Tile_X0Y0_S2MID[6] VGND VGND VPWR VPWR net164 sky130_fd_sc_hd__buf_2
Xinput175 Tile_X0Y1_E1END[1] VGND VGND VPWR VPWR net175 sky130_fd_sc_hd__buf_2
Xinput186 Tile_X0Y1_E2MID[0] VGND VGND VPWR VPWR net186 sky130_fd_sc_hd__buf_2
Xinput197 Tile_X0Y1_E6END[1] VGND VGND VPWR VPWR net197 sky130_fd_sc_hd__clkbuf_2
XFILLER_56_61 VGND VGND VPWR VPWR sky130_fd_sc_hd__decap_3
XFILLER_56_94 VGND VGND VPWR VPWR sky130_fd_sc_hd__decap_3
XFILLER_16_153 VGND VGND VPWR VPWR sky130_fd_sc_hd__decap_3
XFILLER_31_134 VGND VGND VPWR VPWR sky130_fd_sc_hd__decap_3
XFILLER_72_71 VGND VGND VPWR VPWR sky130_fd_sc_hd__decap_3
XFILLER_176_106 VGND VGND VPWR VPWR sky130_fd_sc_hd__decap_3
XFILLER_176_139 VGND VGND VPWR VPWR sky130_fd_sc_hd__fill_1
XFILLER_31_178 VGND VGND VPWR VPWR sky130_fd_sc_hd__decap_3
XFILLER_82_6 VGND VGND VPWR VPWR sky130_fd_sc_hd__decap_3
XFILLER_117_228 VGND VGND VPWR VPWR sky130_fd_sc_hd__fill_2
XFILLER_98_112 VGND VGND VPWR VPWR sky130_fd_sc_hd__fill_1
Xfanout309 net310 VGND VGND VPWR VPWR net309 sky130_fd_sc_hd__clkbuf_4
X_0504_ net68 net94 Tile_X0Y0_OpenRAM_top.Inst_OpenRAM_top_switch_matrix.J_NS4_BEG6
+ Tile_X0Y0_OpenRAM_top.Inst_OpenRAM_top_switch_matrix.J_NS4_BEG14 Tile_X0Y0_OpenRAM_top.Inst_OpenRAM_top_ConfigMem.Inst_frame6_bit15.Q
+ Tile_X0Y0_OpenRAM_top.Inst_OpenRAM_top_ConfigMem.Inst_frame6_bit16.Q VGND VGND VPWR
+ VPWR _0142_ sky130_fd_sc_hd__mux4_1
XFILLER_98_156 VGND VGND VPWR VPWR sky130_fd_sc_hd__decap_3
XFILLER_98_134 VGND VGND VPWR VPWR sky130_fd_sc_hd__decap_3
X_1484_ Tile_X0Y1_OpenRAM_bot.Inst_OpenRAM_bot_switch_matrix.W6BEG2 VGND VGND VPWR
+ VPWR net646 sky130_fd_sc_hd__buf_1
X_0435_ net98 net112 net96 Tile_X0Y0_OpenRAM_top.Inst_OpenRAM_top_switch_matrix.J_NS4_BEG8
+ Tile_X0Y0_OpenRAM_top.Inst_OpenRAM_top_ConfigMem.Inst_frame2_bit4.Q Tile_X0Y0_OpenRAM_top.Inst_OpenRAM_top_ConfigMem.Inst_frame2_bit5.Q
+ VGND VGND VPWR VPWR net402 sky130_fd_sc_hd__mux4_2
XFILLER_98_189 VGND VGND VPWR VPWR sky130_fd_sc_hd__decap_3
XFILLER_97_90 VGND VGND VPWR VPWR sky130_fd_sc_hd__decap_3
XFILLER_100_139 VGND VGND VPWR VPWR sky130_fd_sc_hd__fill_1
XFILLER_39_223 VGND VGND VPWR VPWR sky130_fd_sc_hd__fill_1
X_0366_ Tile_X0Y0_OpenRAM_top.Inst_OpenRAM_top_switch_matrix.N1END0 net10 net146 net42
+ Tile_X0Y0_OpenRAM_top.Inst_OpenRAM_top_ConfigMem.Inst_frame6_bit21.Q Tile_X0Y0_OpenRAM_top.Inst_OpenRAM_top_ConfigMem.Inst_frame6_bit20.Q
+ VGND VGND VPWR VPWR Tile_X0Y0_OpenRAM_top.Inst_OpenRAM_top_switch_matrix.W1BEG0
+ sky130_fd_sc_hd__mux4_1
XPHY_EDGE_ROW_19_Left_202 VGND VGND VPWR VPWR sky130_fd_sc_hd__decap_3
XFILLER_54_215 VGND VGND VPWR VPWR sky130_fd_sc_hd__decap_3
X_0297_ net197 _0019_ _0064_ VGND VGND VPWR VPWR _0065_ sky130_fd_sc_hd__o21a_1
XFILLER_22_112 VGND VGND VPWR VPWR sky130_fd_sc_hd__decap_3
XFILLER_52_19 VGND VGND VPWR VPWR sky130_fd_sc_hd__decap_3
XFILLER_167_128 VGND VGND VPWR VPWR sky130_fd_sc_hd__decap_3
XFILLER_167_106 VGND VGND VPWR VPWR sky130_fd_sc_hd__decap_3
XFILLER_22_156 VGND VGND VPWR VPWR sky130_fd_sc_hd__decap_3
XPHY_EDGE_ROW_28_Left_211 VGND VGND VPWR VPWR sky130_fd_sc_hd__decap_3
XFILLER_175_161 VGND VGND VPWR VPWR sky130_fd_sc_hd__decap_3
XFILLER_108_206 VGND VGND VPWR VPWR sky130_fd_sc_hd__decap_3
XFILLER_175_172 VGND VGND VPWR VPWR sky130_fd_sc_hd__decap_3
XFILLER_117_23 VGND VGND VPWR VPWR sky130_fd_sc_hd__decap_3
XFILLER_117_78 VGND VGND VPWR VPWR sky130_fd_sc_hd__decap_3
XFILLER_77_27 VGND VGND VPWR VPWR sky130_fd_sc_hd__decap_3
XPHY_EDGE_ROW_37_Left_220 VGND VGND VPWR VPWR sky130_fd_sc_hd__decap_3
XFILLER_89_167 VGND VGND VPWR VPWR sky130_fd_sc_hd__fill_1
XFILLER_89_178 VGND VGND VPWR VPWR sky130_fd_sc_hd__decap_3
XFILLER_133_55 VGND VGND VPWR VPWR sky130_fd_sc_hd__fill_1
XFILLER_93_15 VGND VGND VPWR VPWR sky130_fd_sc_hd__decap_3
XFILLER_45_204 VGND VGND VPWR VPWR sky130_fd_sc_hd__decap_3
XFILLER_93_48 VGND VGND VPWR VPWR sky130_fd_sc_hd__decap_3
XFILLER_26_20 VGND VGND VPWR VPWR sky130_fd_sc_hd__decap_3
XFILLER_26_64 VGND VGND VPWR VPWR sky130_fd_sc_hd__decap_3
XFILLER_60_218 VGND VGND VPWR VPWR sky130_fd_sc_hd__decap_3
XFILLER_26_97 VGND VGND VPWR VPWR sky130_fd_sc_hd__decap_3
XFILLER_158_128 VGND VGND VPWR VPWR sky130_fd_sc_hd__decap_3
XFILLER_13_167 VGND VGND VPWR VPWR sky130_fd_sc_hd__fill_1
XFILLER_9_116 VGND VGND VPWR VPWR sky130_fd_sc_hd__decap_3
XFILLER_9_105 VGND VGND VPWR VPWR sky130_fd_sc_hd__decap_3
XFILLER_13_178 VGND VGND VPWR VPWR sky130_fd_sc_hd__decap_3
XFILLER_9_149 VGND VGND VPWR VPWR sky130_fd_sc_hd__decap_3
XFILLER_42_41 VGND VGND VPWR VPWR sky130_fd_sc_hd__decap_3
XFILLER_166_150 VGND VGND VPWR VPWR sky130_fd_sc_hd__decap_3
XFILLER_42_74 VGND VGND VPWR VPWR sky130_fd_sc_hd__decap_3
XFILLER_42_85 VGND VGND VPWR VPWR sky130_fd_sc_hd__fill_1
XFILLER_166_183 VGND VGND VPWR VPWR sky130_fd_sc_hd__decap_3
XFILLER_158_85 VGND VGND VPWR VPWR sky130_fd_sc_hd__decap_3
XFILLER_158_74 VGND VGND VPWR VPWR sky130_fd_sc_hd__decap_3
XFILLER_181_131 VGND VGND VPWR VPWR sky130_fd_sc_hd__decap_3
XFILLER_114_209 VGND VGND VPWR VPWR sky130_fd_sc_hd__decap_3
XFILLER_181_175 VGND VGND VPWR VPWR sky130_fd_sc_hd__decap_3
XFILLER_174_62 VGND VGND VPWR VPWR sky130_fd_sc_hd__decap_3
XFILLER_47_9 VGND VGND VPWR VPWR sky130_fd_sc_hd__fill_1
XFILLER_3_24 VGND VGND VPWR VPWR sky130_fd_sc_hd__decap_3
XFILLER_3_57 VGND VGND VPWR VPWR sky130_fd_sc_hd__decap_3
XFILLER_67_60 VGND VGND VPWR VPWR sky130_fd_sc_hd__decap_3
XFILLER_95_159 VGND VGND VPWR VPWR sky130_fd_sc_hd__decap_3
XTAP_TAPCELL_ROW_19_446 VGND VPWR sky130_fd_sc_hd__tapvpwrvgnd_1
XFILLER_51_229 VGND VGND VPWR VPWR sky130_fd_sc_hd__fill_1
XFILLER_83_81 VGND VGND VPWR VPWR sky130_fd_sc_hd__decap_3
XFILLER_149_128 VGND VGND VPWR VPWR sky130_fd_sc_hd__decap_3
XFILLER_80_3 VGND VGND VPWR VPWR sky130_fd_sc_hd__decap_3
X_0984_ net227 net333 VGND VGND VPWR VPWR Tile_X0Y1_OpenRAM_bot.Inst_OpenRAM_bot_ConfigMem.Inst_frame0_bit14.Q
+ sky130_fd_sc_hd__dlxtp_1
XFILLER_8_171 VGND VGND VPWR VPWR sky130_fd_sc_hd__decap_3
Xoutput402 net485 VGND VGND VPWR VPWR Tile_X0Y0_N2BEGb[4] sky130_fd_sc_hd__buf_2
XFILLER_172_153 VGND VGND VPWR VPWR sky130_fd_sc_hd__decap_3
Xoutput413 net496 VGND VGND VPWR VPWR Tile_X0Y0_N4BEG[1] sky130_fd_sc_hd__buf_2
XFILLER_172_186 VGND VGND VPWR VPWR sky130_fd_sc_hd__decap_3
Xoutput435 net518 VGND VGND VPWR VPWR Tile_X0Y0_W2BEGb[0] sky130_fd_sc_hd__buf_2
Xoutput424 net507 VGND VGND VPWR VPWR Tile_X0Y0_W1BEG[1] sky130_fd_sc_hd__buf_2
XFILLER_172_197 VGND VGND VPWR VPWR sky130_fd_sc_hd__decap_3
Xoutput446 net529 VGND VGND VPWR VPWR Tile_X0Y0_W6BEG[1] sky130_fd_sc_hd__buf_2
Xoutput457 net540 VGND VGND VPWR VPWR Tile_X0Y0_WW4BEG[11] sky130_fd_sc_hd__buf_2
Xoutput468 net551 VGND VGND VPWR VPWR Tile_X0Y0_WW4BEG[7] sky130_fd_sc_hd__buf_2
XFILLER_113_220 VGND VGND VPWR VPWR sky130_fd_sc_hd__decap_3
Xoutput479 net562 VGND VGND VPWR VPWR Tile_X0Y1_FrameData_O[17] sky130_fd_sc_hd__buf_2
X_1467_ Tile_X0Y1_OpenRAM_bot.Inst_OpenRAM_bot_switch_matrix.W2BEG1 VGND VGND VPWR
+ VPWR net627 sky130_fd_sc_hd__buf_1
XFILLER_86_115 VGND VGND VPWR VPWR sky130_fd_sc_hd__decap_3
X_0418_ net364 net169 Tile_X0Y0_OpenRAM_top.Inst_OpenRAM_top_switch_matrix.J_NS4_BEG8
+ Tile_X0Y0_OpenRAM_top.Inst_OpenRAM_top_switch_matrix.J_NS4_BEG12 Tile_X0Y0_OpenRAM_top.Inst_OpenRAM_top_ConfigMem.Inst_frame3_bit2.Q
+ Tile_X0Y0_OpenRAM_top.Inst_OpenRAM_top_ConfigMem.Inst_frame3_bit3.Q VGND VGND VPWR
+ VPWR Tile_X0Y0_OpenRAM_top.Inst_OpenRAM_top_switch_matrix.W6BEG3 sky130_fd_sc_hd__mux4_1
X_1398_ net248 VGND VGND VPWR VPWR net580 sky130_fd_sc_hd__buf_4
XFILLER_27_215 VGND VGND VPWR VPWR sky130_fd_sc_hd__decap_3
X_0349_ net355 net347 Tile_X0Y0_OpenRAM_top.Inst_OpenRAM_top_switch_matrix.S2BEG6
+ net164 Tile_X0Y1_OpenRAM_bot.Inst_OpenRAM_bot_ConfigMem.Inst_frame0_bit20.Q Tile_X0Y1_OpenRAM_bot.Inst_OpenRAM_bot_ConfigMem.Inst_frame0_bit21.Q
+ VGND VGND VPWR VPWR _0086_ sky130_fd_sc_hd__mux4_2
XFILLER_103_36 VGND VGND VPWR VPWR sky130_fd_sc_hd__decap_3
XPHY_EDGE_ROW_118_Right_118 VGND VGND VPWR VPWR sky130_fd_sc_hd__decap_3
XFILLER_42_218 VGND VGND VPWR VPWR sky130_fd_sc_hd__decap_3
XFILLER_179_18 VGND VGND VPWR VPWR sky130_fd_sc_hd__decap_3
XFILLER_10_115 VGND VGND VPWR VPWR sky130_fd_sc_hd__decap_3
XFILLER_10_159 VGND VGND VPWR VPWR sky130_fd_sc_hd__decap_3
XFILLER_148_183 VGND VGND VPWR VPWR sky130_fd_sc_hd__decap_3
XFILLER_128_55 VGND VGND VPWR VPWR sky130_fd_sc_hd__decap_3
XFILLER_12_88 VGND VGND VPWR VPWR sky130_fd_sc_hd__decap_3
XFILLER_12_77 VGND VGND VPWR VPWR sky130_fd_sc_hd__decap_3
XFILLER_128_88 VGND VGND VPWR VPWR sky130_fd_sc_hd__decap_3
XFILLER_88_15 VGND VGND VPWR VPWR sky130_fd_sc_hd__decap_3
XFILLER_88_59 VGND VGND VPWR VPWR sky130_fd_sc_hd__decap_3
XFILLER_144_54 VGND VGND VPWR VPWR sky130_fd_sc_hd__decap_3
XFILLER_77_137 VGND VGND VPWR VPWR sky130_fd_sc_hd__decap_3
XFILLER_77_159 VGND VGND VPWR VPWR sky130_fd_sc_hd__decap_3
XFILLER_18_215 VGND VGND VPWR VPWR sky130_fd_sc_hd__decap_3
XFILLER_37_30 VGND VGND VPWR VPWR sky130_fd_sc_hd__decap_3
XFILLER_160_53 VGND VGND VPWR VPWR sky130_fd_sc_hd__decap_3
XFILLER_37_63 VGND VGND VPWR VPWR sky130_fd_sc_hd__decap_3
XFILLER_85_181 VGND VGND VPWR VPWR sky130_fd_sc_hd__decap_3
XFILLER_37_96 VGND VGND VPWR VPWR sky130_fd_sc_hd__decap_3
XTAP_TAPCELL_ROW_56_596 VGND VPWR sky130_fd_sc_hd__tapvpwrvgnd_1
XTAP_TAPCELL_ROW_158_1003 VGND VPWR sky130_fd_sc_hd__tapvpwrvgnd_1
XFILLER_169_51 VGND VGND VPWR VPWR sky130_fd_sc_hd__decap_3
XFILLER_169_84 VGND VGND VPWR VPWR sky130_fd_sc_hd__decap_3
XFILLER_154_131 VGND VGND VPWR VPWR sky130_fd_sc_hd__decap_3
XFILLER_154_186 VGND VGND VPWR VPWR sky130_fd_sc_hd__decap_3
XFILLER_154_153 VGND VGND VPWR VPWR sky130_fd_sc_hd__decap_3
XFILLER_5_152 VGND VGND VPWR VPWR sky130_fd_sc_hd__decap_3
XFILLER_154_197 VGND VGND VPWR VPWR sky130_fd_sc_hd__decap_3
XFILLER_5_196 VGND VGND VPWR VPWR sky130_fd_sc_hd__decap_3
XFILLER_110_212 VGND VGND VPWR VPWR sky130_fd_sc_hd__fill_1
XFILLER_68_126 VGND VGND VPWR VPWR sky130_fd_sc_hd__decap_3
X_1321_ Tile_X0Y0_OpenRAM_top.Inst_OpenRAM_top_switch_matrix.N2BEGb0 VGND VGND VPWR
+ VPWR net481 sky130_fd_sc_hd__buf_4
X_1252_ net244 net266 VGND VGND VPWR VPWR Tile_X0Y1_OpenRAM_bot.Inst_OpenRAM_bot_ConfigMem.Inst_frame8_bit2.Q
+ sky130_fd_sc_hd__dlxtp_1
XFILLER_68_159 VGND VGND VPWR VPWR sky130_fd_sc_hd__decap_3
XTAP_TAPCELL_ROW_79_688 VGND VPWR sky130_fd_sc_hd__tapvpwrvgnd_1
X_1183_ net251 net280 VGND VGND VPWR VPWR Tile_X0Y1_OpenRAM_bot.Inst_OpenRAM_bot_ConfigMem.Inst_frame6_bit7.Q
+ sky130_fd_sc_hd__dlxtp_1
XFILLER_76_181 VGND VGND VPWR VPWR sky130_fd_sc_hd__decap_3
XFILLER_91_151 VGND VGND VPWR VPWR sky130_fd_sc_hd__decap_3
XFILLER_94_91 VGND VGND VPWR VPWR sky130_fd_sc_hd__decap_3
XFILLER_91_184 VGND VGND VPWR VPWR sky130_fd_sc_hd__fill_1
XFILLER_177_223 VGND VGND VPWR VPWR sky130_fd_sc_hd__fill_1
X_0967_ net246 net330 VGND VGND VPWR VPWR Tile_X0Y1_OpenRAM_bot.Inst_OpenRAM_bot_ConfigMem.Inst_frame0_bit31.Q
+ sky130_fd_sc_hd__dlxtp_1
XFILLER_160_101 VGND VGND VPWR VPWR sky130_fd_sc_hd__decap_3
X_0898_ net121 net282 VGND VGND VPWR VPWR Tile_X0Y0_OpenRAM_top.Inst_OpenRAM_top_ConfigMem.Inst_frame6_bit16.Q
+ sky130_fd_sc_hd__dlxtp_1
XPHY_EDGE_ROW_12_Right_12 VGND VGND VPWR VPWR sky130_fd_sc_hd__decap_3
XFILLER_145_186 VGND VGND VPWR VPWR sky130_fd_sc_hd__decap_3
XFILLER_160_156 VGND VGND VPWR VPWR sky130_fd_sc_hd__decap_3
XFILLER_58_29 VGND VGND VPWR VPWR sky130_fd_sc_hd__decap_3
XFILLER_160_189 VGND VGND VPWR VPWR sky130_fd_sc_hd__decap_3
XFILLER_59_137 VGND VGND VPWR VPWR sky130_fd_sc_hd__decap_3
Xoutput298 net381 VGND VGND VPWR VPWR CLK_A_SRAM sky130_fd_sc_hd__buf_1
Xoutput287 net370 VGND VGND VPWR VPWR ADDR_A_SRAM5 sky130_fd_sc_hd__buf_2
XFILLER_114_35 VGND VGND VPWR VPWR sky130_fd_sc_hd__decap_3
XFILLER_15_207 VGND VGND VPWR VPWR sky130_fd_sc_hd__decap_3
XPHY_EDGE_ROW_21_Right_21 VGND VGND VPWR VPWR sky130_fd_sc_hd__decap_3
XFILLER_82_173 VGND VGND VPWR VPWR sky130_fd_sc_hd__decap_3
XTAP_TAPCELL_ROW_105_792 VGND VPWR sky130_fd_sc_hd__tapvpwrvgnd_1
XFILLER_168_212 VGND VGND VPWR VPWR sky130_fd_sc_hd__decap_3
XFILLER_90_38 VGND VGND VPWR VPWR sky130_fd_sc_hd__decap_3
XFILLER_128_109 VGND VGND VPWR VPWR sky130_fd_sc_hd__decap_3
XFILLER_139_54 VGND VGND VPWR VPWR sky130_fd_sc_hd__fill_2
XFILLER_136_131 VGND VGND VPWR VPWR sky130_fd_sc_hd__decap_3
XFILLER_99_36 VGND VGND VPWR VPWR sky130_fd_sc_hd__decap_3
XFILLER_23_98 VGND VGND VPWR VPWR sky130_fd_sc_hd__decap_3
XPHY_EDGE_ROW_30_Right_30 VGND VGND VPWR VPWR sky130_fd_sc_hd__decap_3
XFILLER_136_153 VGND VGND VPWR VPWR sky130_fd_sc_hd__decap_3
XFILLER_99_69 VGND VGND VPWR VPWR sky130_fd_sc_hd__decap_3
XFILLER_2_100 VGND VGND VPWR VPWR sky130_fd_sc_hd__decap_3
XFILLER_2_133 VGND VGND VPWR VPWR sky130_fd_sc_hd__decap_3
XFILLER_171_63 VGND VGND VPWR VPWR sky130_fd_sc_hd__decap_3
XFILLER_171_30 VGND VGND VPWR VPWR sky130_fd_sc_hd__decap_3
XFILLER_48_62 VGND VGND VPWR VPWR sky130_fd_sc_hd__decap_3
XFILLER_171_96 VGND VGND VPWR VPWR sky130_fd_sc_hd__decap_3
XTAP_TAPCELL_ROW_128_884 VGND VPWR sky130_fd_sc_hd__tapvpwrvgnd_1
XFILLER_58_192 VGND VGND VPWR VPWR sky130_fd_sc_hd__decap_3
XFILLER_73_140 VGND VGND VPWR VPWR sky130_fd_sc_hd__decap_3
XFILLER_159_201 VGND VGND VPWR VPWR sky130_fd_sc_hd__decap_3
XFILLER_9_12 VGND VGND VPWR VPWR sky130_fd_sc_hd__decap_3
XFILLER_64_94 VGND VGND VPWR VPWR sky130_fd_sc_hd__decap_3
XFILLER_9_45 VGND VGND VPWR VPWR sky130_fd_sc_hd__decap_3
XFILLER_9_78 VGND VGND VPWR VPWR sky130_fd_sc_hd__decap_3
XFILLER_174_215 VGND VGND VPWR VPWR sky130_fd_sc_hd__decap_3
X_0821_ net135 net303 VGND VGND VPWR VPWR Tile_X0Y0_OpenRAM_top.Inst_OpenRAM_top_ConfigMem.Inst_frame4_bit29.Q
+ sky130_fd_sc_hd__dlxtp_1
XFILLER_127_142 VGND VGND VPWR VPWR sky130_fd_sc_hd__decap_3
X_0752_ net136 net326 VGND VGND VPWR VPWR Tile_X0Y0_OpenRAM_top.Inst_OpenRAM_top_ConfigMem.Inst_frame1_bit2.Q
+ sky130_fd_sc_hd__dlxtp_1
XTAP_TAPCELL_ROW_171_1055 VGND VPWR sky130_fd_sc_hd__tapvpwrvgnd_1
XFILLER_127_175 VGND VGND VPWR VPWR sky130_fd_sc_hd__decap_3
XFILLER_127_164 VGND VGND VPWR VPWR sky130_fd_sc_hd__decap_3
XFILLER_142_123 VGND VGND VPWR VPWR sky130_fd_sc_hd__fill_1
X_0683_ net355 net343 Tile_X0Y1_OpenRAM_bot.Inst_OpenRAM_bot_ConfigMem.Inst_frame3_bit12.Q
+ VGND VGND VPWR VPWR _0220_ sky130_fd_sc_hd__mux2_1
XFILLER_142_167 VGND VGND VPWR VPWR sky130_fd_sc_hd__fill_1
XFILLER_43_3 VGND VGND VPWR VPWR sky130_fd_sc_hd__fill_1
X_1304_ Tile_X0Y1_FrameStrobe[15] VGND VGND VPWR VPWR net455 sky130_fd_sc_hd__clkbuf_1
XFILLER_56_107 VGND VGND VPWR VPWR sky130_fd_sc_hd__decap_3
XFILLER_49_181 VGND VGND VPWR VPWR sky130_fd_sc_hd__fill_1
X_1235_ net232 net267 VGND VGND VPWR VPWR Tile_X0Y1_OpenRAM_bot.Inst_OpenRAM_bot_ConfigMem.Inst_frame8_bit19.Q
+ sky130_fd_sc_hd__dlxtp_1
X_1166_ net238 net278 VGND VGND VPWR VPWR Tile_X0Y1_OpenRAM_bot.Inst_OpenRAM_bot_ConfigMem.Inst_frame6_bit24.Q
+ sky130_fd_sc_hd__dlxtp_1
XTAP_TAPCELL_ROW_35_511 VGND VPWR sky130_fd_sc_hd__tapvpwrvgnd_1
XFILLER_64_184 VGND VGND VPWR VPWR sky130_fd_sc_hd__decap_3
X_1097_ net243 net297 VGND VGND VPWR VPWR Tile_X0Y1_OpenRAM_bot.Inst_OpenRAM_bot_ConfigMem.Inst_frame4_bit29.Q
+ sky130_fd_sc_hd__dlxtp_1
XFILLER_100_15 VGND VGND VPWR VPWR sky130_fd_sc_hd__decap_3
XFILLER_20_221 VGND VGND VPWR VPWR sky130_fd_sc_hd__decap_3
XFILLER_118_120 VGND VGND VPWR VPWR sky130_fd_sc_hd__decap_3
XFILLER_118_153 VGND VGND VPWR VPWR sky130_fd_sc_hd__decap_3
XFILLER_109_24 VGND VGND VPWR VPWR sky130_fd_sc_hd__decap_3
XFILLER_133_134 VGND VGND VPWR VPWR sky130_fd_sc_hd__decap_3
XFILLER_118_197 VGND VGND VPWR VPWR sky130_fd_sc_hd__fill_2
XFILLER_118_186 VGND VGND VPWR VPWR sky130_fd_sc_hd__decap_3
XFILLER_109_57 VGND VGND VPWR VPWR sky130_fd_sc_hd__decap_3
XFILLER_133_178 VGND VGND VPWR VPWR sky130_fd_sc_hd__decap_3
XFILLER_87_221 VGND VGND VPWR VPWR sky130_fd_sc_hd__decap_3
XFILLER_125_78 VGND VGND VPWR VPWR sky130_fd_sc_hd__decap_3
XPHY_EDGE_ROW_10_Left_193 VGND VGND VPWR VPWR sky130_fd_sc_hd__decap_3
XTAP_TAPCELL_ROW_58_603 VGND VPWR sky130_fd_sc_hd__tapvpwrvgnd_1
XFILLER_85_27 VGND VGND VPWR VPWR sky130_fd_sc_hd__decap_3
XFILLER_18_32 VGND VGND VPWR VPWR sky130_fd_sc_hd__decap_3
XFILLER_18_21 VGND VGND VPWR VPWR sky130_fd_sc_hd__decap_3
XPHY_EDGE_ROW_170_Right_170 VGND VGND VPWR VPWR sky130_fd_sc_hd__decap_3
XFILLER_141_55 VGND VGND VPWR VPWR sky130_fd_sc_hd__fill_1
XFILLER_141_22 VGND VGND VPWR VPWR sky130_fd_sc_hd__decap_3
XFILLER_55_151 VGND VGND VPWR VPWR sky130_fd_sc_hd__decap_3
XFILLER_70_187 VGND VGND VPWR VPWR sky130_fd_sc_hd__decap_3
XTAP_TAPCELL_ROW_41_536 VGND VPWR sky130_fd_sc_hd__tapvpwrvgnd_1
XTAP_TAPCELL_ROW_81_694 VGND VPWR sky130_fd_sc_hd__tapvpwrvgnd_1
XFILLER_7_214 VGND VGND VPWR VPWR sky130_fd_sc_hd__decap_3
XFILLER_7_225 VGND VGND VPWR VPWR sky130_fd_sc_hd__decap_3
XFILLER_50_41 VGND VGND VPWR VPWR sky130_fd_sc_hd__decap_3
XFILLER_166_41 VGND VGND VPWR VPWR sky130_fd_sc_hd__decap_3
XFILLER_50_74 VGND VGND VPWR VPWR sky130_fd_sc_hd__decap_3
XFILLER_50_85 VGND VGND VPWR VPWR sky130_fd_sc_hd__decap_3
XFILLER_166_85 VGND VGND VPWR VPWR sky130_fd_sc_hd__decap_3
XFILLER_109_175 VGND VGND VPWR VPWR sky130_fd_sc_hd__decap_3
XFILLER_124_156 VGND VGND VPWR VPWR sky130_fd_sc_hd__decap_3
XFILLER_78_221 VGND VGND VPWR VPWR sky130_fd_sc_hd__decap_3
XFILLER_15_7 VGND VGND VPWR VPWR sky130_fd_sc_hd__decap_3
X_1020_ net223 net322 VGND VGND VPWR VPWR Tile_X0Y1_OpenRAM_bot.Inst_OpenRAM_bot_ConfigMem.Inst_frame1_bit10.Q
+ sky130_fd_sc_hd__dlxtp_1
XFILLER_75_82 VGND VGND VPWR VPWR sky130_fd_sc_hd__decap_3
XFILLER_46_162 VGND VGND VPWR VPWR sky130_fd_sc_hd__fill_1
XTAP_TAPCELL_ROW_64_628 VGND VPWR sky130_fd_sc_hd__tapvpwrvgnd_1
XTAP_TAPCELL_ROW_72_661 VGND VPWR sky130_fd_sc_hd__tapvpwrvgnd_1
X_0804_ net119 net308 VGND VGND VPWR VPWR Tile_X0Y0_OpenRAM_top.Inst_OpenRAM_top_ConfigMem.Inst_frame3_bit14.Q
+ sky130_fd_sc_hd__dlxtp_1
XFILLER_162_218 VGND VGND VPWR VPWR sky130_fd_sc_hd__fill_1
X_0735_ net124 net329 VGND VGND VPWR VPWR Tile_X0Y0_OpenRAM_top.Inst_OpenRAM_top_ConfigMem.Inst_frame1_bit19.Q
+ sky130_fd_sc_hd__dlxtp_1
XFILLER_115_167 VGND VGND VPWR VPWR sky130_fd_sc_hd__fill_1
X_0666_ Tile_X0Y1_OpenRAM_bot.Inst_OpenRAM_bot_switch_matrix.J_NS4_BEG14 _0086_ Tile_X0Y1_OpenRAM_bot.Inst_OpenRAM_bot_ConfigMem.Inst_frame6_bit2.Q
+ VGND VGND VPWR VPWR _0205_ sky130_fd_sc_hd__mux2_1
XFILLER_130_137 VGND VGND VPWR VPWR sky130_fd_sc_hd__decap_3
X_0597_ net189 Tile_X0Y1_OpenRAM_bot.Inst_OpenRAM_bot_ConfigMem.Inst_frame3_bit26.Q
+ Tile_X0Y1_OpenRAM_bot.Inst_OpenRAM_bot_ConfigMem.Inst_frame3_bit27.Q VGND VGND VPWR
+ VPWR _0163_ sky130_fd_sc_hd__o21ba_1
X_1218_ net248 net272 VGND VGND VPWR VPWR Tile_X0Y1_OpenRAM_bot.Inst_OpenRAM_bot_ConfigMem.Inst_frame7_bit4.Q
+ sky130_fd_sc_hd__dlxtp_1
XTAP_TAPCELL_ROW_95_753 VGND VPWR sky130_fd_sc_hd__tapvpwrvgnd_1
XFILLER_1_90 VGND VGND VPWR VPWR sky130_fd_sc_hd__decap_3
XFILLER_37_184 VGND VGND VPWR VPWR sky130_fd_sc_hd__decap_3
XFILLER_111_36 VGND VGND VPWR VPWR sky130_fd_sc_hd__decap_3
X_1149_ net253 net287 VGND VGND VPWR VPWR Tile_X0Y1_OpenRAM_bot.Inst_OpenRAM_bot_ConfigMem.Inst_frame5_bit9.Q
+ sky130_fd_sc_hd__dlxtp_1
XFILLER_111_69 VGND VGND VPWR VPWR sky130_fd_sc_hd__decap_3
XFILLER_71_18 VGND VGND VPWR VPWR sky130_fd_sc_hd__decap_3
XTAP_TAPCELL_ROW_130_890 VGND VPWR sky130_fd_sc_hd__tapvpwrvgnd_1
XFILLER_4_206 VGND VGND VPWR VPWR sky130_fd_sc_hd__decap_3
XFILLER_106_112 VGND VGND VPWR VPWR sky130_fd_sc_hd__decap_3
XFILLER_136_44 VGND VGND VPWR VPWR sky130_fd_sc_hd__decap_3
XFILLER_106_156 VGND VGND VPWR VPWR sky130_fd_sc_hd__decap_3
XFILLER_20_77 VGND VGND VPWR VPWR sky130_fd_sc_hd__decap_3
XFILLER_20_55 VGND VGND VPWR VPWR sky130_fd_sc_hd__decap_3
XFILLER_136_77 VGND VGND VPWR VPWR sky130_fd_sc_hd__decap_3
XFILLER_20_88 VGND VGND VPWR VPWR sky130_fd_sc_hd__decap_3
XFILLER_96_26 VGND VGND VPWR VPWR sky130_fd_sc_hd__fill_2
XFILLER_136_88 VGND VGND VPWR VPWR sky130_fd_sc_hd__decap_3
XFILLER_29_20 VGND VGND VPWR VPWR sky130_fd_sc_hd__decap_3
XFILLER_29_42 VGND VGND VPWR VPWR sky130_fd_sc_hd__decap_3
XFILLER_152_65 VGND VGND VPWR VPWR sky130_fd_sc_hd__decap_3
XTAP_TAPCELL_ROW_153_982 VGND VPWR sky130_fd_sc_hd__tapvpwrvgnd_1
XTAP_TAPCELL_ROW_113_824 VGND VPWR sky130_fd_sc_hd__tapvpwrvgnd_1
XFILLER_43_143 VGND VGND VPWR VPWR sky130_fd_sc_hd__decap_3
XFILLER_45_41 VGND VGND VPWR VPWR sky130_fd_sc_hd__decap_3
XFILLER_43_198 VGND VGND VPWR VPWR sky130_fd_sc_hd__decap_3
XFILLER_129_204 VGND VGND VPWR VPWR sky130_fd_sc_hd__decap_3
XFILLER_177_51 VGND VGND VPWR VPWR sky130_fd_sc_hd__decap_3
XFILLER_61_84 VGND VGND VPWR VPWR sky130_fd_sc_hd__decap_3
XFILLER_77_9 VGND VGND VPWR VPWR sky130_fd_sc_hd__decap_3
XFILLER_144_218 VGND VGND VPWR VPWR sky130_fd_sc_hd__decap_3
XFILLER_6_24 VGND VGND VPWR VPWR sky130_fd_sc_hd__decap_3
XFILLER_6_35 VGND VGND VPWR VPWR sky130_fd_sc_hd__decap_3
XFILLER_6_68 VGND VGND VPWR VPWR sky130_fd_sc_hd__decap_3
X_0520_ net191 net195 net183 net261 Tile_X0Y1_OpenRAM_bot.Inst_OpenRAM_bot_ConfigMem.Inst_frame7_bit17.Q
+ Tile_X0Y1_OpenRAM_bot.Inst_OpenRAM_bot_ConfigMem.Inst_frame7_bit16.Q VGND VGND VPWR
+ VPWR Tile_X0Y1_OpenRAM_bot.Inst_OpenRAM_bot_switch_matrix.S2BEG2 sky130_fd_sc_hd__mux4_1
XFILLER_112_159 VGND VGND VPWR VPWR sky130_fd_sc_hd__decap_3
XFILLER_112_137 VGND VGND VPWR VPWR sky130_fd_sc_hd__decap_3
X_0451_ net80 net257 Tile_X0Y0_OpenRAM_top.Inst_OpenRAM_top_ConfigMem.Inst_frame2_bit29.Q
+ VGND VGND VPWR VPWR _0101_ sky130_fd_sc_hd__mux2_1
X_0382_ net23 net55 net256 Tile_X0Y0_OpenRAM_top.Inst_OpenRAM_top_switch_matrix.J_NS2_BEG4
+ Tile_X0Y0_OpenRAM_top.Inst_OpenRAM_top_ConfigMem.Inst_frame5_bit20.Q Tile_X0Y0_OpenRAM_top.Inst_OpenRAM_top_ConfigMem.Inst_frame5_bit21.Q
+ VGND VGND VPWR VPWR Tile_X0Y0_OpenRAM_top.Inst_OpenRAM_top_switch_matrix.W2BEGb4
+ sky130_fd_sc_hd__mux4_1
XTAP_TAPCELL_ROW_136_916 VGND VPWR sky130_fd_sc_hd__tapvpwrvgnd_1
XFILLER_86_70 VGND VGND VPWR VPWR sky130_fd_sc_hd__decap_3
XFILLER_19_140 VGND VGND VPWR VPWR sky130_fd_sc_hd__decap_3
X_1003_ net241 net324 VGND VGND VPWR VPWR Tile_X0Y1_OpenRAM_bot.Inst_OpenRAM_bot_ConfigMem.Inst_frame1_bit27.Q
+ sky130_fd_sc_hd__dlxtp_1
XFILLER_19_184 VGND VGND VPWR VPWR sky130_fd_sc_hd__decap_3
XFILLER_179_159 VGND VGND VPWR VPWR sky130_fd_sc_hd__fill_2
XFILLER_135_218 VGND VGND VPWR VPWR sky130_fd_sc_hd__decap_3
XPHY_EDGE_ROW_6_Right_6 VGND VGND VPWR VPWR sky130_fd_sc_hd__decap_3
X_0718_ net140 net334 VGND VGND VPWR VPWR Tile_X0Y0_OpenRAM_top.Inst_OpenRAM_top_ConfigMem.Inst_frame0_bit4.Q
+ sky130_fd_sc_hd__dlxtp_1
XFILLER_103_104 VGND VGND VPWR VPWR sky130_fd_sc_hd__decap_3
XFILLER_106_14 VGND VGND VPWR VPWR sky130_fd_sc_hd__decap_3
X_0649_ Tile_X0Y1_OpenRAM_bot.Inst_OpenRAM_bot_ConfigMem.Inst_frame7_bit2.Q _0190_
+ Tile_X0Y1_OpenRAM_bot.Inst_OpenRAM_bot_ConfigMem.Inst_frame7_bit3.Q VGND VGND VPWR
+ VPWR _0191_ sky130_fd_sc_hd__a21bo_1
XFILLER_106_47 VGND VGND VPWR VPWR sky130_fd_sc_hd__decap_3
XFILLER_66_29 VGND VGND VPWR VPWR sky130_fd_sc_hd__decap_3
XFILLER_181_9 VGND VGND VPWR VPWR sky130_fd_sc_hd__decap_3
XFILLER_122_35 VGND VGND VPWR VPWR sky130_fd_sc_hd__decap_3
XFILLER_122_68 VGND VGND VPWR VPWR sky130_fd_sc_hd__decap_3
XFILLER_15_22 VGND VGND VPWR VPWR sky130_fd_sc_hd__decap_3
XFILLER_25_143 VGND VGND VPWR VPWR sky130_fd_sc_hd__decap_3
XFILLER_15_66 VGND VGND VPWR VPWR sky130_fd_sc_hd__decap_3
XFILLER_25_187 VGND VGND VPWR VPWR sky130_fd_sc_hd__decap_3
XFILLER_40_124 VGND VGND VPWR VPWR sky130_fd_sc_hd__decap_3
XFILLER_40_168 VGND VGND VPWR VPWR sky130_fd_sc_hd__decap_3
XFILLER_178_192 VGND VGND VPWR VPWR sky130_fd_sc_hd__decap_3
XFILLER_147_43 VGND VGND VPWR VPWR sky130_fd_sc_hd__decap_3
XFILLER_147_87 VGND VGND VPWR VPWR sky130_fd_sc_hd__decap_3
XFILLER_31_87 VGND VGND VPWR VPWR sky130_fd_sc_hd__fill_1
Xinput110 Tile_X0Y0_EE4END[6] VGND VGND VPWR VPWR net110 sky130_fd_sc_hd__clkbuf_1
Xinput154 Tile_X0Y0_S2END[4] VGND VGND VPWR VPWR net154 sky130_fd_sc_hd__clkbuf_2
Xinput132 Tile_X0Y0_FrameData[26] VGND VGND VPWR VPWR net132 sky130_fd_sc_hd__clkbuf_4
Xinput121 Tile_X0Y0_FrameData[16] VGND VGND VPWR VPWR net121 sky130_fd_sc_hd__buf_4
Xinput143 Tile_X0Y0_FrameData[7] VGND VGND VPWR VPWR net143 sky130_fd_sc_hd__buf_2
XFILLER_48_224 VGND VGND VPWR VPWR sky130_fd_sc_hd__decap_3
Xinput165 Tile_X0Y0_S2MID[7] VGND VGND VPWR VPWR net165 sky130_fd_sc_hd__buf_2
Xinput176 Tile_X0Y1_E1END[2] VGND VGND VPWR VPWR net176 sky130_fd_sc_hd__clkbuf_2
Xinput187 Tile_X0Y1_E2MID[1] VGND VGND VPWR VPWR net187 sky130_fd_sc_hd__buf_2
Xinput198 Tile_X0Y1_E6END[2] VGND VGND VPWR VPWR net198 sky130_fd_sc_hd__clkbuf_2
XFILLER_56_73 VGND VGND VPWR VPWR sky130_fd_sc_hd__decap_3
XFILLER_63_205 VGND VGND VPWR VPWR sky130_fd_sc_hd__decap_3
XFILLER_16_121 VGND VGND VPWR VPWR sky130_fd_sc_hd__decap_3
XFILLER_16_165 VGND VGND VPWR VPWR sky130_fd_sc_hd__decap_3
XFILLER_31_113 VGND VGND VPWR VPWR sky130_fd_sc_hd__decap_3
XFILLER_176_118 VGND VGND VPWR VPWR sky130_fd_sc_hd__decap_3
XFILLER_31_146 VGND VGND VPWR VPWR sky130_fd_sc_hd__fill_2
XFILLER_72_83 VGND VGND VPWR VPWR sky130_fd_sc_hd__fill_1
XFILLER_169_181 VGND VGND VPWR VPWR sky130_fd_sc_hd__decap_3
XPHY_EDGE_ROW_59_Right_59 VGND VGND VPWR VPWR sky130_fd_sc_hd__decap_3
XFILLER_117_218 VGND VGND VPWR VPWR sky130_fd_sc_hd__decap_3
XFILLER_140_221 VGND VGND VPWR VPWR sky130_fd_sc_hd__decap_3
X_0503_ net103 Tile_X0Y0_OpenRAM_top.Inst_OpenRAM_top_switch_matrix.J_NS4_BEG10 _0096_
+ Tile_X0Y0_OpenRAM_top.Inst_OpenRAM_top_switch_matrix.J_NS2_BEG6 Tile_X0Y0_OpenRAM_top.Inst_OpenRAM_top_ConfigMem.Inst_frame6_bit16.Q
+ Tile_X0Y0_OpenRAM_top.Inst_OpenRAM_top_ConfigMem.Inst_frame6_bit15.Q VGND VGND VPWR
+ VPWR _0141_ sky130_fd_sc_hd__mux4_1
X_1483_ Tile_X0Y1_OpenRAM_bot.Inst_OpenRAM_bot_switch_matrix.W6BEG1 VGND VGND VPWR
+ VPWR net645 sky130_fd_sc_hd__buf_1
X_0434_ net111 net104 net95 Tile_X0Y0_OpenRAM_top.Inst_OpenRAM_top_switch_matrix.J_NS4_BEG7
+ Tile_X0Y0_OpenRAM_top.Inst_OpenRAM_top_ConfigMem.Inst_frame2_bit2.Q Tile_X0Y0_OpenRAM_top.Inst_OpenRAM_top_ConfigMem.Inst_frame2_bit3.Q
+ VGND VGND VPWR VPWR net401 sky130_fd_sc_hd__mux4_1
XFILLER_100_118 VGND VGND VPWR VPWR sky130_fd_sc_hd__decap_3
XPHY_EDGE_ROW_68_Right_68 VGND VGND VPWR VPWR sky130_fd_sc_hd__decap_3
X_0365_ net174 Tile_X0Y1_OpenRAM_bot.Inst_OpenRAM_bot_switch_matrix.J_NS4_BEG12 net200
+ _0094_ Tile_X0Y1_OpenRAM_bot.Inst_OpenRAM_bot_ConfigMem.Inst_frame8_bit1.Q Tile_X0Y1_OpenRAM_bot.Inst_OpenRAM_bot_ConfigMem.Inst_frame8_bit0.Q
+ VGND VGND VPWR VPWR Tile_X0Y0_OpenRAM_top.Inst_OpenRAM_top_switch_matrix.N1END0
+ sky130_fd_sc_hd__mux4_2
X_0296_ net255 Tile_X0Y1_OpenRAM_bot.Inst_OpenRAM_bot_ConfigMem.Inst_frame0_bit26.Q
+ Tile_X0Y1_OpenRAM_bot.Inst_OpenRAM_bot_ConfigMem.Inst_frame0_bit27.Q VGND VGND VPWR
+ VPWR _0064_ sky130_fd_sc_hd__o21ba_1
XFILLER_22_124 VGND VGND VPWR VPWR sky130_fd_sc_hd__decap_3
XPHY_EDGE_ROW_77_Right_77 VGND VGND VPWR VPWR sky130_fd_sc_hd__decap_3
XFILLER_175_140 VGND VGND VPWR VPWR sky130_fd_sc_hd__decap_3
XFILLER_175_184 VGND VGND VPWR VPWR sky130_fd_sc_hd__decap_3
XFILLER_108_218 VGND VGND VPWR VPWR sky130_fd_sc_hd__decap_3
XFILLER_117_35 VGND VGND VPWR VPWR sky130_fd_sc_hd__decap_3
XFILLER_89_102 VGND VGND VPWR VPWR sky130_fd_sc_hd__decap_3
XFILLER_89_113 VGND VGND VPWR VPWR sky130_fd_sc_hd__decap_3
XFILLER_131_221 VGND VGND VPWR VPWR sky130_fd_sc_hd__decap_3
XFILLER_117_57 VGND VGND VPWR VPWR sky130_fd_sc_hd__decap_3
XFILLER_7_9 VGND VGND VPWR VPWR sky130_fd_sc_hd__decap_3
XFILLER_89_146 VGND VGND VPWR VPWR sky130_fd_sc_hd__decap_3
XFILLER_77_39 VGND VGND VPWR VPWR sky130_fd_sc_hd__decap_3
XPHY_EDGE_ROW_86_Right_86 VGND VGND VPWR VPWR sky130_fd_sc_hd__decap_3
XFILLER_133_23 VGND VGND VPWR VPWR sky130_fd_sc_hd__decap_3
XFILLER_133_78 VGND VGND VPWR VPWR sky130_fd_sc_hd__decap_3
XFILLER_45_216 VGND VGND VPWR VPWR sky130_fd_sc_hd__decap_3
XFILLER_93_27 VGND VGND VPWR VPWR sky130_fd_sc_hd__decap_3
XFILLER_26_32 VGND VGND VPWR VPWR sky130_fd_sc_hd__decap_3
XFILLER_13_113 VGND VGND VPWR VPWR sky130_fd_sc_hd__decap_3
XFILLER_26_76 VGND VGND VPWR VPWR sky130_fd_sc_hd__decap_3
XPHY_EDGE_ROW_95_Right_95 VGND VGND VPWR VPWR sky130_fd_sc_hd__decap_3
XFILLER_9_128 VGND VGND VPWR VPWR sky130_fd_sc_hd__decap_3
XFILLER_42_53 VGND VGND VPWR VPWR sky130_fd_sc_hd__decap_3
XFILLER_21_190 VGND VGND VPWR VPWR sky130_fd_sc_hd__decap_3
XFILLER_166_162 VGND VGND VPWR VPWR sky130_fd_sc_hd__decap_3
XFILLER_166_195 VGND VGND VPWR VPWR sky130_fd_sc_hd__fill_1
XFILLER_158_97 VGND VGND VPWR VPWR sky130_fd_sc_hd__decap_3
XFILLER_181_165 VGND VGND VPWR VPWR sky130_fd_sc_hd__decap_3
XFILLER_174_41 VGND VGND VPWR VPWR sky130_fd_sc_hd__decap_3
XFILLER_174_74 VGND VGND VPWR VPWR sky130_fd_sc_hd__decap_3
XPHY_EDGE_ROW_2_Left_185 VGND VGND VPWR VPWR sky130_fd_sc_hd__decap_3
XFILLER_174_85 VGND VGND VPWR VPWR sky130_fd_sc_hd__decap_3
XFILLER_3_36 VGND VGND VPWR VPWR sky130_fd_sc_hd__decap_3
XFILLER_107_90 VGND VGND VPWR VPWR sky130_fd_sc_hd__decap_3
XFILLER_3_69 VGND VGND VPWR VPWR sky130_fd_sc_hd__decap_3
XFILLER_95_116 VGND VGND VPWR VPWR sky130_fd_sc_hd__decap_3
XFILLER_95_127 VGND VGND VPWR VPWR sky130_fd_sc_hd__decap_3
XTAP_TAPCELL_ROW_19_447 VGND VPWR sky130_fd_sc_hd__tapvpwrvgnd_1
XFILLER_51_208 VGND VGND VPWR VPWR sky130_fd_sc_hd__decap_3
XFILLER_83_60 VGND VGND VPWR VPWR sky130_fd_sc_hd__decap_3
XTAP_TAPCELL_ROW_27_480 VGND VPWR sky130_fd_sc_hd__tapvpwrvgnd_1
XFILLER_83_93 VGND VGND VPWR VPWR sky130_fd_sc_hd__decap_3
X_0983_ net228 net333 VGND VGND VPWR VPWR Tile_X0Y1_OpenRAM_bot.Inst_OpenRAM_bot_ConfigMem.Inst_frame0_bit15.Q
+ sky130_fd_sc_hd__dlxtp_1
XFILLER_12_190 VGND VGND VPWR VPWR sky130_fd_sc_hd__decap_3
XFILLER_157_184 VGND VGND VPWR VPWR sky130_fd_sc_hd__decap_3
XFILLER_157_162 VGND VGND VPWR VPWR sky130_fd_sc_hd__decap_3
XFILLER_8_150 VGND VGND VPWR VPWR sky130_fd_sc_hd__decap_3
XFILLER_172_121 VGND VGND VPWR VPWR sky130_fd_sc_hd__decap_3
XFILLER_8_183 VGND VGND VPWR VPWR sky130_fd_sc_hd__decap_3
Xoutput403 net486 VGND VGND VPWR VPWR Tile_X0Y0_N2BEGb[5] sky130_fd_sc_hd__buf_2
Xoutput414 net497 VGND VGND VPWR VPWR Tile_X0Y0_N4BEG[2] sky130_fd_sc_hd__buf_2
XFILLER_172_165 VGND VGND VPWR VPWR sky130_fd_sc_hd__decap_3
Xoutput425 net508 VGND VGND VPWR VPWR Tile_X0Y0_W1BEG[2] sky130_fd_sc_hd__buf_2
Xoutput447 net530 VGND VGND VPWR VPWR Tile_X0Y0_W6BEG[2] sky130_fd_sc_hd__buf_2
Xoutput458 net541 VGND VGND VPWR VPWR Tile_X0Y0_WW4BEG[12] sky130_fd_sc_hd__buf_2
Xoutput469 net552 VGND VGND VPWR VPWR Tile_X0Y0_WW4BEG[8] sky130_fd_sc_hd__buf_2
Xoutput436 net519 VGND VGND VPWR VPWR Tile_X0Y0_W2BEGb[1] sky130_fd_sc_hd__buf_2
X_1466_ Tile_X0Y1_OpenRAM_bot.Inst_OpenRAM_bot_switch_matrix.W2BEG0 VGND VGND VPWR
+ VPWR net626 sky130_fd_sc_hd__buf_1
XFILLER_86_127 VGND VGND VPWR VPWR sky130_fd_sc_hd__decap_3
X_0417_ net363 net168 Tile_X0Y0_OpenRAM_top.Inst_OpenRAM_top_switch_matrix.J_NS4_BEG9
+ Tile_X0Y0_OpenRAM_top.Inst_OpenRAM_top_switch_matrix.J_NS4_BEG13 Tile_X0Y0_OpenRAM_top.Inst_OpenRAM_top_ConfigMem.Inst_frame3_bit0.Q
+ Tile_X0Y0_OpenRAM_top.Inst_OpenRAM_top_ConfigMem.Inst_frame3_bit1.Q VGND VGND VPWR
+ VPWR Tile_X0Y0_OpenRAM_top.Inst_OpenRAM_top_switch_matrix.W6BEG2 sky130_fd_sc_hd__mux4_1
X_1397_ net247 VGND VGND VPWR VPWR net579 sky130_fd_sc_hd__buf_6
XFILLER_86_149 VGND VGND VPWR VPWR sky130_fd_sc_hd__fill_1
X_0348_ net68 net79 net71 Tile_X0Y0_OpenRAM_top.Inst_OpenRAM_top_switch_matrix.J_NS2_BEG6
+ Tile_X0Y0_OpenRAM_top.Inst_OpenRAM_top_ConfigMem.Inst_frame6_bit4.Q Tile_X0Y0_OpenRAM_top.Inst_OpenRAM_top_ConfigMem.Inst_frame6_bit5.Q
+ VGND VGND VPWR VPWR Tile_X0Y0_OpenRAM_top.Inst_OpenRAM_top_switch_matrix.S2BEG6
+ sky130_fd_sc_hd__mux4_1
XFILLER_103_15 VGND VGND VPWR VPWR sky130_fd_sc_hd__decap_3
XFILLER_94_171 VGND VGND VPWR VPWR sky130_fd_sc_hd__decap_3
X_0279_ _0046_ _0047_ Tile_X0Y1_OpenRAM_bot.Inst_OpenRAM_bot_ConfigMem.Inst_frame2_bit28.Q
+ VGND VGND VPWR VPWR _0048_ sky130_fd_sc_hd__or3b_1
XFILLER_10_127 VGND VGND VPWR VPWR sky130_fd_sc_hd__decap_3
XFILLER_148_162 VGND VGND VPWR VPWR sky130_fd_sc_hd__decap_3
XFILLER_6_109 VGND VGND VPWR VPWR sky130_fd_sc_hd__decap_3
XFILLER_148_195 VGND VGND VPWR VPWR sky130_fd_sc_hd__fill_1
XFILLER_128_23 VGND VGND VPWR VPWR sky130_fd_sc_hd__decap_3
XFILLER_12_56 VGND VGND VPWR VPWR sky130_fd_sc_hd__decap_3
XFILLER_128_67 VGND VGND VPWR VPWR sky130_fd_sc_hd__decap_3
XFILLER_88_27 VGND VGND VPWR VPWR sky130_fd_sc_hd__fill_1
XFILLER_163_187 VGND VGND VPWR VPWR sky130_fd_sc_hd__decap_3
XFILLER_104_221 VGND VGND VPWR VPWR sky130_fd_sc_hd__decap_3
XFILLER_5_6 VGND VGND VPWR VPWR sky130_fd_sc_hd__decap_3
XFILLER_88_38 VGND VGND VPWR VPWR sky130_fd_sc_hd__decap_3
XFILLER_144_33 VGND VGND VPWR VPWR sky130_fd_sc_hd__decap_3
XFILLER_144_22 VGND VGND VPWR VPWR sky130_fd_sc_hd__decap_3
XFILLER_144_66 VGND VGND VPWR VPWR sky130_fd_sc_hd__decap_3
XFILLER_77_116 VGND VGND VPWR VPWR sky130_fd_sc_hd__decap_3
XFILLER_37_42 VGND VGND VPWR VPWR sky130_fd_sc_hd__decap_3
XFILLER_160_32 VGND VGND VPWR VPWR sky130_fd_sc_hd__decap_3
XFILLER_160_21 VGND VGND VPWR VPWR sky130_fd_sc_hd__decap_3
XFILLER_18_227 VGND VGND VPWR VPWR sky130_fd_sc_hd__decap_3
XFILLER_37_75 VGND VGND VPWR VPWR sky130_fd_sc_hd__decap_3
XFILLER_85_193 VGND VGND VPWR VPWR sky130_fd_sc_hd__decap_3
XFILLER_33_208 VGND VGND VPWR VPWR sky130_fd_sc_hd__decap_3
XTAP_TAPCELL_ROW_56_597 VGND VPWR sky130_fd_sc_hd__tapvpwrvgnd_1
XFILLER_169_30 VGND VGND VPWR VPWR sky130_fd_sc_hd__decap_3
XFILLER_53_30 VGND VGND VPWR VPWR sky130_fd_sc_hd__decap_3
XFILLER_169_63 VGND VGND VPWR VPWR sky130_fd_sc_hd__decap_3
XTAP_TAPCELL_ROW_158_1004 VGND VPWR sky130_fd_sc_hd__tapvpwrvgnd_1
XFILLER_169_96 VGND VGND VPWR VPWR sky130_fd_sc_hd__decap_3
XFILLER_154_110 VGND VGND VPWR VPWR sky130_fd_sc_hd__decap_3
XFILLER_139_151 VGND VGND VPWR VPWR sky130_fd_sc_hd__decap_3
XFILLER_139_195 VGND VGND VPWR VPWR sky130_fd_sc_hd__decap_3
XFILLER_5_131 VGND VGND VPWR VPWR sky130_fd_sc_hd__decap_3
XFILLER_154_165 VGND VGND VPWR VPWR sky130_fd_sc_hd__decap_3
XFILLER_5_164 VGND VGND VPWR VPWR sky130_fd_sc_hd__decap_3
XFILLER_5_175 VGND VGND VPWR VPWR sky130_fd_sc_hd__decap_3
X_1320_ Tile_X0Y0_OpenRAM_top.Inst_OpenRAM_top_switch_matrix.N2BEG7 VGND VGND VPWR
+ VPWR net480 sky130_fd_sc_hd__clkbuf_2
XFILLER_68_105 VGND VGND VPWR VPWR sky130_fd_sc_hd__decap_3
XFILLER_78_71 VGND VGND VPWR VPWR sky130_fd_sc_hd__decap_3
X_1251_ net247 net266 VGND VGND VPWR VPWR Tile_X0Y1_OpenRAM_bot.Inst_OpenRAM_bot_ConfigMem.Inst_frame8_bit3.Q
+ sky130_fd_sc_hd__dlxtp_1
XFILLER_68_138 VGND VGND VPWR VPWR sky130_fd_sc_hd__fill_2
X_1182_ net252 net278 VGND VGND VPWR VPWR Tile_X0Y1_OpenRAM_bot.Inst_OpenRAM_bot_ConfigMem.Inst_frame6_bit8.Q
+ sky130_fd_sc_hd__dlxtp_1
XTAP_TAPCELL_ROW_79_689 VGND VPWR sky130_fd_sc_hd__tapvpwrvgnd_1
XFILLER_83_108 VGND VGND VPWR VPWR sky130_fd_sc_hd__decap_3
XFILLER_83_119 VGND VGND VPWR VPWR sky130_fd_sc_hd__decap_3
XFILLER_76_193 VGND VGND VPWR VPWR sky130_fd_sc_hd__decap_3
XPHY_EDGE_ROW_56_Left_239 VGND VGND VPWR VPWR sky130_fd_sc_hd__decap_3
XTAP_TAPCELL_ROW_180_1090 VGND VPWR sky130_fd_sc_hd__tapvpwrvgnd_1
XFILLER_177_202 VGND VGND VPWR VPWR sky130_fd_sc_hd__decap_3
X_0966_ net117 net269 VGND VGND VPWR VPWR Tile_X0Y0_OpenRAM_top.Inst_OpenRAM_top_ConfigMem.Inst_frame8_bit12.Q
+ sky130_fd_sc_hd__dlxtp_1
XFILLER_145_143 VGND VGND VPWR VPWR sky130_fd_sc_hd__fill_1
XPHY_EDGE_ROW_65_Left_248 VGND VGND VPWR VPWR sky130_fd_sc_hd__decap_3
X_0897_ net122 net284 VGND VGND VPWR VPWR Tile_X0Y0_OpenRAM_top.Inst_OpenRAM_top_ConfigMem.Inst_frame6_bit17.Q
+ sky130_fd_sc_hd__dlxtp_1
XFILLER_145_198 VGND VGND VPWR VPWR sky130_fd_sc_hd__decap_3
XFILLER_160_168 VGND VGND VPWR VPWR sky130_fd_sc_hd__decap_3
XPHY_EDGE_ROW_151_Right_151 VGND VGND VPWR VPWR sky130_fd_sc_hd__decap_3
Xoutput299 net382 VGND VGND VPWR VPWR CLK_B_SRAM sky130_fd_sc_hd__buf_1
XFILLER_59_105 VGND VGND VPWR VPWR sky130_fd_sc_hd__decap_3
XFILLER_59_116 VGND VGND VPWR VPWR sky130_fd_sc_hd__decap_3
Xoutput288 net371 VGND VGND VPWR VPWR ADDR_A_SRAM6 sky130_fd_sc_hd__buf_2
X_1449_ Tile_X0Y0_S4END[11] VGND VGND VPWR VPWR net615 sky130_fd_sc_hd__buf_6
XFILLER_59_149 VGND VGND VPWR VPWR sky130_fd_sc_hd__decap_3
XFILLER_67_182 VGND VGND VPWR VPWR sky130_fd_sc_hd__decap_3
XPHY_EDGE_ROW_74_Left_257 VGND VGND VPWR VPWR sky130_fd_sc_hd__decap_3
XFILLER_82_141 VGND VGND VPWR VPWR sky130_fd_sc_hd__decap_3
XFILLER_130_35 VGND VGND VPWR VPWR sky130_fd_sc_hd__decap_3
XFILLER_15_219 VGND VGND VPWR VPWR sky130_fd_sc_hd__decap_3
XFILLER_82_185 VGND VGND VPWR VPWR sky130_fd_sc_hd__decap_3
XFILLER_168_224 VGND VGND VPWR VPWR sky130_fd_sc_hd__decap_3
XFILLER_142_6 VGND VGND VPWR VPWR sky130_fd_sc_hd__fill_1
XTAP_TAPCELL_ROW_105_793 VGND VPWR sky130_fd_sc_hd__tapvpwrvgnd_1
XFILLER_139_33 VGND VGND VPWR VPWR sky130_fd_sc_hd__decap_3
XPHY_EDGE_ROW_83_Left_266 VGND VGND VPWR VPWR sky130_fd_sc_hd__decap_3
XFILLER_139_88 VGND VGND VPWR VPWR sky130_fd_sc_hd__decap_3
XFILLER_139_66 VGND VGND VPWR VPWR sky130_fd_sc_hd__decap_3
XFILLER_136_110 VGND VGND VPWR VPWR sky130_fd_sc_hd__decap_3
XFILLER_99_15 VGND VGND VPWR VPWR sky130_fd_sc_hd__decap_3
XFILLER_136_165 VGND VGND VPWR VPWR sky130_fd_sc_hd__decap_3
XFILLER_99_48 VGND VGND VPWR VPWR sky130_fd_sc_hd__decap_3
XFILLER_151_102 VGND VGND VPWR VPWR sky130_fd_sc_hd__decap_3
XFILLER_2_112 VGND VGND VPWR VPWR sky130_fd_sc_hd__decap_3
XFILLER_155_43 VGND VGND VPWR VPWR sky130_fd_sc_hd__decap_3
XFILLER_3_3 VGND VGND VPWR VPWR sky130_fd_sc_hd__decap_3
XFILLER_2_189 VGND VGND VPWR VPWR sky130_fd_sc_hd__decap_3
XFILLER_48_41 VGND VGND VPWR VPWR sky130_fd_sc_hd__decap_3
XFILLER_171_42 VGND VGND VPWR VPWR sky130_fd_sc_hd__decap_3
XFILLER_48_85 VGND VGND VPWR VPWR sky130_fd_sc_hd__decap_3
XFILLER_65_108 VGND VGND VPWR VPWR sky130_fd_sc_hd__decap_3
XFILLER_65_119 VGND VGND VPWR VPWR sky130_fd_sc_hd__decap_3
XPHY_EDGE_ROW_92_Left_275 VGND VGND VPWR VPWR sky130_fd_sc_hd__decap_3
XFILLER_171_75 VGND VGND VPWR VPWR sky130_fd_sc_hd__decap_3
XTAP_TAPCELL_ROW_128_885 VGND VPWR sky130_fd_sc_hd__tapvpwrvgnd_1
XFILLER_0_15 VGND VGND VPWR VPWR sky130_fd_sc_hd__fill_1
XFILLER_58_171 VGND VGND VPWR VPWR sky130_fd_sc_hd__decap_3
XFILLER_104_80 VGND VGND VPWR VPWR sky130_fd_sc_hd__decap_3
XFILLER_73_152 VGND VGND VPWR VPWR sky130_fd_sc_hd__decap_3
XFILLER_104_91 VGND VGND VPWR VPWR sky130_fd_sc_hd__decap_3
XFILLER_14_230 VGND VGND VPWR VPWR sky130_fd_sc_hd__fill_1
XFILLER_159_213 VGND VGND VPWR VPWR sky130_fd_sc_hd__decap_3
XFILLER_9_24 VGND VGND VPWR VPWR sky130_fd_sc_hd__decap_3
XTAP_TAPCELL_ROW_12_420 VGND VPWR sky130_fd_sc_hd__tapvpwrvgnd_1
XFILLER_9_57 VGND VGND VPWR VPWR sky130_fd_sc_hd__decap_3
XFILLER_174_227 VGND VGND VPWR VPWR sky130_fd_sc_hd__decap_3
X_0820_ net137 net302 VGND VGND VPWR VPWR Tile_X0Y0_OpenRAM_top.Inst_OpenRAM_top_ConfigMem.Inst_frame4_bit30.Q
+ sky130_fd_sc_hd__dlxtp_1
XFILLER_80_83 VGND VGND VPWR VPWR sky130_fd_sc_hd__fill_1
X_0751_ net139 net326 VGND VGND VPWR VPWR Tile_X0Y0_OpenRAM_top.Inst_OpenRAM_top_ConfigMem.Inst_frame1_bit3.Q
+ sky130_fd_sc_hd__dlxtp_1
XTAP_TAPCELL_ROW_171_1056 VGND VPWR sky130_fd_sc_hd__tapvpwrvgnd_1
XFILLER_127_187 VGND VGND VPWR VPWR sky130_fd_sc_hd__decap_3
X_0682_ net181 _0214_ VGND VGND VPWR VPWR _0219_ sky130_fd_sc_hd__nor2_1
XFILLER_89_81 VGND VGND VPWR VPWR sky130_fd_sc_hd__decap_3
X_1303_ Tile_X0Y1_FrameStrobe[14] VGND VGND VPWR VPWR net454 sky130_fd_sc_hd__buf_6
XFILLER_56_119 VGND VGND VPWR VPWR sky130_fd_sc_hd__decap_3
X_1234_ net234 net266 VGND VGND VPWR VPWR Tile_X0Y1_OpenRAM_bot.Inst_OpenRAM_bot_ConfigMem.Inst_frame8_bit20.Q
+ sky130_fd_sc_hd__dlxtp_1
X_1165_ net239 net278 VGND VGND VPWR VPWR Tile_X0Y1_OpenRAM_bot.Inst_OpenRAM_bot_ConfigMem.Inst_frame6_bit25.Q
+ sky130_fd_sc_hd__dlxtp_1
XFILLER_64_130 VGND VGND VPWR VPWR sky130_fd_sc_hd__decap_3
XFILLER_64_141 VGND VGND VPWR VPWR sky130_fd_sc_hd__decap_3
X_1096_ net245 net299 VGND VGND VPWR VPWR Tile_X0Y1_OpenRAM_bot.Inst_OpenRAM_bot_ConfigMem.Inst_frame4_bit30.Q
+ sky130_fd_sc_hd__dlxtp_1
XTAP_TAPCELL_ROW_35_512 VGND VPWR sky130_fd_sc_hd__tapvpwrvgnd_1
XTAP_TAPCELL_ROW_75_670 VGND VPWR sky130_fd_sc_hd__tapvpwrvgnd_1
XFILLER_100_27 VGND VGND VPWR VPWR sky130_fd_sc_hd__fill_1
XFILLER_100_38 VGND VGND VPWR VPWR sky130_fd_sc_hd__fill_2
XFILLER_20_200 VGND VGND VPWR VPWR sky130_fd_sc_hd__decap_3
XFILLER_165_205 VGND VGND VPWR VPWR sky130_fd_sc_hd__decap_3
XFILLER_118_132 VGND VGND VPWR VPWR sky130_fd_sc_hd__decap_3
X_0949_ net135 net268 VGND VGND VPWR VPWR Tile_X0Y0_OpenRAM_top.Inst_OpenRAM_top_ConfigMem.Inst_frame8_bit29.Q
+ sky130_fd_sc_hd__dlxtp_1
XFILLER_118_165 VGND VGND VPWR VPWR sky130_fd_sc_hd__decap_3
XFILLER_109_36 VGND VGND VPWR VPWR sky130_fd_sc_hd__decap_3
XFILLER_69_18 VGND VGND VPWR VPWR sky130_fd_sc_hd__decap_3
XFILLER_125_24 VGND VGND VPWR VPWR sky130_fd_sc_hd__decap_3
XTAP_TAPCELL_ROW_98_762 VGND VPWR sky130_fd_sc_hd__tapvpwrvgnd_1
XFILLER_47_119 VGND VGND VPWR VPWR sky130_fd_sc_hd__decap_3
XTAP_TAPCELL_ROW_58_604 VGND VPWR sky130_fd_sc_hd__tapvpwrvgnd_1
XFILLER_141_34 VGND VGND VPWR VPWR sky130_fd_sc_hd__decap_3
XFILLER_18_77 VGND VGND VPWR VPWR sky130_fd_sc_hd__decap_3
XFILLER_55_130 VGND VGND VPWR VPWR sky130_fd_sc_hd__decap_3
XFILLER_141_78 VGND VGND VPWR VPWR sky130_fd_sc_hd__decap_3
XFILLER_18_88 VGND VGND VPWR VPWR sky130_fd_sc_hd__fill_2
XFILLER_55_163 VGND VGND VPWR VPWR sky130_fd_sc_hd__decap_3
XFILLER_70_100 VGND VGND VPWR VPWR sky130_fd_sc_hd__decap_3
XFILLER_34_21 VGND VGND VPWR VPWR sky130_fd_sc_hd__decap_3
XFILLER_70_133 VGND VGND VPWR VPWR sky130_fd_sc_hd__decap_3
XFILLER_70_166 VGND VGND VPWR VPWR sky130_fd_sc_hd__fill_2
XTAP_TAPCELL_ROW_41_537 VGND VPWR sky130_fd_sc_hd__tapvpwrvgnd_1
XTAP_TAPCELL_ROW_81_695 VGND VPWR sky130_fd_sc_hd__tapvpwrvgnd_1
XFILLER_109_110 VGND VGND VPWR VPWR sky130_fd_sc_hd__fill_2
XFILLER_171_208 VGND VGND VPWR VPWR sky130_fd_sc_hd__decap_3
XFILLER_109_165 VGND VGND VPWR VPWR sky130_fd_sc_hd__decap_3
XFILLER_109_143 VGND VGND VPWR VPWR sky130_fd_sc_hd__decap_3
XFILLER_50_53 VGND VGND VPWR VPWR sky130_fd_sc_hd__decap_3
XFILLER_166_53 VGND VGND VPWR VPWR sky130_fd_sc_hd__decap_3
XFILLER_124_124 VGND VGND VPWR VPWR sky130_fd_sc_hd__decap_3
XFILLER_109_187 VGND VGND VPWR VPWR sky130_fd_sc_hd__decap_3
XFILLER_50_97 VGND VGND VPWR VPWR sky130_fd_sc_hd__decap_3
XFILLER_124_168 VGND VGND VPWR VPWR sky130_fd_sc_hd__decap_3
XFILLER_59_40 VGND VGND VPWR VPWR sky130_fd_sc_hd__decap_3
XFILLER_182_85 VGND VGND VPWR VPWR sky130_fd_sc_hd__decap_3
XFILLER_115_90 VGND VGND VPWR VPWR sky130_fd_sc_hd__decap_3
XFILLER_93_214 VGND VGND VPWR VPWR sky130_fd_sc_hd__decap_3
XFILLER_93_225 VGND VGND VPWR VPWR sky130_fd_sc_hd__decap_3
Xfanout290 Tile_X0Y1_FrameStrobe[5] VGND VGND VPWR VPWR net290 sky130_fd_sc_hd__clkbuf_4
XTAP_TAPCELL_ROW_64_629 VGND VPWR sky130_fd_sc_hd__tapvpwrvgnd_1
XFILLER_75_94 VGND VGND VPWR VPWR sky130_fd_sc_hd__decap_3
XFILLER_61_111 VGND VGND VPWR VPWR sky130_fd_sc_hd__fill_1
XFILLER_61_122 VGND VGND VPWR VPWR sky130_fd_sc_hd__decap_3
XFILLER_61_133 VGND VGND VPWR VPWR sky130_fd_sc_hd__decap_3
XFILLER_61_166 VGND VGND VPWR VPWR sky130_fd_sc_hd__fill_2
XFILLER_91_93 VGND VGND VPWR VPWR sky130_fd_sc_hd__decap_3
XFILLER_147_205 VGND VGND VPWR VPWR sky130_fd_sc_hd__decap_3
X_0803_ net120 net308 VGND VGND VPWR VPWR Tile_X0Y0_OpenRAM_top.Inst_OpenRAM_top_ConfigMem.Inst_frame3_bit15.Q
+ sky130_fd_sc_hd__dlxtp_1
XFILLER_162_208 VGND VGND VPWR VPWR sky130_fd_sc_hd__decap_3
XFILLER_115_113 VGND VGND VPWR VPWR sky130_fd_sc_hd__fill_2
X_0734_ net126 net326 VGND VGND VPWR VPWR Tile_X0Y0_OpenRAM_top.Inst_OpenRAM_top_ConfigMem.Inst_frame1_bit20.Q
+ sky130_fd_sc_hd__dlxtp_1
XPHY_EDGE_ROW_139_Left_322 VGND VGND VPWR VPWR sky130_fd_sc_hd__decap_3
X_0665_ Tile_X0Y1_OpenRAM_bot.Inst_OpenRAM_bot_ConfigMem.Inst_frame6_bit3.Q _0203_
+ VGND VGND VPWR VPWR _0204_ sky130_fd_sc_hd__and2b_1
X_0596_ _0024_ Tile_X0Y1_OpenRAM_bot.Inst_OpenRAM_bot_ConfigMem.Inst_frame3_bit25.Q
+ _0082_ _0162_ VGND VGND VPWR VPWR net367 sky130_fd_sc_hd__a31o_1
XTAP_TAPCELL_ROW_107_800 VGND VPWR sky130_fd_sc_hd__tapvpwrvgnd_1
X_1217_ net249 net272 VGND VGND VPWR VPWR Tile_X0Y1_OpenRAM_bot.Inst_OpenRAM_bot_ConfigMem.Inst_frame7_bit5.Q
+ sky130_fd_sc_hd__dlxtp_1
XPHY_EDGE_ROW_148_Left_331 VGND VGND VPWR VPWR sky130_fd_sc_hd__decap_3
XFILLER_111_15 VGND VGND VPWR VPWR sky130_fd_sc_hd__decap_3
X_1148_ net223 net288 VGND VGND VPWR VPWR Tile_X0Y1_OpenRAM_bot.Inst_OpenRAM_bot_ConfigMem.Inst_frame5_bit10.Q
+ sky130_fd_sc_hd__dlxtp_1
XFILLER_37_196 VGND VGND VPWR VPWR sky130_fd_sc_hd__decap_3
XFILLER_52_111 VGND VGND VPWR VPWR sky130_fd_sc_hd__decap_3
XTAP_TAPCELL_ROW_122_858 VGND VPWR sky130_fd_sc_hd__tapvpwrvgnd_1
XFILLER_111_48 VGND VGND VPWR VPWR sky130_fd_sc_hd__decap_3
XFILLER_52_144 VGND VGND VPWR VPWR sky130_fd_sc_hd__fill_2
X_1079_ net228 net306 VGND VGND VPWR VPWR Tile_X0Y1_OpenRAM_bot.Inst_OpenRAM_bot_ConfigMem.Inst_frame3_bit15.Q
+ sky130_fd_sc_hd__dlxtp_1
XTAP_TAPCELL_ROW_130_891 VGND VPWR sky130_fd_sc_hd__tapvpwrvgnd_1
XPHY_EDGE_ROW_157_Left_340 VGND VGND VPWR VPWR sky130_fd_sc_hd__decap_3
XFILLER_20_23 VGND VGND VPWR VPWR sky130_fd_sc_hd__decap_3
XFILLER_4_218 VGND VGND VPWR VPWR sky130_fd_sc_hd__decap_3
XFILLER_106_135 VGND VGND VPWR VPWR sky130_fd_sc_hd__decap_3
XFILLER_105_6 VGND VGND VPWR VPWR sky130_fd_sc_hd__decap_3
XFILLER_136_56 VGND VGND VPWR VPWR sky130_fd_sc_hd__decap_3
XFILLER_106_168 VGND VGND VPWR VPWR sky130_fd_sc_hd__decap_3
XFILLER_121_149 VGND VGND VPWR VPWR sky130_fd_sc_hd__decap_3
XFILLER_121_127 VGND VGND VPWR VPWR sky130_fd_sc_hd__fill_1
XFILLER_29_54 VGND VGND VPWR VPWR sky130_fd_sc_hd__fill_2
XFILLER_29_76 VGND VGND VPWR VPWR sky130_fd_sc_hd__decap_3
XFILLER_75_225 VGND VGND VPWR VPWR sky130_fd_sc_hd__fill_1
XFILLER_152_88 VGND VGND VPWR VPWR sky130_fd_sc_hd__decap_3
XFILLER_152_77 VGND VGND VPWR VPWR sky130_fd_sc_hd__decap_3
XFILLER_28_141 VGND VGND VPWR VPWR sky130_fd_sc_hd__decap_3
XFILLER_45_20 VGND VGND VPWR VPWR sky130_fd_sc_hd__decap_3
XFILLER_90_206 VGND VGND VPWR VPWR sky130_fd_sc_hd__decap_3
XFILLER_90_228 VGND VGND VPWR VPWR sky130_fd_sc_hd__fill_2
XTAP_TAPCELL_ROW_153_983 VGND VPWR sky130_fd_sc_hd__tapvpwrvgnd_1
XTAP_TAPCELL_ROW_113_825 VGND VPWR sky130_fd_sc_hd__tapvpwrvgnd_1
XFILLER_43_111 VGND VGND VPWR VPWR sky130_fd_sc_hd__fill_1
XFILLER_43_122 VGND VGND VPWR VPWR sky130_fd_sc_hd__decap_3
XFILLER_43_155 VGND VGND VPWR VPWR sky130_fd_sc_hd__decap_3
XFILLER_45_75 VGND VGND VPWR VPWR sky130_fd_sc_hd__decap_3
XFILLER_45_97 VGND VGND VPWR VPWR sky130_fd_sc_hd__decap_3
XFILLER_129_216 VGND VGND VPWR VPWR sky130_fd_sc_hd__decap_3
XFILLER_101_81 VGND VGND VPWR VPWR sky130_fd_sc_hd__decap_3
XFILLER_61_30 VGND VGND VPWR VPWR sky130_fd_sc_hd__decap_3
XFILLER_177_30 VGND VGND VPWR VPWR sky130_fd_sc_hd__decap_3
XFILLER_177_63 VGND VGND VPWR VPWR sky130_fd_sc_hd__decap_3
XFILLER_61_96 VGND VGND VPWR VPWR sky130_fd_sc_hd__decap_3
XFILLER_177_96 VGND VGND VPWR VPWR sky130_fd_sc_hd__decap_3
XFILLER_6_47 VGND VGND VPWR VPWR sky130_fd_sc_hd__decap_3
XFILLER_112_116 VGND VGND VPWR VPWR sky130_fd_sc_hd__decap_3
X_0450_ _0100_ Tile_X0Y0_OpenRAM_top.Inst_OpenRAM_top_ConfigMem.Inst_frame2_bit27.Q
+ _0006_ _0099_ VGND VGND VPWR VPWR net370 sky130_fd_sc_hd__a2bb2o_1
X_0381_ net22 net54 Tile_X0Y0_OpenRAM_top.Inst_OpenRAM_top_switch_matrix.J_NS2_BEG3
+ Tile_X0Y0_OpenRAM_top.Inst_OpenRAM_top_switch_matrix.J_NS2_BEG4 Tile_X0Y0_OpenRAM_top.Inst_OpenRAM_top_ConfigMem.Inst_frame5_bit18.Q
+ Tile_X0Y0_OpenRAM_top.Inst_OpenRAM_top_ConfigMem.Inst_frame5_bit19.Q VGND VGND VPWR
+ VPWR Tile_X0Y0_OpenRAM_top.Inst_OpenRAM_top_switch_matrix.W2BEGb3 sky130_fd_sc_hd__mux4_1
XFILLER_105_190 VGND VGND VPWR VPWR sky130_fd_sc_hd__decap_3
XTAP_TAPCELL_ROW_136_917 VGND VPWR sky130_fd_sc_hd__tapvpwrvgnd_1
XFILLER_86_82 VGND VGND VPWR VPWR sky130_fd_sc_hd__fill_2
XFILLER_120_193 VGND VGND VPWR VPWR sky130_fd_sc_hd__decap_3
X_1002_ net242 net322 VGND VGND VPWR VPWR Tile_X0Y1_OpenRAM_bot.Inst_OpenRAM_bot_ConfigMem.Inst_frame1_bit28.Q
+ sky130_fd_sc_hd__dlxtp_1
XFILLER_81_217 VGND VGND VPWR VPWR sky130_fd_sc_hd__decap_3
XFILLER_19_196 VGND VGND VPWR VPWR sky130_fd_sc_hd__decap_3
XFILLER_34_111 VGND VGND VPWR VPWR sky130_fd_sc_hd__decap_3
XFILLER_179_116 VGND VGND VPWR VPWR sky130_fd_sc_hd__decap_3
XFILLER_179_105 VGND VGND VPWR VPWR sky130_fd_sc_hd__decap_3
XTAP_TAPCELL_ROW_60_610 VGND VPWR sky130_fd_sc_hd__tapvpwrvgnd_1
X_0717_ net141 net334 VGND VGND VPWR VPWR Tile_X0Y0_OpenRAM_top.Inst_OpenRAM_top_ConfigMem.Inst_frame0_bit5.Q
+ sky130_fd_sc_hd__dlxtp_1
XFILLER_106_26 VGND VGND VPWR VPWR sky130_fd_sc_hd__fill_2
XFILLER_103_116 VGND VGND VPWR VPWR sky130_fd_sc_hd__decap_3
X_0648_ Tile_X0Y1_OpenRAM_bot.Inst_OpenRAM_bot_switch_matrix.J_NS4_BEG15 net260 Tile_X0Y1_OpenRAM_bot.Inst_OpenRAM_bot_ConfigMem.Inst_frame7_bit1.Q
+ VGND VGND VPWR VPWR _0190_ sky130_fd_sc_hd__mux2_1
XFILLER_106_59 VGND VGND VPWR VPWR sky130_fd_sc_hd__decap_3
X_0579_ net29 _0146_ _0150_ net262 Tile_X0Y1_OpenRAM_bot.Inst_OpenRAM_bot_ConfigMem.Inst_frame4_bit27.Q
+ Tile_X0Y1_OpenRAM_bot.Inst_OpenRAM_bot_ConfigMem.Inst_frame4_bit26.Q VGND VGND VPWR
+ VPWR Tile_X0Y1_OpenRAM_bot.Inst_OpenRAM_bot_switch_matrix.W6BEG5 sky130_fd_sc_hd__mux4_1
XFILLER_57_225 VGND VGND VPWR VPWR sky130_fd_sc_hd__decap_3
XFILLER_111_193 VGND VGND VPWR VPWR sky130_fd_sc_hd__decap_3
XFILLER_174_9 VGND VGND VPWR VPWR sky130_fd_sc_hd__decap_3
XFILLER_122_25 VGND VGND VPWR VPWR sky130_fd_sc_hd__decap_3
XFILLER_72_206 VGND VGND VPWR VPWR sky130_fd_sc_hd__fill_1
XTAP_TAPCELL_ROW_83_702 VGND VPWR sky130_fd_sc_hd__tapvpwrvgnd_1
XFILLER_82_18 VGND VGND VPWR VPWR sky130_fd_sc_hd__decap_3
XFILLER_82_29 VGND VGND VPWR VPWR sky130_fd_sc_hd__decap_3
XFILLER_25_155 VGND VGND VPWR VPWR sky130_fd_sc_hd__decap_3
XFILLER_15_34 VGND VGND VPWR VPWR sky130_fd_sc_hd__fill_1
XFILLER_25_199 VGND VGND VPWR VPWR sky130_fd_sc_hd__decap_3
XFILLER_40_103 VGND VGND VPWR VPWR sky130_fd_sc_hd__decap_3
XFILLER_178_171 VGND VGND VPWR VPWR sky130_fd_sc_hd__decap_3
XFILLER_31_11 VGND VGND VPWR VPWR sky130_fd_sc_hd__decap_3
XFILLER_31_44 VGND VGND VPWR VPWR sky130_fd_sc_hd__decap_3
XFILLER_147_22 VGND VGND VPWR VPWR sky130_fd_sc_hd__decap_3
XFILLER_147_55 VGND VGND VPWR VPWR sky130_fd_sc_hd__fill_1
XFILLER_147_99 VGND VGND VPWR VPWR sky130_fd_sc_hd__decap_3
XFILLER_103_3 VGND VGND VPWR VPWR sky130_fd_sc_hd__decap_3
XFILLER_0_221 VGND VGND VPWR VPWR sky130_fd_sc_hd__decap_3
XFILLER_163_54 VGND VGND VPWR VPWR sky130_fd_sc_hd__fill_2
Xinput100 Tile_X0Y0_EE4END[11] VGND VGND VPWR VPWR net100 sky130_fd_sc_hd__buf_1
Xinput111 Tile_X0Y0_EE4END[7] VGND VGND VPWR VPWR net111 sky130_fd_sc_hd__buf_1
Xinput133 Tile_X0Y0_FrameData[27] VGND VGND VPWR VPWR net133 sky130_fd_sc_hd__clkbuf_4
Xinput122 Tile_X0Y0_FrameData[17] VGND VGND VPWR VPWR net122 sky130_fd_sc_hd__buf_4
XFILLER_163_87 VGND VGND VPWR VPWR sky130_fd_sc_hd__decap_3
Xinput144 Tile_X0Y0_FrameData[8] VGND VGND VPWR VPWR net144 sky130_fd_sc_hd__clkbuf_4
XFILLER_102_171 VGND VGND VPWR VPWR sky130_fd_sc_hd__fill_1
Xinput155 Tile_X0Y0_S2END[5] VGND VGND VPWR VPWR net155 sky130_fd_sc_hd__clkbuf_2
Xinput166 Tile_X0Y0_S4END[0] VGND VGND VPWR VPWR net166 sky130_fd_sc_hd__clkbuf_2
XFILLER_102_193 VGND VGND VPWR VPWR sky130_fd_sc_hd__decap_3
Xinput177 Tile_X0Y1_E1END[3] VGND VGND VPWR VPWR net177 sky130_fd_sc_hd__clkbuf_2
Xinput188 Tile_X0Y1_E2MID[2] VGND VGND VPWR VPWR net188 sky130_fd_sc_hd__clkbuf_2
Xinput199 Tile_X0Y1_E6END[3] VGND VGND VPWR VPWR net199 sky130_fd_sc_hd__dlymetal6s2s_1
XFILLER_56_52 VGND VGND VPWR VPWR sky130_fd_sc_hd__decap_3
XFILLER_63_217 VGND VGND VPWR VPWR sky130_fd_sc_hd__decap_3
XFILLER_63_228 VGND VGND VPWR VPWR sky130_fd_sc_hd__decap_3
XFILLER_16_100 VGND VGND VPWR VPWR sky130_fd_sc_hd__decap_3
XFILLER_56_85 VGND VGND VPWR VPWR sky130_fd_sc_hd__decap_3
XFILLER_16_144 VGND VGND VPWR VPWR sky130_fd_sc_hd__decap_3
XFILLER_16_133 VGND VGND VPWR VPWR sky130_fd_sc_hd__decap_3
XFILLER_112_91 VGND VGND VPWR VPWR sky130_fd_sc_hd__decap_3
XFILLER_31_103 VGND VGND VPWR VPWR sky130_fd_sc_hd__decap_3
XFILLER_31_125 VGND VGND VPWR VPWR sky130_fd_sc_hd__decap_3
XFILLER_72_62 VGND VGND VPWR VPWR sky130_fd_sc_hd__decap_3
XFILLER_169_193 VGND VGND VPWR VPWR sky130_fd_sc_hd__decap_3
XFILLER_31_169 VGND VGND VPWR VPWR sky130_fd_sc_hd__decap_3
XFILLER_140_200 VGND VGND VPWR VPWR sky130_fd_sc_hd__decap_3
XFILLER_98_103 VGND VGND VPWR VPWR sky130_fd_sc_hd__decap_3
X_0502_ _0016_ _0136_ _0140_ VGND VGND VPWR VPWR Tile_X0Y0_OpenRAM_top.Inst_OpenRAM_top_switch_matrix.S4BEG1
+ sky130_fd_sc_hd__o21a_1
XFILLER_98_125 VGND VGND VPWR VPWR sky130_fd_sc_hd__decap_3
X_1482_ Tile_X0Y1_OpenRAM_bot.Inst_OpenRAM_bot_switch_matrix.W6BEG0 VGND VGND VPWR
+ VPWR net642 sky130_fd_sc_hd__clkbuf_1
X_0433_ net110 net103 net94 Tile_X0Y0_OpenRAM_top.Inst_OpenRAM_top_switch_matrix.J_NS4_BEG6
+ Tile_X0Y0_OpenRAM_top.Inst_OpenRAM_top_ConfigMem.Inst_frame2_bit0.Q Tile_X0Y0_OpenRAM_top.Inst_OpenRAM_top_ConfigMem.Inst_frame2_bit1.Q
+ VGND VGND VPWR VPWR net400 sky130_fd_sc_hd__mux4_2
XFILLER_39_203 VGND VGND VPWR VPWR sky130_fd_sc_hd__fill_2
X_0364_ _0017_ Tile_X0Y1_OpenRAM_bot.Inst_OpenRAM_bot_ConfigMem.Inst_frame0_bit25.Q
+ _0091_ _0093_ VGND VGND VPWR VPWR _0094_ sky130_fd_sc_hd__a31o_1
X_0295_ net67 net97 Tile_X0Y0_OpenRAM_top.Inst_OpenRAM_top_switch_matrix.J_NS4_BEG13
+ _0062_ Tile_X0Y0_OpenRAM_top.Inst_OpenRAM_top_ConfigMem.Inst_frame7_bit18.Q Tile_X0Y0_OpenRAM_top.Inst_OpenRAM_top_ConfigMem.Inst_frame7_bit19.Q
+ VGND VGND VPWR VPWR _0063_ sky130_fd_sc_hd__mux4_2
XFILLER_54_206 VGND VGND VPWR VPWR sky130_fd_sc_hd__decap_3
XFILLER_22_103 VGND VGND VPWR VPWR sky130_fd_sc_hd__decap_3
XFILLER_167_119 VGND VGND VPWR VPWR sky130_fd_sc_hd__decap_3
XFILLER_175_152 VGND VGND VPWR VPWR sky130_fd_sc_hd__decap_3
XFILLER_30_180 VGND VGND VPWR VPWR sky130_fd_sc_hd__decap_3
XFILLER_175_196 VGND VGND VPWR VPWR sky130_fd_sc_hd__decap_3
XFILLER_7_90 VGND VGND VPWR VPWR sky130_fd_sc_hd__decap_3
XFILLER_117_14 VGND VGND VPWR VPWR sky130_fd_sc_hd__decap_3
XFILLER_117_69 VGND VGND VPWR VPWR sky130_fd_sc_hd__decap_3
XFILLER_117_47 VGND VGND VPWR VPWR sky130_fd_sc_hd__decap_3
XFILLER_77_18 VGND VGND VPWR VPWR sky130_fd_sc_hd__decap_3
XFILLER_89_125 VGND VGND VPWR VPWR sky130_fd_sc_hd__decap_3
XFILLER_89_158 VGND VGND VPWR VPWR sky130_fd_sc_hd__decap_3
XFILLER_89_169 VGND VGND VPWR VPWR sky130_fd_sc_hd__decap_3
XFILLER_133_57 VGND VGND VPWR VPWR sky130_fd_sc_hd__decap_3
XFILLER_133_35 VGND VGND VPWR VPWR sky130_fd_sc_hd__fill_2
XFILLER_97_191 VGND VGND VPWR VPWR sky130_fd_sc_hd__decap_3
XFILLER_93_39 VGND VGND VPWR VPWR sky130_fd_sc_hd__decap_3
XFILLER_172_6 VGND VGND VPWR VPWR sky130_fd_sc_hd__decap_3
XFILLER_26_11 VGND VGND VPWR VPWR sky130_fd_sc_hd__decap_3
XFILLER_26_88 VGND VGND VPWR VPWR sky130_fd_sc_hd__decap_3
XFILLER_158_119 VGND VGND VPWR VPWR sky130_fd_sc_hd__decap_3
XFILLER_13_169 VGND VGND VPWR VPWR sky130_fd_sc_hd__decap_3
XFILLER_42_21 VGND VGND VPWR VPWR sky130_fd_sc_hd__decap_3
XFILLER_42_32 VGND VGND VPWR VPWR sky130_fd_sc_hd__decap_3
XPHY_EDGE_ROW_165_Right_165 VGND VGND VPWR VPWR sky130_fd_sc_hd__decap_3
XFILLER_166_141 VGND VGND VPWR VPWR sky130_fd_sc_hd__decap_3
XFILLER_158_32 VGND VGND VPWR VPWR sky130_fd_sc_hd__decap_3
XFILLER_42_65 VGND VGND VPWR VPWR sky130_fd_sc_hd__decap_3
XFILLER_181_111 VGND VGND VPWR VPWR sky130_fd_sc_hd__fill_1
XFILLER_166_174 VGND VGND VPWR VPWR sky130_fd_sc_hd__decap_3
XFILLER_158_65 VGND VGND VPWR VPWR sky130_fd_sc_hd__decap_3
XFILLER_174_53 VGND VGND VPWR VPWR sky130_fd_sc_hd__decap_3
XFILLER_122_222 VGND VGND VPWR VPWR sky130_fd_sc_hd__decap_3
XFILLER_122_200 VGND VGND VPWR VPWR sky130_fd_sc_hd__fill_1
XFILLER_174_97 VGND VGND VPWR VPWR sky130_fd_sc_hd__decap_3
XFILLER_3_15 VGND VGND VPWR VPWR sky130_fd_sc_hd__decap_3
XFILLER_3_48 VGND VGND VPWR VPWR sky130_fd_sc_hd__decap_3
XFILLER_67_51 VGND VGND VPWR VPWR sky130_fd_sc_hd__decap_3
XFILLER_88_191 VGND VGND VPWR VPWR sky130_fd_sc_hd__decap_3
XFILLER_123_90 VGND VGND VPWR VPWR sky130_fd_sc_hd__decap_3
XTAP_TAPCELL_ROW_19_448 VGND VPWR sky130_fd_sc_hd__tapvpwrvgnd_1
XFILLER_83_72 VGND VGND VPWR VPWR sky130_fd_sc_hd__decap_3
XPHY_EDGE_ROW_103_Left_286 VGND VGND VPWR VPWR sky130_fd_sc_hd__decap_3
XTAP_TAPCELL_ROW_27_481 VGND VPWR sky130_fd_sc_hd__tapvpwrvgnd_1
X_0982_ net229 net331 VGND VGND VPWR VPWR Tile_X0Y1_OpenRAM_bot.Inst_OpenRAM_bot_ConfigMem.Inst_frame0_bit16.Q
+ sky130_fd_sc_hd__dlxtp_1
XFILLER_172_100 VGND VGND VPWR VPWR sky130_fd_sc_hd__decap_3
XPHY_EDGE_ROW_132_Right_132 VGND VGND VPWR VPWR sky130_fd_sc_hd__decap_3
XFILLER_8_162 VGND VGND VPWR VPWR sky130_fd_sc_hd__decap_3
XFILLER_172_144 VGND VGND VPWR VPWR sky130_fd_sc_hd__decap_3
XFILLER_172_133 VGND VGND VPWR VPWR sky130_fd_sc_hd__decap_3
XFILLER_8_195 VGND VGND VPWR VPWR sky130_fd_sc_hd__fill_1
Xoutput415 net498 VGND VGND VPWR VPWR Tile_X0Y0_N4BEG[3] sky130_fd_sc_hd__buf_2
Xoutput404 net487 VGND VGND VPWR VPWR Tile_X0Y0_N2BEGb[6] sky130_fd_sc_hd__buf_2
XFILLER_172_177 VGND VGND VPWR VPWR sky130_fd_sc_hd__decap_3
Xoutput426 net509 VGND VGND VPWR VPWR Tile_X0Y0_W1BEG[3] sky130_fd_sc_hd__buf_2
Xoutput448 net531 VGND VGND VPWR VPWR Tile_X0Y0_W6BEG[3] sky130_fd_sc_hd__buf_2
Xoutput459 net542 VGND VGND VPWR VPWR Tile_X0Y0_WW4BEG[13] sky130_fd_sc_hd__buf_2
Xoutput437 net520 VGND VGND VPWR VPWR Tile_X0Y0_W2BEGb[2] sky130_fd_sc_hd__buf_2
XFILLER_113_211 VGND VGND VPWR VPWR sky130_fd_sc_hd__decap_3
XPHY_EDGE_ROW_112_Left_295 VGND VGND VPWR VPWR sky130_fd_sc_hd__decap_3
X_1465_ Tile_X0Y1_OpenRAM_bot.Inst_OpenRAM_bot_switch_matrix.W1BEG3 VGND VGND VPWR
+ VPWR net625 sky130_fd_sc_hd__buf_1
X_0416_ net362 net167 Tile_X0Y0_OpenRAM_top.Inst_OpenRAM_top_switch_matrix.J_NS4_BEG10
+ Tile_X0Y0_OpenRAM_top.Inst_OpenRAM_top_switch_matrix.J_NS4_BEG14 Tile_X0Y0_OpenRAM_top.Inst_OpenRAM_top_ConfigMem.Inst_frame4_bit30.Q
+ Tile_X0Y0_OpenRAM_top.Inst_OpenRAM_top_ConfigMem.Inst_frame4_bit31.Q VGND VGND VPWR
+ VPWR Tile_X0Y0_OpenRAM_top.Inst_OpenRAM_top_switch_matrix.W6BEG1 sky130_fd_sc_hd__mux4_1
X_1396_ net244 VGND VGND VPWR VPWR net576 sky130_fd_sc_hd__buf_4
XFILLER_86_139 VGND VGND VPWR VPWR sky130_fd_sc_hd__fill_1
X_0347_ net80 net72 net90 Tile_X0Y0_OpenRAM_top.Inst_OpenRAM_top_switch_matrix.J_NS2_BEG5
+ Tile_X0Y0_OpenRAM_top.Inst_OpenRAM_top_ConfigMem.Inst_frame8_bit30.Q Tile_X0Y0_OpenRAM_top.Inst_OpenRAM_top_ConfigMem.Inst_frame8_bit31.Q
+ VGND VGND VPWR VPWR Tile_X0Y0_OpenRAM_top.Inst_OpenRAM_top_switch_matrix.N2BEG5
+ sky130_fd_sc_hd__mux4_1
XFILLER_27_206 VGND VGND VPWR VPWR sky130_fd_sc_hd__decap_3
XFILLER_103_27 VGND VGND VPWR VPWR sky130_fd_sc_hd__decap_3
XFILLER_94_183 VGND VGND VPWR VPWR sky130_fd_sc_hd__decap_3
X_0278_ net161 Tile_X0Y1_OpenRAM_bot.Inst_OpenRAM_bot_ConfigMem.Inst_frame2_bit30.Q
+ _0045_ net182 VGND VGND VPWR VPWR _0047_ sky130_fd_sc_hd__a22o_1
XFILLER_10_106 VGND VGND VPWR VPWR sky130_fd_sc_hd__decap_3
XFILLER_148_130 VGND VGND VPWR VPWR sky130_fd_sc_hd__decap_3
XFILLER_10_139 VGND VGND VPWR VPWR sky130_fd_sc_hd__fill_1
XFILLER_163_100 VGND VGND VPWR VPWR sky130_fd_sc_hd__decap_3
XFILLER_148_174 VGND VGND VPWR VPWR sky130_fd_sc_hd__decap_3
XFILLER_12_24 VGND VGND VPWR VPWR sky130_fd_sc_hd__decap_3
XFILLER_163_122 VGND VGND VPWR VPWR sky130_fd_sc_hd__decap_3
XFILLER_128_46 VGND VGND VPWR VPWR sky130_fd_sc_hd__decap_3
XFILLER_12_68 VGND VGND VPWR VPWR sky130_fd_sc_hd__decap_3
XFILLER_163_166 VGND VGND VPWR VPWR sky130_fd_sc_hd__fill_2
XFILLER_163_199 VGND VGND VPWR VPWR sky130_fd_sc_hd__decap_3
XFILLER_104_200 VGND VGND VPWR VPWR sky130_fd_sc_hd__decap_3
XFILLER_144_45 VGND VGND VPWR VPWR sky130_fd_sc_hd__decap_3
XFILLER_77_106 VGND VGND VPWR VPWR sky130_fd_sc_hd__decap_3
XFILLER_77_128 VGND VGND VPWR VPWR sky130_fd_sc_hd__decap_3
XFILLER_144_78 VGND VGND VPWR VPWR sky130_fd_sc_hd__decap_3
XFILLER_18_206 VGND VGND VPWR VPWR sky130_fd_sc_hd__decap_3
XFILLER_37_21 VGND VGND VPWR VPWR sky130_fd_sc_hd__decap_3
XFILLER_85_161 VGND VGND VPWR VPWR sky130_fd_sc_hd__decap_3
XFILLER_160_44 VGND VGND VPWR VPWR sky130_fd_sc_hd__decap_3
XFILLER_37_54 VGND VGND VPWR VPWR sky130_fd_sc_hd__fill_2
XFILLER_85_172 VGND VGND VPWR VPWR sky130_fd_sc_hd__decap_3
XFILLER_160_77 VGND VGND VPWR VPWR sky130_fd_sc_hd__decap_3
XFILLER_37_87 VGND VGND VPWR VPWR sky130_fd_sc_hd__decap_3
XFILLER_41_220 VGND VGND VPWR VPWR sky130_fd_sc_hd__decap_3
XFILLER_53_53 VGND VGND VPWR VPWR sky130_fd_sc_hd__decap_3
XFILLER_169_42 VGND VGND VPWR VPWR sky130_fd_sc_hd__decap_3
XTAP_TAPCELL_ROW_158_1005 VGND VPWR sky130_fd_sc_hd__tapvpwrvgnd_1
XFILLER_53_75 VGND VGND VPWR VPWR sky130_fd_sc_hd__decap_3
XFILLER_169_75 VGND VGND VPWR VPWR sky130_fd_sc_hd__decap_3
XFILLER_139_163 VGND VGND VPWR VPWR sky130_fd_sc_hd__decap_3
XFILLER_154_122 VGND VGND VPWR VPWR sky130_fd_sc_hd__decap_3
XFILLER_154_177 VGND VGND VPWR VPWR sky130_fd_sc_hd__decap_3
XFILLER_154_144 VGND VGND VPWR VPWR sky130_fd_sc_hd__decap_3
XFILLER_5_143 VGND VGND VPWR VPWR sky130_fd_sc_hd__decap_3
XFILLER_5_187 VGND VGND VPWR VPWR sky130_fd_sc_hd__decap_3
XFILLER_78_50 VGND VGND VPWR VPWR sky130_fd_sc_hd__decap_3
XFILLER_68_117 VGND VGND VPWR VPWR sky130_fd_sc_hd__decap_3
X_1250_ net248 net265 VGND VGND VPWR VPWR Tile_X0Y1_OpenRAM_bot.Inst_OpenRAM_bot_ConfigMem.Inst_frame8_bit4.Q
+ sky130_fd_sc_hd__dlxtp_1
X_1181_ net253 net278 VGND VGND VPWR VPWR Tile_X0Y1_OpenRAM_bot.Inst_OpenRAM_bot_ConfigMem.Inst_frame6_bit9.Q
+ sky130_fd_sc_hd__dlxtp_1
XFILLER_24_209 VGND VGND VPWR VPWR sky130_fd_sc_hd__fill_2
XFILLER_91_142 VGND VGND VPWR VPWR sky130_fd_sc_hd__decap_3
XFILLER_94_82 VGND VGND VPWR VPWR sky130_fd_sc_hd__fill_2
XTAP_TAPCELL_ROW_180_1091 VGND VPWR sky130_fd_sc_hd__tapvpwrvgnd_1
XFILLER_91_175 VGND VGND VPWR VPWR sky130_fd_sc_hd__decap_3
XFILLER_177_225 VGND VGND VPWR VPWR sky130_fd_sc_hd__decap_3
XFILLER_177_214 VGND VGND VPWR VPWR sky130_fd_sc_hd__decap_3
X_0965_ net118 net269 VGND VGND VPWR VPWR Tile_X0Y0_OpenRAM_top.Inst_OpenRAM_top_ConfigMem.Inst_frame8_bit13.Q
+ sky130_fd_sc_hd__dlxtp_1
X_0896_ net123 net284 VGND VGND VPWR VPWR Tile_X0Y0_OpenRAM_top.Inst_OpenRAM_top_ConfigMem.Inst_frame6_bit18.Q
+ sky130_fd_sc_hd__dlxtp_1
XPHY_EDGE_ROW_120_Left_303 VGND VGND VPWR VPWR sky130_fd_sc_hd__decap_3
XFILLER_160_136 VGND VGND VPWR VPWR sky130_fd_sc_hd__decap_3
XFILLER_160_147 VGND VGND VPWR VPWR sky130_fd_sc_hd__decap_3
Xoutput289 net372 VGND VGND VPWR VPWR ADDR_A_SRAM7 sky130_fd_sc_hd__buf_2
X_1448_ Tile_X0Y0_S4END[10] VGND VGND VPWR VPWR net614 sky130_fd_sc_hd__buf_6
XFILLER_4_80 VGND VGND VPWR VPWR sky130_fd_sc_hd__decap_3
XFILLER_4_91 VGND VGND VPWR VPWR sky130_fd_sc_hd__decap_3
X_1379_ Tile_X0Y0_OpenRAM_top.Inst_OpenRAM_top_switch_matrix.WW4BEG1 VGND VGND VPWR
+ VPWR net545 sky130_fd_sc_hd__buf_1
XFILLER_67_172 VGND VGND VPWR VPWR sky130_fd_sc_hd__fill_1
XFILLER_67_194 VGND VGND VPWR VPWR sky130_fd_sc_hd__decap_3
XFILLER_168_203 VGND VGND VPWR VPWR sky130_fd_sc_hd__decap_3
XFILLER_90_29 VGND VGND VPWR VPWR sky130_fd_sc_hd__decap_3
XFILLER_23_45 VGND VGND VPWR VPWR sky130_fd_sc_hd__decap_3
XFILLER_139_45 VGND VGND VPWR VPWR sky130_fd_sc_hd__decap_3
XTAP_TAPCELL_ROW_21_454 VGND VPWR sky130_fd_sc_hd__tapvpwrvgnd_1
XFILLER_136_122 VGND VGND VPWR VPWR sky130_fd_sc_hd__decap_3
XFILLER_99_27 VGND VGND VPWR VPWR sky130_fd_sc_hd__decap_3
XFILLER_136_144 VGND VGND VPWR VPWR sky130_fd_sc_hd__decap_3
XFILLER_155_66 VGND VGND VPWR VPWR sky130_fd_sc_hd__decap_3
XFILLER_155_55 VGND VGND VPWR VPWR sky130_fd_sc_hd__fill_1
XFILLER_2_124 VGND VGND VPWR VPWR sky130_fd_sc_hd__decap_3
XFILLER_155_99 VGND VGND VPWR VPWR sky130_fd_sc_hd__decap_3
XFILLER_2_168 VGND VGND VPWR VPWR sky130_fd_sc_hd__decap_3
XFILLER_171_54 VGND VGND VPWR VPWR sky130_fd_sc_hd__fill_2
XFILLER_171_21 VGND VGND VPWR VPWR sky130_fd_sc_hd__decap_3
XFILLER_48_53 VGND VGND VPWR VPWR sky130_fd_sc_hd__decap_3
XFILLER_58_150 VGND VGND VPWR VPWR sky130_fd_sc_hd__decap_3
XFILLER_171_87 VGND VGND VPWR VPWR sky130_fd_sc_hd__decap_3
XFILLER_58_183 VGND VGND VPWR VPWR sky130_fd_sc_hd__decap_3
XFILLER_73_131 VGND VGND VPWR VPWR sky130_fd_sc_hd__decap_3
XFILLER_73_164 VGND VGND VPWR VPWR sky130_fd_sc_hd__decap_3
XFILLER_73_175 VGND VGND VPWR VPWR sky130_fd_sc_hd__fill_1
XTAP_TAPCELL_ROW_44_546 VGND VPWR sky130_fd_sc_hd__tapvpwrvgnd_1
XFILLER_64_85 VGND VGND VPWR VPWR sky130_fd_sc_hd__decap_3
XFILLER_73_197 VGND VGND VPWR VPWR sky130_fd_sc_hd__decap_3
XFILLER_159_225 VGND VGND VPWR VPWR sky130_fd_sc_hd__decap_3
XFILLER_9_36 VGND VGND VPWR VPWR sky130_fd_sc_hd__decap_3
XFILLER_9_69 VGND VGND VPWR VPWR sky130_fd_sc_hd__decap_3
XFILLER_174_206 VGND VGND VPWR VPWR sky130_fd_sc_hd__decap_3
XTAP_TAPCELL_ROW_12_421 VGND VPWR sky130_fd_sc_hd__tapvpwrvgnd_1
XFILLER_127_122 VGND VGND VPWR VPWR sky130_fd_sc_hd__fill_2
XFILLER_127_111 VGND VGND VPWR VPWR sky130_fd_sc_hd__fill_1
X_0750_ net140 net326 VGND VGND VPWR VPWR Tile_X0Y0_OpenRAM_top.Inst_OpenRAM_top_ConfigMem.Inst_frame1_bit4.Q
+ sky130_fd_sc_hd__dlxtp_1
XTAP_TAPCELL_ROW_171_1057 VGND VPWR sky130_fd_sc_hd__tapvpwrvgnd_1
XFILLER_142_114 VGND VGND VPWR VPWR sky130_fd_sc_hd__decap_3
X_0681_ _0001_ Tile_X0Y1_OpenRAM_bot.Inst_OpenRAM_bot_ConfigMem.Inst_frame3_bit14.Q
+ _0217_ Tile_X0Y1_OpenRAM_bot.Inst_OpenRAM_bot_ConfigMem.Inst_frame3_bit13.Q VGND
+ VGND VPWR VPWR _0218_ sky130_fd_sc_hd__o22a_1
XFILLER_89_60 VGND VGND VPWR VPWR sky130_fd_sc_hd__fill_2
XFILLER_142_147 VGND VGND VPWR VPWR sky130_fd_sc_hd__fill_2
XFILLER_142_136 VGND VGND VPWR VPWR sky130_fd_sc_hd__decap_3
XFILLER_89_93 VGND VGND VPWR VPWR sky130_fd_sc_hd__decap_3
X_1302_ Tile_X0Y1_FrameStrobe[13] VGND VGND VPWR VPWR net453 sky130_fd_sc_hd__clkbuf_1
XFILLER_150_180 VGND VGND VPWR VPWR sky130_fd_sc_hd__decap_3
XFILLER_1_190 VGND VGND VPWR VPWR sky130_fd_sc_hd__decap_3
X_1233_ net235 net266 VGND VGND VPWR VPWR Tile_X0Y1_OpenRAM_bot.Inst_OpenRAM_bot_ConfigMem.Inst_frame8_bit21.Q
+ sky130_fd_sc_hd__dlxtp_1
XFILLER_49_161 VGND VGND VPWR VPWR sky130_fd_sc_hd__decap_3
XFILLER_49_172 VGND VGND VPWR VPWR sky130_fd_sc_hd__decap_3
XTAP_TAPCELL_ROW_67_638 VGND VPWR sky130_fd_sc_hd__tapvpwrvgnd_1
X_1164_ net240 net279 VGND VGND VPWR VPWR Tile_X0Y1_OpenRAM_bot.Inst_OpenRAM_bot_ConfigMem.Inst_frame6_bit26.Q
+ sky130_fd_sc_hd__dlxtp_1
XFILLER_49_194 VGND VGND VPWR VPWR sky130_fd_sc_hd__decap_3
X_1095_ net246 net299 VGND VGND VPWR VPWR Tile_X0Y1_OpenRAM_bot.Inst_OpenRAM_bot_ConfigMem.Inst_frame4_bit31.Q
+ sky130_fd_sc_hd__dlxtp_1
XTAP_TAPCELL_ROW_35_513 VGND VPWR sky130_fd_sc_hd__tapvpwrvgnd_1
XFILLER_64_164 VGND VGND VPWR VPWR sky130_fd_sc_hd__fill_2
XFILLER_64_175 VGND VGND VPWR VPWR sky130_fd_sc_hd__decap_3
XTAP_TAPCELL_ROW_75_671 VGND VPWR sky130_fd_sc_hd__tapvpwrvgnd_1
XFILLER_64_197 VGND VGND VPWR VPWR sky130_fd_sc_hd__decap_3
XFILLER_20_212 VGND VGND VPWR VPWR sky130_fd_sc_hd__decap_3
XFILLER_165_228 VGND VGND VPWR VPWR sky130_fd_sc_hd__fill_2
XFILLER_165_217 VGND VGND VPWR VPWR sky130_fd_sc_hd__decap_3
XFILLER_118_111 VGND VGND VPWR VPWR sky130_fd_sc_hd__decap_3
X_0948_ net137 net269 VGND VGND VPWR VPWR Tile_X0Y0_OpenRAM_top.Inst_OpenRAM_top_ConfigMem.Inst_frame8_bit30.Q
+ sky130_fd_sc_hd__dlxtp_1
XFILLER_118_144 VGND VGND VPWR VPWR sky130_fd_sc_hd__decap_3
XFILLER_118_177 VGND VGND VPWR VPWR sky130_fd_sc_hd__decap_3
X_0879_ net139 net292 VGND VGND VPWR VPWR Tile_X0Y0_OpenRAM_top.Inst_OpenRAM_top_ConfigMem.Inst_frame5_bit3.Q
+ sky130_fd_sc_hd__dlxtp_1
XFILLER_133_169 VGND VGND VPWR VPWR sky130_fd_sc_hd__decap_3
XFILLER_125_36 VGND VGND VPWR VPWR sky130_fd_sc_hd__decap_3
XTAP_TAPCELL_ROW_98_763 VGND VPWR sky130_fd_sc_hd__tapvpwrvgnd_1
XFILLER_47_109 VGND VGND VPWR VPWR sky130_fd_sc_hd__decap_3
XTAP_TAPCELL_ROW_58_605 VGND VPWR sky130_fd_sc_hd__tapvpwrvgnd_1
XFILLER_141_46 VGND VGND VPWR VPWR sky130_fd_sc_hd__decap_3
XFILLER_55_142 VGND VGND VPWR VPWR sky130_fd_sc_hd__decap_3
XFILLER_55_175 VGND VGND VPWR VPWR sky130_fd_sc_hd__decap_3
XFILLER_11_223 VGND VGND VPWR VPWR sky130_fd_sc_hd__fill_1
XFILLER_34_88 VGND VGND VPWR VPWR sky130_fd_sc_hd__decap_3
XTAP_TAPCELL_ROW_81_696 VGND VPWR sky130_fd_sc_hd__tapvpwrvgnd_1
XFILLER_156_206 VGND VGND VPWR VPWR sky130_fd_sc_hd__decap_3
XFILLER_7_205 VGND VGND VPWR VPWR sky130_fd_sc_hd__decap_3
XFILLER_109_122 VGND VGND VPWR VPWR sky130_fd_sc_hd__decap_3
XFILLER_50_32 VGND VGND VPWR VPWR sky130_fd_sc_hd__decap_3
XFILLER_166_32 VGND VGND VPWR VPWR sky130_fd_sc_hd__decap_3
XFILLER_166_21 VGND VGND VPWR VPWR sky130_fd_sc_hd__decap_3
XFILLER_50_65 VGND VGND VPWR VPWR sky130_fd_sc_hd__decap_3
XFILLER_166_76 VGND VGND VPWR VPWR sky130_fd_sc_hd__decap_3
XFILLER_109_199 VGND VGND VPWR VPWR sky130_fd_sc_hd__decap_3
XFILLER_124_147 VGND VGND VPWR VPWR sky130_fd_sc_hd__decap_3
XFILLER_124_136 VGND VGND VPWR VPWR sky130_fd_sc_hd__decap_3
XFILLER_59_52 VGND VGND VPWR VPWR sky130_fd_sc_hd__decap_3
XFILLER_132_180 VGND VGND VPWR VPWR sky130_fd_sc_hd__decap_3
XFILLER_59_63 VGND VGND VPWR VPWR sky130_fd_sc_hd__decap_3
XFILLER_78_212 VGND VGND VPWR VPWR sky130_fd_sc_hd__fill_2
XFILLER_59_96 VGND VGND VPWR VPWR sky130_fd_sc_hd__decap_3
Xfanout291 net294 VGND VGND VPWR VPWR net291 sky130_fd_sc_hd__clkbuf_4
Xfanout280 net281 VGND VGND VPWR VPWR net280 sky130_fd_sc_hd__buf_2
XFILLER_75_40 VGND VGND VPWR VPWR sky130_fd_sc_hd__decap_3
XTAP_TAPCELL_ROW_116_834 VGND VPWR sky130_fd_sc_hd__tapvpwrvgnd_1
XFILLER_46_197 VGND VGND VPWR VPWR sky130_fd_sc_hd__decap_3
XFILLER_131_90 VGND VGND VPWR VPWR sky130_fd_sc_hd__decap_3
XFILLER_98_6 VGND VGND VPWR VPWR sky130_fd_sc_hd__decap_3
X_0802_ net121 net310 VGND VGND VPWR VPWR Tile_X0Y0_OpenRAM_top.Inst_OpenRAM_top_ConfigMem.Inst_frame3_bit16.Q
+ sky130_fd_sc_hd__dlxtp_1
X_0733_ net127 net326 VGND VGND VPWR VPWR Tile_X0Y0_OpenRAM_top.Inst_OpenRAM_top_ConfigMem.Inst_frame1_bit21.Q
+ sky130_fd_sc_hd__dlxtp_1
XFILLER_115_136 VGND VGND VPWR VPWR sky130_fd_sc_hd__fill_1
X_0664_ _0150_ _0146_ Tile_X0Y1_OpenRAM_bot.Inst_OpenRAM_bot_ConfigMem.Inst_frame6_bit2.Q
+ VGND VGND VPWR VPWR _0203_ sky130_fd_sc_hd__mux2_1
XFILLER_130_106 VGND VGND VPWR VPWR sky130_fd_sc_hd__fill_1
XFILLER_115_169 VGND VGND VPWR VPWR sky130_fd_sc_hd__decap_3
XTAP_TAPCELL_ROW_139_926 VGND VPWR sky130_fd_sc_hd__tapvpwrvgnd_1
XFILLER_130_128 VGND VGND VPWR VPWR sky130_fd_sc_hd__decap_3
X_0595_ net180 _0024_ _0161_ VGND VGND VPWR VPWR _0162_ sky130_fd_sc_hd__o21a_1
XTAP_TAPCELL_ROW_107_801 VGND VPWR sky130_fd_sc_hd__tapvpwrvgnd_1
XFILLER_37_120 VGND VGND VPWR VPWR sky130_fd_sc_hd__decap_3
X_1216_ net250 net273 VGND VGND VPWR VPWR Tile_X0Y1_OpenRAM_bot.Inst_OpenRAM_bot_ConfigMem.Inst_frame7_bit6.Q
+ sky130_fd_sc_hd__dlxtp_1
X_1147_ net224 net288 VGND VGND VPWR VPWR Tile_X0Y1_OpenRAM_bot.Inst_OpenRAM_bot_ConfigMem.Inst_frame5_bit11.Q
+ sky130_fd_sc_hd__dlxtp_1
XFILLER_1_81 VGND VGND VPWR VPWR sky130_fd_sc_hd__decap_3
XFILLER_37_153 VGND VGND VPWR VPWR sky130_fd_sc_hd__fill_2
XFILLER_37_175 VGND VGND VPWR VPWR sky130_fd_sc_hd__decap_3
XFILLER_111_27 VGND VGND VPWR VPWR sky130_fd_sc_hd__decap_3
XTAP_TAPCELL_ROW_122_859 VGND VPWR sky130_fd_sc_hd__tapvpwrvgnd_1
XFILLER_52_167 VGND VGND VPWR VPWR sky130_fd_sc_hd__fill_1
X_1078_ net229 net305 VGND VGND VPWR VPWR Tile_X0Y1_OpenRAM_bot.Inst_OpenRAM_bot_ConfigMem.Inst_frame3_bit16.Q
+ sky130_fd_sc_hd__dlxtp_1
XFILLER_138_206 VGND VGND VPWR VPWR sky130_fd_sc_hd__fill_1
XTAP_TAPCELL_ROW_130_892 VGND VPWR sky130_fd_sc_hd__tapvpwrvgnd_1
XFILLER_106_103 VGND VGND VPWR VPWR sky130_fd_sc_hd__decap_3
XFILLER_136_35 VGND VGND VPWR VPWR sky130_fd_sc_hd__decap_3
XFILLER_106_147 VGND VGND VPWR VPWR sky130_fd_sc_hd__decap_3
XFILLER_20_35 VGND VGND VPWR VPWR sky130_fd_sc_hd__fill_2
XFILLER_136_68 VGND VGND VPWR VPWR sky130_fd_sc_hd__decap_3
XFILLER_114_191 VGND VGND VPWR VPWR sky130_fd_sc_hd__decap_3
XFILLER_152_56 VGND VGND VPWR VPWR sky130_fd_sc_hd__decap_3
XTAP_TAPCELL_ROW_153_984 VGND VPWR sky130_fd_sc_hd__tapvpwrvgnd_1
XFILLER_43_134 VGND VGND VPWR VPWR sky130_fd_sc_hd__decap_3
XFILLER_45_32 VGND VGND VPWR VPWR sky130_fd_sc_hd__decap_3
XFILLER_43_167 VGND VGND VPWR VPWR sky130_fd_sc_hd__fill_1
XFILLER_43_189 VGND VGND VPWR VPWR sky130_fd_sc_hd__decap_3
XFILLER_177_42 VGND VGND VPWR VPWR sky130_fd_sc_hd__decap_3
XFILLER_129_228 VGND VGND VPWR VPWR sky130_fd_sc_hd__fill_2
XFILLER_61_75 VGND VGND VPWR VPWR sky130_fd_sc_hd__decap_3
XFILLER_177_75 VGND VGND VPWR VPWR sky130_fd_sc_hd__decap_3
XFILLER_144_209 VGND VGND VPWR VPWR sky130_fd_sc_hd__decap_3
XFILLER_6_15 VGND VGND VPWR VPWR sky130_fd_sc_hd__decap_3
XFILLER_6_59 VGND VGND VPWR VPWR sky130_fd_sc_hd__decap_3
XFILLER_112_106 VGND VGND VPWR VPWR sky130_fd_sc_hd__fill_1
XFILLER_112_128 VGND VGND VPWR VPWR sky130_fd_sc_hd__decap_3
X_0380_ net21 net53 net257 Tile_X0Y0_OpenRAM_top.Inst_OpenRAM_top_switch_matrix.J_NS2_BEG5
+ Tile_X0Y0_OpenRAM_top.Inst_OpenRAM_top_ConfigMem.Inst_frame5_bit16.Q Tile_X0Y0_OpenRAM_top.Inst_OpenRAM_top_ConfigMem.Inst_frame5_bit17.Q
+ VGND VGND VPWR VPWR Tile_X0Y0_OpenRAM_top.Inst_OpenRAM_top_switch_matrix.W2BEGb2
+ sky130_fd_sc_hd__mux4_1
XFILLER_66_215 VGND VGND VPWR VPWR sky130_fd_sc_hd__fill_2
XFILLER_19_131 VGND VGND VPWR VPWR sky130_fd_sc_hd__decap_3
XFILLER_19_164 VGND VGND VPWR VPWR sky130_fd_sc_hd__decap_3
X_1001_ net243 net322 VGND VGND VPWR VPWR Tile_X0Y1_OpenRAM_bot.Inst_OpenRAM_bot_ConfigMem.Inst_frame1_bit29.Q
+ sky130_fd_sc_hd__dlxtp_1
XFILLER_81_229 VGND VGND VPWR VPWR sky130_fd_sc_hd__fill_1
XFILLER_19_175 VGND VGND VPWR VPWR sky130_fd_sc_hd__decap_3
XPHY_EDGE_ROW_179_Right_179 VGND VGND VPWR VPWR sky130_fd_sc_hd__decap_3
XFILLER_179_128 VGND VGND VPWR VPWR sky130_fd_sc_hd__decap_3
XTAP_TAPCELL_ROW_60_611 VGND VPWR sky130_fd_sc_hd__tapvpwrvgnd_1
XFILLER_96_3 VGND VGND VPWR VPWR sky130_fd_sc_hd__decap_3
XFILLER_135_209 VGND VGND VPWR VPWR sky130_fd_sc_hd__decap_3
X_0716_ net142 net338 VGND VGND VPWR VPWR Tile_X0Y0_OpenRAM_top.Inst_OpenRAM_top_ConfigMem.Inst_frame0_bit6.Q
+ sky130_fd_sc_hd__dlxtp_1
X_0647_ Tile_X0Y1_OpenRAM_bot.Inst_OpenRAM_bot_ConfigMem.Inst_frame7_bit2.Q _0188_
+ VGND VGND VPWR VPWR _0189_ sky130_fd_sc_hd__and2b_1
XFILLER_106_38 VGND VGND VPWR VPWR sky130_fd_sc_hd__decap_3
X_0578_ net28 _0145_ _0149_ net263 Tile_X0Y1_OpenRAM_bot.Inst_OpenRAM_bot_ConfigMem.Inst_frame4_bit25.Q
+ Tile_X0Y1_OpenRAM_bot.Inst_OpenRAM_bot_ConfigMem.Inst_frame4_bit24.Q VGND VGND VPWR
+ VPWR Tile_X0Y1_OpenRAM_bot.Inst_OpenRAM_bot_switch_matrix.W6BEG4 sky130_fd_sc_hd__mux4_1
XFILLER_57_204 VGND VGND VPWR VPWR sky130_fd_sc_hd__decap_3
XTAP_TAPCELL_ROW_83_703 VGND VPWR sky130_fd_sc_hd__tapvpwrvgnd_1
XFILLER_25_123 VGND VGND VPWR VPWR sky130_fd_sc_hd__decap_3
XPHY_EDGE_ROW_146_Right_146 VGND VGND VPWR VPWR sky130_fd_sc_hd__decap_3
XFILLER_25_134 VGND VGND VPWR VPWR sky130_fd_sc_hd__decap_3
XFILLER_25_167 VGND VGND VPWR VPWR sky130_fd_sc_hd__fill_1
XFILLER_25_178 VGND VGND VPWR VPWR sky130_fd_sc_hd__decap_3
XFILLER_40_115 VGND VGND VPWR VPWR sky130_fd_sc_hd__decap_3
XFILLER_178_150 VGND VGND VPWR VPWR sky130_fd_sc_hd__decap_3
XFILLER_40_159 VGND VGND VPWR VPWR sky130_fd_sc_hd__decap_3
XFILLER_178_183 VGND VGND VPWR VPWR sky130_fd_sc_hd__decap_3
XFILLER_147_34 VGND VGND VPWR VPWR sky130_fd_sc_hd__decap_3
XFILLER_31_78 VGND VGND VPWR VPWR sky130_fd_sc_hd__decap_3
XFILLER_0_200 VGND VGND VPWR VPWR sky130_fd_sc_hd__decap_3
Xinput101 Tile_X0Y0_EE4END[12] VGND VGND VPWR VPWR net101 sky130_fd_sc_hd__dlymetal6s2s_1
Xinput134 Tile_X0Y0_FrameData[28] VGND VGND VPWR VPWR net134 sky130_fd_sc_hd__buf_4
Xinput123 Tile_X0Y0_FrameData[18] VGND VGND VPWR VPWR net123 sky130_fd_sc_hd__clkbuf_4
XFILLER_163_66 VGND VGND VPWR VPWR sky130_fd_sc_hd__decap_3
Xinput145 Tile_X0Y0_FrameData[9] VGND VGND VPWR VPWR net145 sky130_fd_sc_hd__clkbuf_4
Xinput112 Tile_X0Y0_EE4END[8] VGND VGND VPWR VPWR net112 sky130_fd_sc_hd__dlymetal6s2s_1
XFILLER_102_150 VGND VGND VPWR VPWR sky130_fd_sc_hd__decap_3
XFILLER_48_215 VGND VGND VPWR VPWR sky130_fd_sc_hd__decap_3
Xinput167 Tile_X0Y0_S4END[1] VGND VGND VPWR VPWR net167 sky130_fd_sc_hd__clkbuf_2
Xinput156 Tile_X0Y0_S2END[6] VGND VGND VPWR VPWR net156 sky130_fd_sc_hd__clkbuf_2
Xinput178 Tile_X0Y1_E2END[0] VGND VGND VPWR VPWR net178 sky130_fd_sc_hd__clkbuf_2
Xinput189 Tile_X0Y1_E2MID[3] VGND VGND VPWR VPWR net189 sky130_fd_sc_hd__buf_2
XFILLER_56_64 VGND VGND VPWR VPWR sky130_fd_sc_hd__decap_3
XFILLER_16_112 VGND VGND VPWR VPWR sky130_fd_sc_hd__decap_3
XFILLER_56_97 VGND VGND VPWR VPWR sky130_fd_sc_hd__decap_3
XPHY_EDGE_ROW_113_Right_113 VGND VGND VPWR VPWR sky130_fd_sc_hd__decap_3
XFILLER_16_156 VGND VGND VPWR VPWR sky130_fd_sc_hd__decap_3
XFILLER_176_109 VGND VGND VPWR VPWR sky130_fd_sc_hd__decap_3
XFILLER_31_137 VGND VGND VPWR VPWR sky130_fd_sc_hd__decap_3
XFILLER_72_74 VGND VGND VPWR VPWR sky130_fd_sc_hd__decap_3
XFILLER_72_85 VGND VGND VPWR VPWR sky130_fd_sc_hd__decap_3
XFILLER_169_172 VGND VGND VPWR VPWR sky130_fd_sc_hd__decap_3
XFILLER_82_9 VGND VGND VPWR VPWR sky130_fd_sc_hd__decap_3
XFILLER_125_220 VGND VGND VPWR VPWR sky130_fd_sc_hd__decap_3
X_0501_ _0137_ _0138_ _0139_ Tile_X0Y0_OpenRAM_top.Inst_OpenRAM_top_ConfigMem.Inst_frame6_bit12.Q
+ Tile_X0Y0_OpenRAM_top.Inst_OpenRAM_top_ConfigMem.Inst_frame6_bit13.Q VGND VGND VPWR
+ VPWR _0140_ sky130_fd_sc_hd__a221o_1
XFILLER_140_212 VGND VGND VPWR VPWR sky130_fd_sc_hd__decap_3
XFILLER_98_137 VGND VGND VPWR VPWR sky130_fd_sc_hd__decap_3
X_1481_ Tile_X0Y1_OpenRAM_bot.Inst_OpenRAM_bot_switch_matrix.W2BEGb7 VGND VGND VPWR
+ VPWR net641 sky130_fd_sc_hd__buf_1
XPHY_EDGE_ROW_176_Left_359 VGND VGND VPWR VPWR sky130_fd_sc_hd__decap_3
X_0432_ net109 net102 net93 Tile_X0Y0_OpenRAM_top.Inst_OpenRAM_top_switch_matrix.J_NS4_BEG5
+ Tile_X0Y0_OpenRAM_top.Inst_OpenRAM_top_ConfigMem.Inst_frame3_bit30.Q Tile_X0Y0_OpenRAM_top.Inst_OpenRAM_top_ConfigMem.Inst_frame3_bit31.Q
+ VGND VGND VPWR VPWR net399 sky130_fd_sc_hd__mux4_2
XFILLER_98_159 VGND VGND VPWR VPWR sky130_fd_sc_hd__decap_3
XFILLER_97_60 VGND VGND VPWR VPWR sky130_fd_sc_hd__decap_3
XFILLER_100_109 VGND VGND VPWR VPWR sky130_fd_sc_hd__decap_3
XFILLER_97_93 VGND VGND VPWR VPWR sky130_fd_sc_hd__fill_1
X_0363_ net194 _0017_ _0092_ VGND VGND VPWR VPWR _0093_ sky130_fd_sc_hd__o21a_1
X_0294_ Tile_X0Y0_OpenRAM_top.Inst_OpenRAM_top_ConfigMem.Inst_frame0_bit26.Q _0061_
+ _0002_ _0060_ VGND VGND VPWR VPWR _0062_ sky130_fd_sc_hd__a2bb2o_1
XFILLER_54_218 VGND VGND VPWR VPWR sky130_fd_sc_hd__decap_3
XFILLER_22_115 VGND VGND VPWR VPWR sky130_fd_sc_hd__decap_3
XFILLER_167_109 VGND VGND VPWR VPWR sky130_fd_sc_hd__decap_3
XFILLER_22_159 VGND VGND VPWR VPWR sky130_fd_sc_hd__fill_1
XFILLER_175_131 VGND VGND VPWR VPWR sky130_fd_sc_hd__decap_3
XFILLER_175_175 VGND VGND VPWR VPWR sky130_fd_sc_hd__decap_3
XFILLER_175_164 VGND VGND VPWR VPWR sky130_fd_sc_hd__decap_3
XFILLER_108_209 VGND VGND VPWR VPWR sky130_fd_sc_hd__decap_3
XFILLER_30_192 VGND VGND VPWR VPWR sky130_fd_sc_hd__decap_3
XFILLER_117_26 VGND VGND VPWR VPWR sky130_fd_sc_hd__decap_3
XFILLER_131_212 VGND VGND VPWR VPWR sky130_fd_sc_hd__decap_3
XFILLER_45_207 VGND VGND VPWR VPWR sky130_fd_sc_hd__decap_3
XFILLER_93_18 VGND VGND VPWR VPWR sky130_fd_sc_hd__decap_3
XFILLER_26_23 VGND VGND VPWR VPWR sky130_fd_sc_hd__decap_3
XFILLER_26_67 VGND VGND VPWR VPWR sky130_fd_sc_hd__decap_3
XFILLER_9_119 VGND VGND VPWR VPWR sky130_fd_sc_hd__decap_3
XFILLER_9_108 VGND VGND VPWR VPWR sky130_fd_sc_hd__decap_3
XFILLER_42_44 VGND VGND VPWR VPWR sky130_fd_sc_hd__decap_3
XFILLER_166_131 VGND VGND VPWR VPWR sky130_fd_sc_hd__decap_3
XFILLER_42_77 VGND VGND VPWR VPWR sky130_fd_sc_hd__decap_3
XFILLER_166_153 VGND VGND VPWR VPWR sky130_fd_sc_hd__decap_3
XFILLER_158_77 VGND VGND VPWR VPWR sky130_fd_sc_hd__decap_3
XFILLER_181_134 VGND VGND VPWR VPWR sky130_fd_sc_hd__fill_1
XFILLER_166_197 VGND VGND VPWR VPWR sky130_fd_sc_hd__decap_3
XFILLER_166_186 VGND VGND VPWR VPWR sky130_fd_sc_hd__decap_3
XFILLER_158_88 VGND VGND VPWR VPWR sky130_fd_sc_hd__decap_3
XFILLER_107_220 VGND VGND VPWR VPWR sky130_fd_sc_hd__decap_3
XFILLER_181_178 VGND VGND VPWR VPWR sky130_fd_sc_hd__decap_3
XFILLER_174_32 VGND VGND VPWR VPWR sky130_fd_sc_hd__decap_3
XFILLER_174_21 VGND VGND VPWR VPWR sky130_fd_sc_hd__decap_3
XFILLER_174_65 VGND VGND VPWR VPWR sky130_fd_sc_hd__decap_3
XFILLER_3_27 VGND VGND VPWR VPWR sky130_fd_sc_hd__decap_3
XFILLER_107_81 VGND VGND VPWR VPWR sky130_fd_sc_hd__decap_3
XFILLER_67_30 VGND VGND VPWR VPWR sky130_fd_sc_hd__decap_3
XTAP_TAPCELL_ROW_167_1040 VGND VPWR sky130_fd_sc_hd__tapvpwrvgnd_1
XFILLER_67_63 VGND VGND VPWR VPWR sky130_fd_sc_hd__decap_3
XTAP_TAPCELL_ROW_19_449 VGND VPWR sky130_fd_sc_hd__tapvpwrvgnd_1
XFILLER_83_84 VGND VGND VPWR VPWR sky130_fd_sc_hd__decap_3
X_0981_ net230 net331 VGND VGND VPWR VPWR Tile_X0Y1_OpenRAM_bot.Inst_OpenRAM_bot_ConfigMem.Inst_frame0_bit17.Q
+ sky130_fd_sc_hd__dlxtp_1
XFILLER_12_181 VGND VGND VPWR VPWR sky130_fd_sc_hd__decap_3
XFILLER_8_130 VGND VGND VPWR VPWR sky130_fd_sc_hd__decap_3
XFILLER_80_6 VGND VGND VPWR VPWR sky130_fd_sc_hd__decap_3
XTAP_TAPCELL_ROW_174_1066 VGND VPWR sky130_fd_sc_hd__tapvpwrvgnd_1
XFILLER_157_153 VGND VGND VPWR VPWR sky130_fd_sc_hd__decap_3
XFILLER_8_141 VGND VGND VPWR VPWR sky130_fd_sc_hd__decap_3
XFILLER_172_112 VGND VGND VPWR VPWR sky130_fd_sc_hd__decap_3
XFILLER_8_174 VGND VGND VPWR VPWR sky130_fd_sc_hd__decap_3
Xoutput416 net499 VGND VGND VPWR VPWR Tile_X0Y0_N4BEG[4] sky130_fd_sc_hd__buf_2
Xoutput405 net488 VGND VGND VPWR VPWR Tile_X0Y0_N2BEGb[7] sky130_fd_sc_hd__buf_2
XFILLER_172_156 VGND VGND VPWR VPWR sky130_fd_sc_hd__decap_3
XFILLER_172_189 VGND VGND VPWR VPWR sky130_fd_sc_hd__decap_3
Xoutput449 net532 VGND VGND VPWR VPWR Tile_X0Y0_W6BEG[4] sky130_fd_sc_hd__buf_2
Xoutput438 net521 VGND VGND VPWR VPWR Tile_X0Y0_W2BEGb[3] sky130_fd_sc_hd__buf_2
XFILLER_113_223 VGND VGND VPWR VPWR sky130_fd_sc_hd__fill_1
Xoutput427 net510 VGND VGND VPWR VPWR Tile_X0Y0_W2BEG[0] sky130_fd_sc_hd__buf_2
X_1464_ Tile_X0Y1_OpenRAM_bot.Inst_OpenRAM_bot_switch_matrix.W1BEG2 VGND VGND VPWR
+ VPWR net624 sky130_fd_sc_hd__clkbuf_2
X_0415_ net361 net166 Tile_X0Y0_OpenRAM_top.Inst_OpenRAM_top_switch_matrix.J_NS4_BEG11
+ Tile_X0Y0_OpenRAM_top.Inst_OpenRAM_top_switch_matrix.J_NS4_BEG15 Tile_X0Y0_OpenRAM_top.Inst_OpenRAM_top_ConfigMem.Inst_frame4_bit28.Q
+ Tile_X0Y0_OpenRAM_top.Inst_OpenRAM_top_ConfigMem.Inst_frame4_bit29.Q VGND VGND VPWR
+ VPWR Tile_X0Y0_OpenRAM_top.Inst_OpenRAM_top_switch_matrix.W6BEG0 sky130_fd_sc_hd__mux4_1
XFILLER_86_118 VGND VGND VPWR VPWR sky130_fd_sc_hd__decap_3
X_1395_ net233 VGND VGND VPWR VPWR net565 sky130_fd_sc_hd__buf_6
XFILLER_94_162 VGND VGND VPWR VPWR sky130_fd_sc_hd__decap_3
X_0346_ Tile_X0Y0_OpenRAM_top.Inst_OpenRAM_top_switch_matrix.N2BEGb5 net163 net354
+ net155 Tile_X0Y0_OpenRAM_top.Inst_OpenRAM_top_ConfigMem.Inst_frame0_bit19.Q Tile_X0Y0_OpenRAM_top.Inst_OpenRAM_top_ConfigMem.Inst_frame0_bit18.Q
+ VGND VGND VPWR VPWR Tile_X0Y0_OpenRAM_top.Inst_OpenRAM_top_switch_matrix.J_NS2_BEG5
+ sky130_fd_sc_hd__mux4_2
XFILLER_103_39 VGND VGND VPWR VPWR sky130_fd_sc_hd__fill_1
XFILLER_27_218 VGND VGND VPWR VPWR sky130_fd_sc_hd__decap_3
X_0277_ Tile_X0Y1_OpenRAM_bot.Inst_OpenRAM_bot_ConfigMem.Inst_frame2_bit30.Q Tile_X0Y0_OpenRAM_top.Inst_OpenRAM_top_switch_matrix.S2BEG0
+ Tile_X0Y1_OpenRAM_bot.Inst_OpenRAM_bot_ConfigMem.Inst_frame2_bit29.Q VGND VGND VPWR
+ VPWR _0046_ sky130_fd_sc_hd__o21a_1
XFILLER_50_232 VGND VGND VPWR VPWR sky130_fd_sc_hd__fill_2
XFILLER_10_118 VGND VGND VPWR VPWR sky130_fd_sc_hd__decap_3
XFILLER_148_153 VGND VGND VPWR VPWR sky130_fd_sc_hd__decap_3
XFILLER_148_186 VGND VGND VPWR VPWR sky130_fd_sc_hd__decap_3
XFILLER_128_58 VGND VGND VPWR VPWR sky130_fd_sc_hd__decap_3
XFILLER_88_18 VGND VGND VPWR VPWR sky130_fd_sc_hd__decap_3
XFILLER_104_212 VGND VGND VPWR VPWR sky130_fd_sc_hd__decap_3
XFILLER_88_29 VGND VGND VPWR VPWR sky130_fd_sc_hd__decap_3
XFILLER_144_57 VGND VGND VPWR VPWR sky130_fd_sc_hd__decap_3
XFILLER_37_33 VGND VGND VPWR VPWR sky130_fd_sc_hd__decap_3
XFILLER_18_218 VGND VGND VPWR VPWR sky130_fd_sc_hd__decap_3
XFILLER_37_66 VGND VGND VPWR VPWR sky130_fd_sc_hd__decap_3
XFILLER_85_184 VGND VGND VPWR VPWR sky130_fd_sc_hd__decap_3
XFILLER_37_99 VGND VGND VPWR VPWR sky130_fd_sc_hd__decap_3
XFILLER_169_21 VGND VGND VPWR VPWR sky130_fd_sc_hd__decap_3
XFILLER_53_21 VGND VGND VPWR VPWR sky130_fd_sc_hd__decap_3
XFILLER_169_54 VGND VGND VPWR VPWR sky130_fd_sc_hd__fill_2
XFILLER_169_87 VGND VGND VPWR VPWR sky130_fd_sc_hd__decap_3
XFILLER_53_98 VGND VGND VPWR VPWR sky130_fd_sc_hd__decap_3
XFILLER_154_134 VGND VGND VPWR VPWR sky130_fd_sc_hd__decap_3
XFILLER_5_122 VGND VGND VPWR VPWR sky130_fd_sc_hd__decap_3
XFILLER_5_111 VGND VGND VPWR VPWR sky130_fd_sc_hd__fill_1
XFILLER_154_156 VGND VGND VPWR VPWR sky130_fd_sc_hd__decap_3
XFILLER_5_155 VGND VGND VPWR VPWR sky130_fd_sc_hd__decap_3
XFILLER_154_189 VGND VGND VPWR VPWR sky130_fd_sc_hd__decap_3
XFILLER_118_80 VGND VGND VPWR VPWR sky130_fd_sc_hd__decap_3
XFILLER_5_199 VGND VGND VPWR VPWR sky130_fd_sc_hd__decap_3
XFILLER_78_62 VGND VGND VPWR VPWR sky130_fd_sc_hd__decap_3
XFILLER_68_129 VGND VGND VPWR VPWR sky130_fd_sc_hd__decap_3
X_1180_ net223 net279 VGND VGND VPWR VPWR Tile_X0Y1_OpenRAM_bot.Inst_OpenRAM_bot_ConfigMem.Inst_frame6_bit10.Q
+ sky130_fd_sc_hd__dlxtp_1
XFILLER_76_162 VGND VGND VPWR VPWR sky130_fd_sc_hd__decap_3
XFILLER_76_184 VGND VGND VPWR VPWR sky130_fd_sc_hd__decap_3
XFILLER_94_94 VGND VGND VPWR VPWR sky130_fd_sc_hd__decap_3
XTAP_TAPCELL_ROW_180_1092 VGND VPWR sky130_fd_sc_hd__tapvpwrvgnd_1
XFILLER_32_221 VGND VGND VPWR VPWR sky130_fd_sc_hd__decap_3
XTAP_TAPCELL_ROW_15_430 VGND VPWR sky130_fd_sc_hd__tapvpwrvgnd_1
X_0964_ net119 net269 VGND VGND VPWR VPWR Tile_X0Y0_OpenRAM_top.Inst_OpenRAM_top_ConfigMem.Inst_frame8_bit14.Q
+ sky130_fd_sc_hd__dlxtp_1
X_0895_ net124 net284 VGND VGND VPWR VPWR Tile_X0Y0_OpenRAM_top.Inst_OpenRAM_top_ConfigMem.Inst_frame6_bit19.Q
+ sky130_fd_sc_hd__dlxtp_1
XFILLER_160_104 VGND VGND VPWR VPWR sky130_fd_sc_hd__decap_3
XFILLER_145_189 VGND VGND VPWR VPWR sky130_fd_sc_hd__decap_3
XFILLER_99_210 VGND VGND VPWR VPWR sky130_fd_sc_hd__decap_3
XFILLER_160_159 VGND VGND VPWR VPWR sky130_fd_sc_hd__decap_3
X_1447_ Tile_X0Y0_S4END[9] VGND VGND VPWR VPWR net613 sky130_fd_sc_hd__buf_6
X_1378_ Tile_X0Y0_OpenRAM_top.Inst_OpenRAM_top_switch_matrix.WW4BEG0 VGND VGND VPWR
+ VPWR net538 sky130_fd_sc_hd__buf_1
XFILLER_114_38 VGND VGND VPWR VPWR sky130_fd_sc_hd__decap_3
XFILLER_67_140 VGND VGND VPWR VPWR sky130_fd_sc_hd__fill_2
XTAP_TAPCELL_ROW_38_522 VGND VPWR sky130_fd_sc_hd__tapvpwrvgnd_1
XFILLER_82_110 VGND VGND VPWR VPWR sky130_fd_sc_hd__decap_3
X_0329_ net351 Tile_X0Y0_OpenRAM_top.Inst_OpenRAM_top_switch_matrix.S2BEG2 net343
+ net160 Tile_X0Y1_OpenRAM_bot.Inst_OpenRAM_bot_ConfigMem.Inst_frame0_bit13.Q Tile_X0Y1_OpenRAM_bot.Inst_OpenRAM_bot_ConfigMem.Inst_frame0_bit12.Q
+ VGND VGND VPWR VPWR _0082_ sky130_fd_sc_hd__mux4_2
XFILLER_82_176 VGND VGND VPWR VPWR sky130_fd_sc_hd__decap_3
XFILLER_23_221 VGND VGND VPWR VPWR sky130_fd_sc_hd__decap_3
XFILLER_168_215 VGND VGND VPWR VPWR sky130_fd_sc_hd__decap_3
XFILLER_139_24 VGND VGND VPWR VPWR sky130_fd_sc_hd__decap_3
XFILLER_23_57 VGND VGND VPWR VPWR sky130_fd_sc_hd__fill_1
XFILLER_139_57 VGND VGND VPWR VPWR sky130_fd_sc_hd__decap_3
XTAP_TAPCELL_ROW_21_455 VGND VPWR sky130_fd_sc_hd__tapvpwrvgnd_1
XFILLER_136_156 VGND VGND VPWR VPWR sky130_fd_sc_hd__decap_3
XFILLER_136_134 VGND VGND VPWR VPWR sky130_fd_sc_hd__decap_3
XFILLER_99_39 VGND VGND VPWR VPWR sky130_fd_sc_hd__decap_3
XFILLER_2_103 VGND VGND VPWR VPWR sky130_fd_sc_hd__decap_3
XFILLER_151_159 VGND VGND VPWR VPWR sky130_fd_sc_hd__fill_2
XFILLER_151_137 VGND VGND VPWR VPWR sky130_fd_sc_hd__decap_3
XFILLER_2_136 VGND VGND VPWR VPWR sky130_fd_sc_hd__decap_3
XFILLER_48_21 VGND VGND VPWR VPWR sky130_fd_sc_hd__decap_3
XFILLER_48_32 VGND VGND VPWR VPWR sky130_fd_sc_hd__decap_3
XFILLER_171_33 VGND VGND VPWR VPWR sky130_fd_sc_hd__decap_3
XFILLER_48_65 VGND VGND VPWR VPWR sky130_fd_sc_hd__decap_3
XFILLER_171_66 VGND VGND VPWR VPWR sky130_fd_sc_hd__decap_3
XFILLER_58_162 VGND VGND VPWR VPWR sky130_fd_sc_hd__decap_3
XFILLER_73_110 VGND VGND VPWR VPWR sky130_fd_sc_hd__fill_2
XFILLER_171_99 VGND VGND VPWR VPWR sky130_fd_sc_hd__decap_3
XFILLER_104_71 VGND VGND VPWR VPWR sky130_fd_sc_hd__decap_3
XFILLER_58_195 VGND VGND VPWR VPWR sky130_fd_sc_hd__fill_1
XFILLER_73_143 VGND VGND VPWR VPWR sky130_fd_sc_hd__decap_3
XFILLER_14_221 VGND VGND VPWR VPWR sky130_fd_sc_hd__decap_3
XTAP_TAPCELL_ROW_44_547 VGND VPWR sky130_fd_sc_hd__tapvpwrvgnd_1
XFILLER_64_97 VGND VGND VPWR VPWR sky130_fd_sc_hd__decap_3
XFILLER_159_204 VGND VGND VPWR VPWR sky130_fd_sc_hd__decap_3
XFILLER_9_15 VGND VGND VPWR VPWR sky130_fd_sc_hd__decap_3
XFILLER_120_81 VGND VGND VPWR VPWR sky130_fd_sc_hd__decap_3
XFILLER_9_48 VGND VGND VPWR VPWR sky130_fd_sc_hd__decap_3
XTAP_TAPCELL_ROW_52_580 VGND VPWR sky130_fd_sc_hd__tapvpwrvgnd_1
XFILLER_174_218 VGND VGND VPWR VPWR sky130_fd_sc_hd__decap_3
XFILLER_80_85 VGND VGND VPWR VPWR sky130_fd_sc_hd__fill_1
XFILLER_127_145 VGND VGND VPWR VPWR sky130_fd_sc_hd__decap_3
X_0680_ net160 Tile_X0Y1_OpenRAM_bot.Inst_OpenRAM_bot_ConfigMem.Inst_frame3_bit14.Q
+ VGND VGND VPWR VPWR _0217_ sky130_fd_sc_hd__and2b_1
XFILLER_129_90 VGND VGND VPWR VPWR sky130_fd_sc_hd__decap_3
XFILLER_127_178 VGND VGND VPWR VPWR sky130_fd_sc_hd__decap_3
XFILLER_127_167 VGND VGND VPWR VPWR sky130_fd_sc_hd__fill_1
XFILLER_150_192 VGND VGND VPWR VPWR sky130_fd_sc_hd__decap_3
X_1301_ Tile_X0Y1_FrameStrobe[12] VGND VGND VPWR VPWR net452 sky130_fd_sc_hd__buf_6
XPHY_EDGE_ROW_8_Left_191 VGND VGND VPWR VPWR sky130_fd_sc_hd__decap_3
XFILLER_49_140 VGND VGND VPWR VPWR sky130_fd_sc_hd__decap_3
X_1232_ net236 net264 VGND VGND VPWR VPWR Tile_X0Y1_OpenRAM_bot.Inst_OpenRAM_bot_ConfigMem.Inst_frame8_bit22.Q
+ sky130_fd_sc_hd__dlxtp_1
XTAP_TAPCELL_ROW_67_639 VGND VPWR sky130_fd_sc_hd__tapvpwrvgnd_1
X_1163_ net241 net279 VGND VGND VPWR VPWR Tile_X0Y1_OpenRAM_bot.Inst_OpenRAM_bot_ConfigMem.Inst_frame6_bit27.Q
+ sky130_fd_sc_hd__dlxtp_1
XFILLER_64_121 VGND VGND VPWR VPWR sky130_fd_sc_hd__decap_3
X_1094_ net222 net307 VGND VGND VPWR VPWR Tile_X0Y1_OpenRAM_bot.Inst_OpenRAM_bot_ConfigMem.Inst_frame3_bit0.Q
+ sky130_fd_sc_hd__dlxtp_1
XTAP_TAPCELL_ROW_75_672 VGND VPWR sky130_fd_sc_hd__tapvpwrvgnd_1
XFILLER_64_187 VGND VGND VPWR VPWR sky130_fd_sc_hd__decap_3
XFILLER_100_18 VGND VGND VPWR VPWR sky130_fd_sc_hd__decap_3
XFILLER_100_29 VGND VGND VPWR VPWR sky130_fd_sc_hd__decap_3
XFILLER_20_224 VGND VGND VPWR VPWR sky130_fd_sc_hd__decap_3
XFILLER_118_123 VGND VGND VPWR VPWR sky130_fd_sc_hd__decap_3
X_0947_ net138 net269 VGND VGND VPWR VPWR Tile_X0Y0_OpenRAM_top.Inst_OpenRAM_top_ConfigMem.Inst_frame8_bit31.Q
+ sky130_fd_sc_hd__dlxtp_1
XFILLER_118_156 VGND VGND VPWR VPWR sky130_fd_sc_hd__decap_3
XFILLER_109_27 VGND VGND VPWR VPWR sky130_fd_sc_hd__decap_3
X_0878_ net140 net291 VGND VGND VPWR VPWR Tile_X0Y0_OpenRAM_top.Inst_OpenRAM_top_ConfigMem.Inst_frame5_bit4.Q
+ sky130_fd_sc_hd__dlxtp_1
XFILLER_118_189 VGND VGND VPWR VPWR sky130_fd_sc_hd__decap_3
XFILLER_133_137 VGND VGND VPWR VPWR sky130_fd_sc_hd__decap_3
XFILLER_141_181 VGND VGND VPWR VPWR sky130_fd_sc_hd__decap_3
XTAP_TAPCELL_ROW_98_764 VGND VPWR sky130_fd_sc_hd__tapvpwrvgnd_1
XFILLER_18_35 VGND VGND VPWR VPWR sky130_fd_sc_hd__decap_3
XFILLER_18_24 VGND VGND VPWR VPWR sky130_fd_sc_hd__decap_3
XFILLER_141_25 VGND VGND VPWR VPWR sky130_fd_sc_hd__decap_3
XFILLER_141_69 VGND VGND VPWR VPWR sky130_fd_sc_hd__decap_3
XFILLER_55_154 VGND VGND VPWR VPWR sky130_fd_sc_hd__decap_3
XFILLER_70_124 VGND VGND VPWR VPWR sky130_fd_sc_hd__decap_3
XFILLER_70_157 VGND VGND VPWR VPWR sky130_fd_sc_hd__decap_3
XFILLER_34_67 VGND VGND VPWR VPWR sky130_fd_sc_hd__decap_3
XTAP_TAPCELL_ROW_81_697 VGND VPWR sky130_fd_sc_hd__tapvpwrvgnd_1
XFILLER_7_228 VGND VGND VPWR VPWR sky130_fd_sc_hd__decap_3
XFILLER_7_217 VGND VGND VPWR VPWR sky130_fd_sc_hd__decap_3
XFILLER_50_22 VGND VGND VPWR VPWR sky130_fd_sc_hd__decap_3
Xclkload0 clknet_1_1__leaf_Tile_X0Y1_UserCLK VGND VGND VPWR VPWR clkload0/X sky130_fd_sc_hd__clkbuf_4
XFILLER_50_44 VGND VGND VPWR VPWR sky130_fd_sc_hd__decap_3
XFILLER_166_44 VGND VGND VPWR VPWR sky130_fd_sc_hd__decap_3
XFILLER_124_115 VGND VGND VPWR VPWR sky130_fd_sc_hd__decap_3
XFILLER_109_178 VGND VGND VPWR VPWR sky130_fd_sc_hd__decap_3
XFILLER_50_77 VGND VGND VPWR VPWR sky130_fd_sc_hd__decap_3
XFILLER_50_88 VGND VGND VPWR VPWR sky130_fd_sc_hd__decap_3
XFILLER_166_88 VGND VGND VPWR VPWR sky130_fd_sc_hd__decap_3
XFILLER_124_159 VGND VGND VPWR VPWR sky130_fd_sc_hd__decap_3
XFILLER_78_224 VGND VGND VPWR VPWR sky130_fd_sc_hd__fill_2
XFILLER_132_192 VGND VGND VPWR VPWR sky130_fd_sc_hd__decap_3
XFILLER_115_81 VGND VGND VPWR VPWR sky130_fd_sc_hd__decap_3
Xfanout292 net294 VGND VGND VPWR VPWR net292 sky130_fd_sc_hd__clkbuf_2
Xfanout270 net271 VGND VGND VPWR VPWR net270 sky130_fd_sc_hd__buf_2
Xfanout281 net286 VGND VGND VPWR VPWR net281 sky130_fd_sc_hd__buf_2
XTAP_TAPCELL_ROW_116_835 VGND VPWR sky130_fd_sc_hd__tapvpwrvgnd_1
XFILLER_75_85 VGND VGND VPWR VPWR sky130_fd_sc_hd__decap_3
XFILLER_61_113 VGND VGND VPWR VPWR sky130_fd_sc_hd__decap_3
X_0801_ net122 net310 VGND VGND VPWR VPWR Tile_X0Y0_OpenRAM_top.Inst_OpenRAM_top_ConfigMem.Inst_frame3_bit17.Q
+ sky130_fd_sc_hd__dlxtp_1
X_0732_ net128 net328 VGND VGND VPWR VPWR Tile_X0Y0_OpenRAM_top.Inst_OpenRAM_top_ConfigMem.Inst_frame1_bit22.Q
+ sky130_fd_sc_hd__dlxtp_1
XFILLER_170_221 VGND VGND VPWR VPWR sky130_fd_sc_hd__decap_3
X_0663_ _0199_ _0201_ _0202_ Tile_X0Y1_OpenRAM_bot.Inst_OpenRAM_bot_ConfigMem.Inst_frame6_bit1.Q
+ VGND VGND VPWR VPWR Tile_X0Y1_OpenRAM_bot.Inst_OpenRAM_bot_switch_matrix.S4BEG1
+ sky130_fd_sc_hd__o22a_1
XFILLER_69_202 VGND VGND VPWR VPWR sky130_fd_sc_hd__decap_3
X_0594_ net188 Tile_X0Y1_OpenRAM_bot.Inst_OpenRAM_bot_ConfigMem.Inst_frame3_bit24.Q
+ Tile_X0Y1_OpenRAM_bot.Inst_OpenRAM_bot_ConfigMem.Inst_frame3_bit25.Q VGND VGND VPWR
+ VPWR _0161_ sky130_fd_sc_hd__o21ba_1
XTAP_TAPCELL_ROW_139_927 VGND VPWR sky130_fd_sc_hd__tapvpwrvgnd_1
XTAP_TAPCELL_ROW_147_960 VGND VPWR sky130_fd_sc_hd__tapvpwrvgnd_1
XPHY_EDGE_ROW_127_Right_127 VGND VGND VPWR VPWR sky130_fd_sc_hd__decap_3
X_1215_ net251 net273 VGND VGND VPWR VPWR Tile_X0Y1_OpenRAM_bot.Inst_OpenRAM_bot_ConfigMem.Inst_frame7_bit7.Q
+ sky130_fd_sc_hd__dlxtp_1
X_1146_ net225 net289 VGND VGND VPWR VPWR Tile_X0Y1_OpenRAM_bot.Inst_OpenRAM_bot_ConfigMem.Inst_frame5_bit12.Q
+ sky130_fd_sc_hd__dlxtp_1
XFILLER_1_93 VGND VGND VPWR VPWR sky130_fd_sc_hd__decap_3
XFILLER_37_187 VGND VGND VPWR VPWR sky130_fd_sc_hd__decap_3
XFILLER_111_39 VGND VGND VPWR VPWR sky130_fd_sc_hd__decap_3
X_1077_ net230 net305 VGND VGND VPWR VPWR Tile_X0Y1_OpenRAM_bot.Inst_OpenRAM_bot_ConfigMem.Inst_frame3_bit17.Q
+ sky130_fd_sc_hd__dlxtp_1
XTAP_TAPCELL_ROW_130_893 VGND VPWR sky130_fd_sc_hd__tapvpwrvgnd_1
XFILLER_106_115 VGND VGND VPWR VPWR sky130_fd_sc_hd__decap_3
XFILLER_4_209 VGND VGND VPWR VPWR sky130_fd_sc_hd__decap_3
XFILLER_20_58 VGND VGND VPWR VPWR sky130_fd_sc_hd__decap_3
XFILLER_136_47 VGND VGND VPWR VPWR sky130_fd_sc_hd__decap_3
XFILLER_106_159 VGND VGND VPWR VPWR sky130_fd_sc_hd__decap_3
XFILLER_29_23 VGND VGND VPWR VPWR sky130_fd_sc_hd__decap_3
XFILLER_29_45 VGND VGND VPWR VPWR sky130_fd_sc_hd__decap_3
XFILLER_29_67 VGND VGND VPWR VPWR sky130_fd_sc_hd__decap_3
XFILLER_152_68 VGND VGND VPWR VPWR sky130_fd_sc_hd__decap_3
XFILLER_28_121 VGND VGND VPWR VPWR sky130_fd_sc_hd__fill_1
XFILLER_90_219 VGND VGND VPWR VPWR sky130_fd_sc_hd__decap_3
XTAP_TAPCELL_ROW_153_985 VGND VPWR sky130_fd_sc_hd__tapvpwrvgnd_1
XFILLER_43_102 VGND VGND VPWR VPWR sky130_fd_sc_hd__decap_3
XFILLER_43_113 VGND VGND VPWR VPWR sky130_fd_sc_hd__decap_3
XFILLER_45_44 VGND VGND VPWR VPWR sky130_fd_sc_hd__decap_3
XFILLER_43_146 VGND VGND VPWR VPWR sky130_fd_sc_hd__decap_3
XFILLER_129_207 VGND VGND VPWR VPWR sky130_fd_sc_hd__decap_3
XFILLER_177_21 VGND VGND VPWR VPWR sky130_fd_sc_hd__decap_3
XFILLER_61_54 VGND VGND VPWR VPWR sky130_fd_sc_hd__fill_2
XFILLER_177_54 VGND VGND VPWR VPWR sky130_fd_sc_hd__fill_2
XFILLER_61_87 VGND VGND VPWR VPWR sky130_fd_sc_hd__decap_3
XFILLER_177_87 VGND VGND VPWR VPWR sky130_fd_sc_hd__decap_3
XFILLER_6_38 VGND VGND VPWR VPWR sky130_fd_sc_hd__decap_3
XFILLER_6_27 VGND VGND VPWR VPWR sky130_fd_sc_hd__fill_1
XFILLER_3_220 VGND VGND VPWR VPWR sky130_fd_sc_hd__decap_3
XPHY_EDGE_ROW_89_Left_272 VGND VGND VPWR VPWR sky130_fd_sc_hd__decap_3
XFILLER_3_231 VGND VGND VPWR VPWR sky130_fd_sc_hd__decap_3
XFILLER_10_91 VGND VGND VPWR VPWR sky130_fd_sc_hd__decap_3
XFILLER_10_80 VGND VGND VPWR VPWR sky130_fd_sc_hd__decap_3
XFILLER_105_181 VGND VGND VPWR VPWR sky130_fd_sc_hd__decap_3
XFILLER_86_51 VGND VGND VPWR VPWR sky130_fd_sc_hd__decap_3
XFILLER_120_184 VGND VGND VPWR VPWR sky130_fd_sc_hd__decap_3
XFILLER_19_143 VGND VGND VPWR VPWR sky130_fd_sc_hd__decap_3
X_1000_ net245 net322 VGND VGND VPWR VPWR Tile_X0Y1_OpenRAM_bot.Inst_OpenRAM_bot_ConfigMem.Inst_frame1_bit30.Q
+ sky130_fd_sc_hd__dlxtp_1
XPHY_EDGE_ROW_98_Left_281 VGND VGND VPWR VPWR sky130_fd_sc_hd__decap_3
XFILLER_19_187 VGND VGND VPWR VPWR sky130_fd_sc_hd__decap_3
XTAP_TAPCELL_ROW_60_612 VGND VPWR sky130_fd_sc_hd__tapvpwrvgnd_1
XFILLER_89_3 VGND VGND VPWR VPWR sky130_fd_sc_hd__decap_3
X_0715_ net143 net338 VGND VGND VPWR VPWR Tile_X0Y0_OpenRAM_top.Inst_OpenRAM_top_ConfigMem.Inst_frame0_bit7.Q
+ sky130_fd_sc_hd__dlxtp_1
XFILLER_106_17 VGND VGND VPWR VPWR sky130_fd_sc_hd__decap_3
XFILLER_103_107 VGND VGND VPWR VPWR sky130_fd_sc_hd__decap_3
X_0646_ _0149_ _0145_ Tile_X0Y1_OpenRAM_bot.Inst_OpenRAM_bot_ConfigMem.Inst_frame7_bit1.Q
+ VGND VGND VPWR VPWR _0188_ sky130_fd_sc_hd__mux2_1
X_0577_ net360 net173 _0148_ Tile_X0Y1_OpenRAM_bot.Inst_OpenRAM_bot_switch_matrix.J_NS4_BEG12
+ Tile_X0Y1_OpenRAM_bot.Inst_OpenRAM_bot_ConfigMem.Inst_frame4_bit22.Q Tile_X0Y1_OpenRAM_bot.Inst_OpenRAM_bot_ConfigMem.Inst_frame4_bit23.Q
+ VGND VGND VPWR VPWR Tile_X0Y1_OpenRAM_bot.Inst_OpenRAM_bot_switch_matrix.W6BEG3
+ sky130_fd_sc_hd__mux4_1
XFILLER_111_151 VGND VGND VPWR VPWR sky130_fd_sc_hd__decap_3
XFILLER_122_38 VGND VGND VPWR VPWR sky130_fd_sc_hd__decap_3
XFILLER_72_219 VGND VGND VPWR VPWR sky130_fd_sc_hd__fill_1
XTAP_TAPCELL_ROW_83_704 VGND VPWR sky130_fd_sc_hd__tapvpwrvgnd_1
XFILLER_25_113 VGND VGND VPWR VPWR sky130_fd_sc_hd__decap_3
XFILLER_25_146 VGND VGND VPWR VPWR sky130_fd_sc_hd__decap_3
X_1129_ net243 net289 VGND VGND VPWR VPWR Tile_X0Y1_OpenRAM_bot.Inst_OpenRAM_bot_ConfigMem.Inst_frame5_bit29.Q
+ sky130_fd_sc_hd__dlxtp_1
XFILLER_15_25 VGND VGND VPWR VPWR sky130_fd_sc_hd__decap_3
XFILLER_15_69 VGND VGND VPWR VPWR sky130_fd_sc_hd__fill_1
XFILLER_40_127 VGND VGND VPWR VPWR sky130_fd_sc_hd__fill_1
XFILLER_178_162 VGND VGND VPWR VPWR sky130_fd_sc_hd__decap_3
XFILLER_178_195 VGND VGND VPWR VPWR sky130_fd_sc_hd__fill_1
XFILLER_31_35 VGND VGND VPWR VPWR sky130_fd_sc_hd__decap_3
XFILLER_147_57 VGND VGND VPWR VPWR sky130_fd_sc_hd__fill_1
XFILLER_147_46 VGND VGND VPWR VPWR sky130_fd_sc_hd__decap_3
XFILLER_134_221 VGND VGND VPWR VPWR sky130_fd_sc_hd__decap_3
XFILLER_0_212 VGND VGND VPWR VPWR sky130_fd_sc_hd__decap_3
Xinput102 Tile_X0Y0_EE4END[13] VGND VGND VPWR VPWR net102 sky130_fd_sc_hd__clkbuf_1
Xinput135 Tile_X0Y0_FrameData[29] VGND VGND VPWR VPWR net135 sky130_fd_sc_hd__buf_4
Xinput124 Tile_X0Y0_FrameData[19] VGND VGND VPWR VPWR net124 sky130_fd_sc_hd__clkbuf_4
Xinput113 Tile_X0Y0_EE4END[9] VGND VGND VPWR VPWR net113 sky130_fd_sc_hd__buf_1
XFILLER_102_162 VGND VGND VPWR VPWR sky130_fd_sc_hd__decap_3
Xinput157 Tile_X0Y0_S2END[7] VGND VGND VPWR VPWR net157 sky130_fd_sc_hd__clkbuf_2
Xinput146 Tile_X0Y0_S1END[0] VGND VGND VPWR VPWR net146 sky130_fd_sc_hd__buf_2
Xinput168 Tile_X0Y0_S4END[2] VGND VGND VPWR VPWR net168 sky130_fd_sc_hd__buf_2
XFILLER_102_184 VGND VGND VPWR VPWR sky130_fd_sc_hd__decap_3
XFILLER_48_227 VGND VGND VPWR VPWR sky130_fd_sc_hd__decap_3
XFILLER_56_21 VGND VGND VPWR VPWR sky130_fd_sc_hd__decap_3
XFILLER_56_32 VGND VGND VPWR VPWR sky130_fd_sc_hd__decap_3
Xinput179 Tile_X0Y1_E2END[1] VGND VGND VPWR VPWR net179 sky130_fd_sc_hd__buf_2
XFILLER_63_208 VGND VGND VPWR VPWR sky130_fd_sc_hd__decap_3
XFILLER_56_76 VGND VGND VPWR VPWR sky130_fd_sc_hd__decap_3
XPHY_EDGE_ROW_19_Right_19 VGND VGND VPWR VPWR sky130_fd_sc_hd__decap_3
XFILLER_16_124 VGND VGND VPWR VPWR sky130_fd_sc_hd__decap_3
XFILLER_16_168 VGND VGND VPWR VPWR sky130_fd_sc_hd__decap_3
XFILLER_31_116 VGND VGND VPWR VPWR sky130_fd_sc_hd__decap_3
XFILLER_72_53 VGND VGND VPWR VPWR sky130_fd_sc_hd__decap_3
XFILLER_169_184 VGND VGND VPWR VPWR sky130_fd_sc_hd__decap_3
XFILLER_169_162 VGND VGND VPWR VPWR sky130_fd_sc_hd__decap_3
X_0500_ net93 Tile_X0Y0_OpenRAM_top.Inst_OpenRAM_top_switch_matrix.J_NS4_BEG1 Tile_X0Y0_OpenRAM_top.Inst_OpenRAM_top_ConfigMem.Inst_frame6_bit11.Q
+ VGND VGND VPWR VPWR _0139_ sky130_fd_sc_hd__mux2_1
XFILLER_21_90 VGND VGND VPWR VPWR sky130_fd_sc_hd__decap_3
XPHY_EDGE_ROW_28_Right_28 VGND VGND VPWR VPWR sky130_fd_sc_hd__decap_3
XFILLER_140_224 VGND VGND VPWR VPWR sky130_fd_sc_hd__decap_3
X_1480_ Tile_X0Y1_OpenRAM_bot.Inst_OpenRAM_bot_switch_matrix.W2BEGb6 VGND VGND VPWR
+ VPWR net640 sky130_fd_sc_hd__clkbuf_2
X_0431_ net108 net101 net92 Tile_X0Y0_OpenRAM_top.Inst_OpenRAM_top_switch_matrix.J_NS4_BEG4
+ Tile_X0Y0_OpenRAM_top.Inst_OpenRAM_top_ConfigMem.Inst_frame3_bit28.Q Tile_X0Y0_OpenRAM_top.Inst_OpenRAM_top_ConfigMem.Inst_frame3_bit29.Q
+ VGND VGND VPWR VPWR net398 sky130_fd_sc_hd__mux4_2
XFILLER_97_72 VGND VGND VPWR VPWR sky130_fd_sc_hd__decap_3
X_0362_ net254 Tile_X0Y1_OpenRAM_bot.Inst_OpenRAM_bot_ConfigMem.Inst_frame0_bit24.Q
+ Tile_X0Y1_OpenRAM_bot.Inst_OpenRAM_bot_ConfigMem.Inst_frame0_bit25.Q VGND VGND VPWR
+ VPWR _0092_ sky130_fd_sc_hd__o21ba_1
X_0293_ net147 Tile_X0Y0_OpenRAM_top.Inst_OpenRAM_top_ConfigMem.Inst_frame0_bit27.Q
+ VGND VGND VPWR VPWR _0061_ sky130_fd_sc_hd__nand2_1
XTAP_TAPCELL_ROW_132_900 VGND VPWR sky130_fd_sc_hd__tapvpwrvgnd_1
XPHY_EDGE_ROW_37_Right_37 VGND VGND VPWR VPWR sky130_fd_sc_hd__decap_3
XFILLER_22_127 VGND VGND VPWR VPWR sky130_fd_sc_hd__decap_3
XFILLER_175_143 VGND VGND VPWR VPWR sky130_fd_sc_hd__decap_3
XFILLER_30_171 VGND VGND VPWR VPWR sky130_fd_sc_hd__decap_3
XPHY_EDGE_ROW_46_Right_46 VGND VGND VPWR VPWR sky130_fd_sc_hd__decap_3
XFILLER_175_187 VGND VGND VPWR VPWR sky130_fd_sc_hd__decap_3
XFILLER_116_221 VGND VGND VPWR VPWR sky130_fd_sc_hd__decap_3
XFILLER_7_81 VGND VGND VPWR VPWR sky130_fd_sc_hd__decap_3
XFILLER_117_38 VGND VGND VPWR VPWR sky130_fd_sc_hd__decap_3
XFILLER_89_105 VGND VGND VPWR VPWR sky130_fd_sc_hd__decap_3
XFILLER_89_116 VGND VGND VPWR VPWR sky130_fd_sc_hd__decap_3
X_0629_ Tile_X0Y1_OpenRAM_bot.Inst_OpenRAM_bot_ConfigMem.Inst_frame8_bit25.Q _0173_
+ VGND VGND VPWR VPWR _0174_ sky130_fd_sc_hd__and2b_1
XFILLER_89_149 VGND VGND VPWR VPWR sky130_fd_sc_hd__decap_3
XFILLER_133_26 VGND VGND VPWR VPWR sky130_fd_sc_hd__decap_3
XPHY_EDGE_ROW_55_Right_55 VGND VGND VPWR VPWR sky130_fd_sc_hd__decap_3
XFILLER_45_219 VGND VGND VPWR VPWR sky130_fd_sc_hd__decap_3
XFILLER_26_35 VGND VGND VPWR VPWR sky130_fd_sc_hd__decap_3
XFILLER_26_79 VGND VGND VPWR VPWR sky130_fd_sc_hd__decap_3
XFILLER_166_110 VGND VGND VPWR VPWR sky130_fd_sc_hd__decap_3
XFILLER_42_56 VGND VGND VPWR VPWR sky130_fd_sc_hd__decap_3
XPHY_EDGE_ROW_64_Right_64 VGND VGND VPWR VPWR sky130_fd_sc_hd__decap_3
XFILLER_166_165 VGND VGND VPWR VPWR sky130_fd_sc_hd__decap_3
XFILLER_21_193 VGND VGND VPWR VPWR sky130_fd_sc_hd__decap_3
XFILLER_174_44 VGND VGND VPWR VPWR sky130_fd_sc_hd__decap_3
XFILLER_122_213 VGND VGND VPWR VPWR sky130_fd_sc_hd__decap_3
XFILLER_174_88 VGND VGND VPWR VPWR sky130_fd_sc_hd__decap_3
XFILLER_174_77 VGND VGND VPWR VPWR sky130_fd_sc_hd__decap_3
XFILLER_107_93 VGND VGND VPWR VPWR sky130_fd_sc_hd__decap_3
XFILLER_3_39 VGND VGND VPWR VPWR sky130_fd_sc_hd__decap_3
XFILLER_95_108 VGND VGND VPWR VPWR sky130_fd_sc_hd__decap_3
XFILLER_95_119 VGND VGND VPWR VPWR sky130_fd_sc_hd__decap_3
XTAP_TAPCELL_ROW_167_1041 VGND VPWR sky130_fd_sc_hd__tapvpwrvgnd_1
XFILLER_67_42 VGND VGND VPWR VPWR sky130_fd_sc_hd__decap_3
XPHY_EDGE_ROW_73_Right_73 VGND VGND VPWR VPWR sky130_fd_sc_hd__decap_3
XFILLER_88_182 VGND VGND VPWR VPWR sky130_fd_sc_hd__decap_3
XFILLER_123_81 VGND VGND VPWR VPWR sky130_fd_sc_hd__decap_3
XFILLER_83_30 VGND VGND VPWR VPWR sky130_fd_sc_hd__decap_3
XFILLER_83_63 VGND VGND VPWR VPWR sky130_fd_sc_hd__decap_3
XFILLER_83_96 VGND VGND VPWR VPWR sky130_fd_sc_hd__decap_3
X_0980_ net231 net332 VGND VGND VPWR VPWR Tile_X0Y1_OpenRAM_bot.Inst_OpenRAM_bot_ConfigMem.Inst_frame0_bit18.Q
+ sky130_fd_sc_hd__dlxtp_1
XPHY_EDGE_ROW_82_Right_82 VGND VGND VPWR VPWR sky130_fd_sc_hd__decap_3
XFILLER_157_165 VGND VGND VPWR VPWR sky130_fd_sc_hd__decap_3
XFILLER_12_193 VGND VGND VPWR VPWR sky130_fd_sc_hd__decap_3
XFILLER_8_153 VGND VGND VPWR VPWR sky130_fd_sc_hd__decap_3
XTAP_TAPCELL_ROW_174_1067 VGND VPWR sky130_fd_sc_hd__tapvpwrvgnd_1
XFILLER_172_124 VGND VGND VPWR VPWR sky130_fd_sc_hd__decap_3
XFILLER_157_187 VGND VGND VPWR VPWR sky130_fd_sc_hd__fill_2
XFILLER_8_197 VGND VGND VPWR VPWR sky130_fd_sc_hd__decap_3
XFILLER_8_186 VGND VGND VPWR VPWR sky130_fd_sc_hd__decap_3
Xoutput417 net500 VGND VGND VPWR VPWR Tile_X0Y0_N4BEG[5] sky130_fd_sc_hd__buf_2
Xoutput406 net489 VGND VGND VPWR VPWR Tile_X0Y0_N4BEG[0] sky130_fd_sc_hd__buf_2
XFILLER_172_168 VGND VGND VPWR VPWR sky130_fd_sc_hd__decap_3
Xoutput439 net522 VGND VGND VPWR VPWR Tile_X0Y0_W2BEGb[4] sky130_fd_sc_hd__buf_2
XFILLER_113_202 VGND VGND VPWR VPWR sky130_fd_sc_hd__decap_3
Xoutput428 net511 VGND VGND VPWR VPWR Tile_X0Y0_W2BEG[1] sky130_fd_sc_hd__buf_2
X_1463_ Tile_X0Y1_OpenRAM_bot.Inst_OpenRAM_bot_switch_matrix.W1BEG1 VGND VGND VPWR
+ VPWR net623 sky130_fd_sc_hd__buf_1
X_0414_ net27 net59 Tile_X0Y0_OpenRAM_top.Inst_OpenRAM_top_switch_matrix.J_NS4_BEG0
+ net259 Tile_X0Y0_OpenRAM_top.Inst_OpenRAM_top_ConfigMem.Inst_frame4_bit26.Q Tile_X0Y0_OpenRAM_top.Inst_OpenRAM_top_ConfigMem.Inst_frame4_bit27.Q
+ VGND VGND VPWR VPWR Tile_X0Y0_OpenRAM_top.Inst_OpenRAM_top_switch_matrix.WW4BEG15
+ sky130_fd_sc_hd__mux4_1
XPHY_EDGE_ROW_91_Right_91 VGND VGND VPWR VPWR sky130_fd_sc_hd__decap_3
X_1394_ net222 VGND VGND VPWR VPWR net554 sky130_fd_sc_hd__buf_4
XFILLER_79_193 VGND VGND VPWR VPWR sky130_fd_sc_hd__decap_3
X_0345_ net188 net198 net180 _0085_ Tile_X0Y1_OpenRAM_bot.Inst_OpenRAM_bot_ConfigMem.Inst_frame8_bit19.Q
+ Tile_X0Y1_OpenRAM_bot.Inst_OpenRAM_bot_ConfigMem.Inst_frame8_bit18.Q VGND VGND VPWR
+ VPWR Tile_X0Y0_OpenRAM_top.Inst_OpenRAM_top_switch_matrix.N2BEGb5 sky130_fd_sc_hd__mux4_1
XFILLER_94_130 VGND VGND VPWR VPWR sky130_fd_sc_hd__decap_3
XFILLER_103_18 VGND VGND VPWR VPWR sky130_fd_sc_hd__decap_3
X_0276_ Tile_X0Y1_OpenRAM_bot.Inst_OpenRAM_bot_ConfigMem.Inst_frame2_bit29.Q Tile_X0Y1_OpenRAM_bot.Inst_OpenRAM_bot_ConfigMem.Inst_frame2_bit30.Q
+ VGND VGND VPWR VPWR _0045_ sky130_fd_sc_hd__nor2_1
XFILLER_94_174 VGND VGND VPWR VPWR sky130_fd_sc_hd__decap_3
XFILLER_148_121 VGND VGND VPWR VPWR sky130_fd_sc_hd__decap_3
XFILLER_148_165 VGND VGND VPWR VPWR sky130_fd_sc_hd__decap_3
XFILLER_12_15 VGND VGND VPWR VPWR sky130_fd_sc_hd__decap_3
XFILLER_163_113 VGND VGND VPWR VPWR sky130_fd_sc_hd__decap_3
XFILLER_128_26 VGND VGND VPWR VPWR sky130_fd_sc_hd__fill_2
XFILLER_12_59 VGND VGND VPWR VPWR sky130_fd_sc_hd__decap_3
XFILLER_171_190 VGND VGND VPWR VPWR sky130_fd_sc_hd__decap_3
XFILLER_104_224 VGND VGND VPWR VPWR sky130_fd_sc_hd__decap_3
XFILLER_5_9 VGND VGND VPWR VPWR sky130_fd_sc_hd__decap_3
XFILLER_144_36 VGND VGND VPWR VPWR sky130_fd_sc_hd__decap_3
XFILLER_144_25 VGND VGND VPWR VPWR sky130_fd_sc_hd__decap_3
XFILLER_77_119 VGND VGND VPWR VPWR sky130_fd_sc_hd__decap_3
XFILLER_144_69 VGND VGND VPWR VPWR sky130_fd_sc_hd__decap_3
XFILLER_85_152 VGND VGND VPWR VPWR sky130_fd_sc_hd__decap_3
XFILLER_160_35 VGND VGND VPWR VPWR sky130_fd_sc_hd__decap_3
XFILLER_160_24 VGND VGND VPWR VPWR sky130_fd_sc_hd__decap_3
XFILLER_37_45 VGND VGND VPWR VPWR sky130_fd_sc_hd__decap_3
XFILLER_37_78 VGND VGND VPWR VPWR sky130_fd_sc_hd__decap_3
XFILLER_85_196 VGND VGND VPWR VPWR sky130_fd_sc_hd__decap_3
XFILLER_41_211 VGND VGND VPWR VPWR sky130_fd_sc_hd__decap_3
XFILLER_53_33 VGND VGND VPWR VPWR sky130_fd_sc_hd__decap_3
XFILLER_169_33 VGND VGND VPWR VPWR sky130_fd_sc_hd__decap_3
XFILLER_169_66 VGND VGND VPWR VPWR sky130_fd_sc_hd__decap_3
XFILLER_169_99 VGND VGND VPWR VPWR sky130_fd_sc_hd__decap_3
XFILLER_139_154 VGND VGND VPWR VPWR sky130_fd_sc_hd__decap_3
XFILLER_154_113 VGND VGND VPWR VPWR sky130_fd_sc_hd__decap_3
XFILLER_139_198 VGND VGND VPWR VPWR sky130_fd_sc_hd__decap_3
XFILLER_154_168 VGND VGND VPWR VPWR sky130_fd_sc_hd__decap_3
XFILLER_5_134 VGND VGND VPWR VPWR sky130_fd_sc_hd__decap_3
XFILLER_5_178 VGND VGND VPWR VPWR sky130_fd_sc_hd__decap_3
XFILLER_5_167 VGND VGND VPWR VPWR sky130_fd_sc_hd__fill_1
XFILLER_78_41 VGND VGND VPWR VPWR sky130_fd_sc_hd__decap_3
XFILLER_68_108 VGND VGND VPWR VPWR sky130_fd_sc_hd__decap_3
XFILLER_78_74 VGND VGND VPWR VPWR sky130_fd_sc_hd__decap_3
XFILLER_78_85 VGND VGND VPWR VPWR sky130_fd_sc_hd__decap_3
XFILLER_134_80 VGND VGND VPWR VPWR sky130_fd_sc_hd__decap_3
XFILLER_91_111 VGND VGND VPWR VPWR sky130_fd_sc_hd__fill_1
XFILLER_94_62 VGND VGND VPWR VPWR sky130_fd_sc_hd__fill_2
XFILLER_91_122 VGND VGND VPWR VPWR sky130_fd_sc_hd__decap_3
XFILLER_91_166 VGND VGND VPWR VPWR sky130_fd_sc_hd__fill_2
XTAP_TAPCELL_ROW_180_1093 VGND VPWR sky130_fd_sc_hd__tapvpwrvgnd_1
XFILLER_177_205 VGND VGND VPWR VPWR sky130_fd_sc_hd__decap_3
XTAP_TAPCELL_ROW_15_431 VGND VPWR sky130_fd_sc_hd__tapvpwrvgnd_1
XPHY_EDGE_ROW_25_Left_208 VGND VGND VPWR VPWR sky130_fd_sc_hd__decap_3
X_0963_ net120 net269 VGND VGND VPWR VPWR Tile_X0Y0_OpenRAM_top.Inst_OpenRAM_top_ConfigMem.Inst_frame8_bit15.Q
+ sky130_fd_sc_hd__dlxtp_1
X_0894_ net126 net283 VGND VGND VPWR VPWR Tile_X0Y0_OpenRAM_top.Inst_OpenRAM_top_ConfigMem.Inst_frame6_bit20.Q
+ sky130_fd_sc_hd__dlxtp_1
XFILLER_160_127 VGND VGND VPWR VPWR sky130_fd_sc_hd__decap_3
XFILLER_99_222 VGND VGND VPWR VPWR sky130_fd_sc_hd__fill_2
XPHY_EDGE_ROW_34_Left_217 VGND VGND VPWR VPWR sky130_fd_sc_hd__decap_3
XFILLER_59_108 VGND VGND VPWR VPWR sky130_fd_sc_hd__decap_3
XFILLER_59_119 VGND VGND VPWR VPWR sky130_fd_sc_hd__decap_3
X_1446_ Tile_X0Y0_S4END[8] VGND VGND VPWR VPWR net606 sky130_fd_sc_hd__clkbuf_1
XFILLER_4_71 VGND VGND VPWR VPWR sky130_fd_sc_hd__decap_3
X_1377_ Tile_X0Y0_OpenRAM_top.Inst_OpenRAM_top_switch_matrix.W6BEG11 VGND VGND VPWR
+ VPWR net528 sky130_fd_sc_hd__buf_1
X_0328_ net83 net75 net87 Tile_X0Y0_OpenRAM_top.Inst_OpenRAM_top_switch_matrix.J_NS2_BEG2
+ Tile_X0Y0_OpenRAM_top.Inst_OpenRAM_top_ConfigMem.Inst_frame7_bit28.Q Tile_X0Y0_OpenRAM_top.Inst_OpenRAM_top_ConfigMem.Inst_frame7_bit29.Q
+ VGND VGND VPWR VPWR Tile_X0Y0_OpenRAM_top.Inst_OpenRAM_top_switch_matrix.S2BEG2
+ sky130_fd_sc_hd__mux4_2
XFILLER_67_185 VGND VGND VPWR VPWR sky130_fd_sc_hd__decap_3
XTAP_TAPCELL_ROW_38_523 VGND VPWR sky130_fd_sc_hd__tapvpwrvgnd_1
XFILLER_82_122 VGND VGND VPWR VPWR sky130_fd_sc_hd__decap_3
XFILLER_82_144 VGND VGND VPWR VPWR sky130_fd_sc_hd__decap_3
X_0259_ net193 net185 net203 _0030_ Tile_X0Y1_OpenRAM_bot.Inst_OpenRAM_bot_ConfigMem.Inst_frame8_bit8.Q
+ Tile_X0Y1_OpenRAM_bot.Inst_OpenRAM_bot_ConfigMem.Inst_frame8_bit9.Q VGND VGND VPWR
+ VPWR Tile_X0Y0_OpenRAM_top.Inst_OpenRAM_top_switch_matrix.N2BEGb0 sky130_fd_sc_hd__mux4_1
XFILLER_130_38 VGND VGND VPWR VPWR sky130_fd_sc_hd__decap_3
XPHY_EDGE_ROW_43_Left_226 VGND VGND VPWR VPWR sky130_fd_sc_hd__decap_3
XFILLER_82_188 VGND VGND VPWR VPWR sky130_fd_sc_hd__decap_3
XFILLER_168_227 VGND VGND VPWR VPWR sky130_fd_sc_hd__decap_3
XFILLER_139_36 VGND VGND VPWR VPWR sky130_fd_sc_hd__decap_3
XFILLER_139_69 VGND VGND VPWR VPWR sky130_fd_sc_hd__decap_3
XFILLER_136_113 VGND VGND VPWR VPWR sky130_fd_sc_hd__decap_3
XFILLER_99_18 VGND VGND VPWR VPWR sky130_fd_sc_hd__decap_3
XTAP_TAPCELL_ROW_21_456 VGND VPWR sky130_fd_sc_hd__tapvpwrvgnd_1
XFILLER_151_105 VGND VGND VPWR VPWR sky130_fd_sc_hd__decap_3
XFILLER_136_168 VGND VGND VPWR VPWR sky130_fd_sc_hd__decap_3
XPHY_EDGE_ROW_52_Left_235 VGND VGND VPWR VPWR sky130_fd_sc_hd__decap_3
XFILLER_155_57 VGND VGND VPWR VPWR sky130_fd_sc_hd__fill_1
XFILLER_155_46 VGND VGND VPWR VPWR sky130_fd_sc_hd__decap_3
XFILLER_2_115 VGND VGND VPWR VPWR sky130_fd_sc_hd__decap_3
XFILLER_3_6 VGND VGND VPWR VPWR sky130_fd_sc_hd__decap_3
XFILLER_171_45 VGND VGND VPWR VPWR sky130_fd_sc_hd__decap_3
XFILLER_48_44 VGND VGND VPWR VPWR sky130_fd_sc_hd__decap_3
XFILLER_58_141 VGND VGND VPWR VPWR sky130_fd_sc_hd__decap_3
XFILLER_171_78 VGND VGND VPWR VPWR sky130_fd_sc_hd__decap_3
XFILLER_58_174 VGND VGND VPWR VPWR sky130_fd_sc_hd__decap_3
XFILLER_104_50 VGND VGND VPWR VPWR sky130_fd_sc_hd__decap_3
XFILLER_0_29 VGND VGND VPWR VPWR sky130_fd_sc_hd__decap_3
XFILLER_73_122 VGND VGND VPWR VPWR sky130_fd_sc_hd__decap_3
XFILLER_104_94 VGND VGND VPWR VPWR sky130_fd_sc_hd__decap_3
XFILLER_104_83 VGND VGND VPWR VPWR sky130_fd_sc_hd__fill_1
XPHY_EDGE_ROW_61_Left_244 VGND VGND VPWR VPWR sky130_fd_sc_hd__decap_3
XFILLER_64_32 VGND VGND VPWR VPWR sky130_fd_sc_hd__decap_3
XFILLER_73_155 VGND VGND VPWR VPWR sky130_fd_sc_hd__decap_3
XFILLER_14_200 VGND VGND VPWR VPWR sky130_fd_sc_hd__decap_3
XFILLER_73_188 VGND VGND VPWR VPWR sky130_fd_sc_hd__decap_3
XFILLER_159_216 VGND VGND VPWR VPWR sky130_fd_sc_hd__decap_3
XFILLER_9_27 VGND VGND VPWR VPWR sky130_fd_sc_hd__decap_3
XTAP_TAPCELL_ROW_44_548 VGND VPWR sky130_fd_sc_hd__tapvpwrvgnd_1
XFILLER_120_60 VGND VGND VPWR VPWR sky130_fd_sc_hd__decap_3
XTAP_TAPCELL_ROW_52_581 VGND VPWR sky130_fd_sc_hd__tapvpwrvgnd_1
XFILLER_127_113 VGND VGND VPWR VPWR sky130_fd_sc_hd__decap_3
XFILLER_127_102 VGND VGND VPWR VPWR sky130_fd_sc_hd__decap_3
XPHY_EDGE_ROW_70_Left_253 VGND VGND VPWR VPWR sky130_fd_sc_hd__decap_3
XPHY_EDGE_ROW_108_Right_108 VGND VGND VPWR VPWR sky130_fd_sc_hd__decap_3
XFILLER_89_84 VGND VGND VPWR VPWR sky130_fd_sc_hd__decap_3
X_1300_ Tile_X0Y1_FrameStrobe[11] VGND VGND VPWR VPWR net451 sky130_fd_sc_hd__clkbuf_1
XTAP_TAPCELL_ROW_182_1100 VGND VPWR sky130_fd_sc_hd__tapvpwrvgnd_1
XFILLER_1_181 VGND VGND VPWR VPWR sky130_fd_sc_hd__decap_3
X_1231_ net237 net264 VGND VGND VPWR VPWR Tile_X0Y1_OpenRAM_bot.Inst_OpenRAM_bot_ConfigMem.Inst_frame8_bit23.Q
+ sky130_fd_sc_hd__dlxtp_1
XFILLER_49_152 VGND VGND VPWR VPWR sky130_fd_sc_hd__decap_3
XFILLER_64_100 VGND VGND VPWR VPWR sky130_fd_sc_hd__decap_3
X_1162_ net242 net280 VGND VGND VPWR VPWR Tile_X0Y1_OpenRAM_bot.Inst_OpenRAM_bot_ConfigMem.Inst_frame6_bit28.Q
+ sky130_fd_sc_hd__dlxtp_1
XFILLER_64_133 VGND VGND VPWR VPWR sky130_fd_sc_hd__decap_3
X_1093_ net233 net307 VGND VGND VPWR VPWR Tile_X0Y1_OpenRAM_bot.Inst_OpenRAM_bot_ConfigMem.Inst_frame3_bit1.Q
+ sky130_fd_sc_hd__dlxtp_1
XFILLER_64_144 VGND VGND VPWR VPWR sky130_fd_sc_hd__fill_2
XTAP_TAPCELL_ROW_75_673 VGND VPWR sky130_fd_sc_hd__tapvpwrvgnd_1
XFILLER_20_203 VGND VGND VPWR VPWR sky130_fd_sc_hd__decap_3
XFILLER_165_208 VGND VGND VPWR VPWR sky130_fd_sc_hd__decap_3
XPHY_EDGE_ROW_109_Left_292 VGND VGND VPWR VPWR sky130_fd_sc_hd__decap_3
X_0946_ net114 net277 VGND VGND VPWR VPWR Tile_X0Y0_OpenRAM_top.Inst_OpenRAM_top_ConfigMem.Inst_frame7_bit0.Q
+ sky130_fd_sc_hd__dlxtp_1
XFILLER_118_135 VGND VGND VPWR VPWR sky130_fd_sc_hd__decap_3
X_0877_ net141 net291 VGND VGND VPWR VPWR Tile_X0Y0_OpenRAM_top.Inst_OpenRAM_top_ConfigMem.Inst_frame5_bit5.Q
+ sky130_fd_sc_hd__dlxtp_1
XFILLER_133_116 VGND VGND VPWR VPWR sky130_fd_sc_hd__decap_3
XFILLER_118_168 VGND VGND VPWR VPWR sky130_fd_sc_hd__decap_3
XFILLER_125_27 VGND VGND VPWR VPWR sky130_fd_sc_hd__decap_3
XFILLER_87_225 VGND VGND VPWR VPWR sky130_fd_sc_hd__decap_3
XTAP_TAPCELL_ROW_98_765 VGND VPWR sky130_fd_sc_hd__tapvpwrvgnd_1
X_1429_ Tile_X0Y1_OpenRAM_bot.Inst_OpenRAM_bot_switch_matrix.S1BEG3 VGND VGND VPWR
+ VPWR net589 sky130_fd_sc_hd__buf_1
XFILLER_141_37 VGND VGND VPWR VPWR sky130_fd_sc_hd__decap_3
XFILLER_55_133 VGND VGND VPWR VPWR sky130_fd_sc_hd__decap_3
XFILLER_55_166 VGND VGND VPWR VPWR sky130_fd_sc_hd__fill_2
XFILLER_70_103 VGND VGND VPWR VPWR sky130_fd_sc_hd__decap_3
XFILLER_34_24 VGND VGND VPWR VPWR sky130_fd_sc_hd__fill_1
XFILLER_70_136 VGND VGND VPWR VPWR sky130_fd_sc_hd__decap_3
XFILLER_11_214 VGND VGND VPWR VPWR sky130_fd_sc_hd__decap_3
XFILLER_11_225 VGND VGND VPWR VPWR sky130_fd_sc_hd__decap_3
XFILLER_109_113 VGND VGND VPWR VPWR sky130_fd_sc_hd__decap_3
XFILLER_109_146 VGND VGND VPWR VPWR sky130_fd_sc_hd__decap_3
XFILLER_50_56 VGND VGND VPWR VPWR sky130_fd_sc_hd__decap_3
XFILLER_166_56 VGND VGND VPWR VPWR sky130_fd_sc_hd__fill_2
XFILLER_119_3 VGND VGND VPWR VPWR sky130_fd_sc_hd__fill_1
XFILLER_124_127 VGND VGND VPWR VPWR sky130_fd_sc_hd__decap_3
XFILLER_117_190 VGND VGND VPWR VPWR sky130_fd_sc_hd__decap_3
XFILLER_1_3 VGND VGND VPWR VPWR sky130_fd_sc_hd__decap_3
XFILLER_59_43 VGND VGND VPWR VPWR sky130_fd_sc_hd__decap_3
XFILLER_132_171 VGND VGND VPWR VPWR sky130_fd_sc_hd__decap_3
XFILLER_59_87 VGND VGND VPWR VPWR sky130_fd_sc_hd__decap_3
Xfanout282 net286 VGND VGND VPWR VPWR net282 sky130_fd_sc_hd__buf_2
Xfanout260 _0083_ VGND VGND VPWR VPWR net260 sky130_fd_sc_hd__clkbuf_4
Xfanout271 net273 VGND VGND VPWR VPWR net271 sky130_fd_sc_hd__clkbuf_2
XFILLER_93_217 VGND VGND VPWR VPWR sky130_fd_sc_hd__decap_3
XFILLER_93_228 VGND VGND VPWR VPWR sky130_fd_sc_hd__fill_2
XTAP_TAPCELL_ROW_156_994 VGND VPWR sky130_fd_sc_hd__tapvpwrvgnd_1
Xfanout293 net294 VGND VGND VPWR VPWR net293 sky130_fd_sc_hd__clkbuf_2
XFILLER_115_93 VGND VGND VPWR VPWR sky130_fd_sc_hd__decap_3
XTAP_TAPCELL_ROW_116_836 VGND VPWR sky130_fd_sc_hd__tapvpwrvgnd_1
XFILLER_75_97 VGND VGND VPWR VPWR sky130_fd_sc_hd__decap_3
XFILLER_61_125 VGND VGND VPWR VPWR sky130_fd_sc_hd__decap_3
XFILLER_131_81 VGND VGND VPWR VPWR sky130_fd_sc_hd__decap_3
XFILLER_61_136 VGND VGND VPWR VPWR sky130_fd_sc_hd__decap_3
XFILLER_91_30 VGND VGND VPWR VPWR sky130_fd_sc_hd__decap_3
XFILLER_147_208 VGND VGND VPWR VPWR sky130_fd_sc_hd__decap_3
XFILLER_91_96 VGND VGND VPWR VPWR sky130_fd_sc_hd__decap_3
X_0800_ net123 net310 VGND VGND VPWR VPWR Tile_X0Y0_OpenRAM_top.Inst_OpenRAM_top_ConfigMem.Inst_frame3_bit18.Q
+ sky130_fd_sc_hd__dlxtp_1
X_0731_ net129 net328 VGND VGND VPWR VPWR Tile_X0Y0_OpenRAM_top.Inst_OpenRAM_top_ConfigMem.Inst_frame1_bit23.Q
+ sky130_fd_sc_hd__dlxtp_1
XFILLER_170_200 VGND VGND VPWR VPWR sky130_fd_sc_hd__decap_3
XFILLER_115_149 VGND VGND VPWR VPWR sky130_fd_sc_hd__decap_3
X_0662_ net175 net210 net201 _0155_ Tile_X0Y1_OpenRAM_bot.Inst_OpenRAM_bot_ConfigMem.Inst_frame7_bit31.Q
+ Tile_X0Y1_OpenRAM_bot.Inst_OpenRAM_bot_ConfigMem.Inst_frame6_bit0.Q VGND VGND VPWR
+ VPWR _0202_ sky130_fd_sc_hd__mux4_1
X_0593_ _0023_ Tile_X0Y1_OpenRAM_bot.Inst_OpenRAM_bot_ConfigMem.Inst_frame3_bit23.Q
+ _0081_ _0160_ VGND VGND VPWR VPWR net366 sky130_fd_sc_hd__a31o_1
XFILLER_130_119 VGND VGND VPWR VPWR sky130_fd_sc_hd__decap_3
XFILLER_34_3 VGND VGND VPWR VPWR sky130_fd_sc_hd__fill_2
XTAP_TAPCELL_ROW_139_928 VGND VPWR sky130_fd_sc_hd__tapvpwrvgnd_1
XTAP_TAPCELL_ROW_147_961 VGND VPWR sky130_fd_sc_hd__tapvpwrvgnd_1
XFILLER_37_111 VGND VGND VPWR VPWR sky130_fd_sc_hd__fill_1
X_1214_ net252 net271 VGND VGND VPWR VPWR Tile_X0Y1_OpenRAM_bot.Inst_OpenRAM_bot_ConfigMem.Inst_frame7_bit8.Q
+ sky130_fd_sc_hd__dlxtp_1
X_1145_ net226 net289 VGND VGND VPWR VPWR Tile_X0Y1_OpenRAM_bot.Inst_OpenRAM_bot_ConfigMem.Inst_frame5_bit13.Q
+ sky130_fd_sc_hd__dlxtp_1
XFILLER_111_18 VGND VGND VPWR VPWR sky130_fd_sc_hd__decap_3
XFILLER_37_199 VGND VGND VPWR VPWR sky130_fd_sc_hd__decap_3
X_1076_ net231 net304 VGND VGND VPWR VPWR Tile_X0Y1_OpenRAM_bot.Inst_OpenRAM_bot_ConfigMem.Inst_frame3_bit18.Q
+ sky130_fd_sc_hd__dlxtp_1
XPHY_EDGE_ROW_117_Left_300 VGND VGND VPWR VPWR sky130_fd_sc_hd__decap_3
XFILLER_60_180 VGND VGND VPWR VPWR sky130_fd_sc_hd__decap_3
X_0929_ net122 net275 VGND VGND VPWR VPWR Tile_X0Y0_OpenRAM_top.Inst_OpenRAM_top_ConfigMem.Inst_frame7_bit17.Q
+ sky130_fd_sc_hd__dlxtp_1
XFILLER_106_138 VGND VGND VPWR VPWR sky130_fd_sc_hd__fill_2
XFILLER_105_9 VGND VGND VPWR VPWR sky130_fd_sc_hd__decap_3
XFILLER_20_26 VGND VGND VPWR VPWR sky130_fd_sc_hd__fill_2
XFILLER_136_59 VGND VGND VPWR VPWR sky130_fd_sc_hd__decap_3
XFILLER_114_182 VGND VGND VPWR VPWR sky130_fd_sc_hd__decap_3
XFILLER_152_25 VGND VGND VPWR VPWR sky130_fd_sc_hd__decap_3
XFILLER_29_57 VGND VGND VPWR VPWR sky130_fd_sc_hd__decap_3
XFILLER_28_100 VGND VGND VPWR VPWR sky130_fd_sc_hd__decap_3
XTAP_TAPCELL_ROW_161_1014 VGND VPWR sky130_fd_sc_hd__tapvpwrvgnd_1
XFILLER_28_144 VGND VGND VPWR VPWR sky130_fd_sc_hd__fill_1
XFILLER_90_209 VGND VGND VPWR VPWR sky130_fd_sc_hd__fill_2
XFILLER_43_125 VGND VGND VPWR VPWR sky130_fd_sc_hd__decap_3
XFILLER_45_23 VGND VGND VPWR VPWR sky130_fd_sc_hd__decap_3
XFILLER_43_158 VGND VGND VPWR VPWR sky130_fd_sc_hd__decap_3
XFILLER_45_78 VGND VGND VPWR VPWR sky130_fd_sc_hd__decap_3
XFILLER_43_169 VGND VGND VPWR VPWR sky130_fd_sc_hd__fill_2
XFILLER_101_84 VGND VGND VPWR VPWR sky130_fd_sc_hd__decap_3
XFILLER_177_33 VGND VGND VPWR VPWR sky130_fd_sc_hd__decap_3
XFILLER_129_219 VGND VGND VPWR VPWR sky130_fd_sc_hd__decap_3
XFILLER_177_66 VGND VGND VPWR VPWR sky130_fd_sc_hd__decap_3
XFILLER_177_99 VGND VGND VPWR VPWR sky130_fd_sc_hd__decap_3
XFILLER_152_200 VGND VGND VPWR VPWR sky130_fd_sc_hd__decap_3
XFILLER_112_119 VGND VGND VPWR VPWR sky130_fd_sc_hd__decap_3
XFILLER_126_70 VGND VGND VPWR VPWR sky130_fd_sc_hd__fill_2
XFILLER_105_193 VGND VGND VPWR VPWR sky130_fd_sc_hd__decap_3
XFILLER_19_111 VGND VGND VPWR VPWR sky130_fd_sc_hd__fill_1
XFILLER_19_90 VGND VGND VPWR VPWR sky130_fd_sc_hd__decap_3
XFILLER_142_91 VGND VGND VPWR VPWR sky130_fd_sc_hd__decap_3
XFILLER_19_199 VGND VGND VPWR VPWR sky130_fd_sc_hd__decap_3
XFILLER_34_114 VGND VGND VPWR VPWR sky130_fd_sc_hd__fill_1
XTAP_TAPCELL_ROW_92_738 VGND VPWR sky130_fd_sc_hd__tapvpwrvgnd_1
XFILLER_179_119 VGND VGND VPWR VPWR sky130_fd_sc_hd__decap_3
XFILLER_179_108 VGND VGND VPWR VPWR sky130_fd_sc_hd__decap_3
XFILLER_34_136 VGND VGND VPWR VPWR sky130_fd_sc_hd__decap_3
XFILLER_34_158 VGND VGND VPWR VPWR sky130_fd_sc_hd__fill_2
XTAP_TAPCELL_ROW_60_613 VGND VPWR sky130_fd_sc_hd__tapvpwrvgnd_1
XFILLER_42_191 VGND VGND VPWR VPWR sky130_fd_sc_hd__decap_3
XPHY_EDGE_ROW_160_Right_160 VGND VGND VPWR VPWR sky130_fd_sc_hd__decap_3
XFILLER_143_222 VGND VGND VPWR VPWR sky130_fd_sc_hd__fill_2
XFILLER_143_200 VGND VGND VPWR VPWR sky130_fd_sc_hd__decap_3
X_0714_ net144 net338 VGND VGND VPWR VPWR Tile_X0Y0_OpenRAM_top.Inst_OpenRAM_top_ConfigMem.Inst_frame0_bit8.Q
+ sky130_fd_sc_hd__dlxtp_1
X_0645_ _0184_ _0186_ _0187_ Tile_X0Y1_OpenRAM_bot.Inst_OpenRAM_bot_ConfigMem.Inst_frame7_bit0.Q
+ VGND VGND VPWR VPWR Tile_X0Y0_OpenRAM_top.N4BEG_outbuf_10.A sky130_fd_sc_hd__o22a_1
XFILLER_103_119 VGND VGND VPWR VPWR sky130_fd_sc_hd__fill_2
XFILLER_106_29 VGND VGND VPWR VPWR sky130_fd_sc_hd__decap_3
X_0576_ net359 net172 _0147_ Tile_X0Y1_OpenRAM_bot.Inst_OpenRAM_bot_switch_matrix.J_NS4_BEG13
+ Tile_X0Y1_OpenRAM_bot.Inst_OpenRAM_bot_ConfigMem.Inst_frame4_bit20.Q Tile_X0Y1_OpenRAM_bot.Inst_OpenRAM_bot_ConfigMem.Inst_frame4_bit21.Q
+ VGND VGND VPWR VPWR Tile_X0Y1_OpenRAM_bot.Inst_OpenRAM_bot_switch_matrix.W6BEG2
+ sky130_fd_sc_hd__mux4_1
XFILLER_57_228 VGND VGND VPWR VPWR sky130_fd_sc_hd__decap_3
XTAP_TAPCELL_ROW_83_705 VGND VPWR sky130_fd_sc_hd__tapvpwrvgnd_1
XFILLER_25_158 VGND VGND VPWR VPWR sky130_fd_sc_hd__decap_3
X_1128_ net245 net290 VGND VGND VPWR VPWR Tile_X0Y1_OpenRAM_bot.Inst_OpenRAM_bot_ConfigMem.Inst_frame5_bit30.Q
+ sky130_fd_sc_hd__dlxtp_1
XFILLER_25_169 VGND VGND VPWR VPWR sky130_fd_sc_hd__decap_3
XFILLER_40_106 VGND VGND VPWR VPWR sky130_fd_sc_hd__decap_3
X_1059_ net247 net312 VGND VGND VPWR VPWR Tile_X0Y1_OpenRAM_bot.Inst_OpenRAM_bot_ConfigMem.Inst_frame2_bit3.Q
+ sky130_fd_sc_hd__dlxtp_1
XFILLER_178_141 VGND VGND VPWR VPWR sky130_fd_sc_hd__decap_3
XFILLER_178_130 VGND VGND VPWR VPWR sky130_fd_sc_hd__decap_3
XFILLER_178_174 VGND VGND VPWR VPWR sky130_fd_sc_hd__decap_3
XFILLER_147_25 VGND VGND VPWR VPWR sky130_fd_sc_hd__decap_3
XFILLER_31_47 VGND VGND VPWR VPWR sky130_fd_sc_hd__decap_3
XFILLER_134_200 VGND VGND VPWR VPWR sky130_fd_sc_hd__decap_3
XFILLER_31_69 VGND VGND VPWR VPWR sky130_fd_sc_hd__decap_3
XFILLER_103_6 VGND VGND VPWR VPWR sky130_fd_sc_hd__decap_3
XFILLER_163_57 VGND VGND VPWR VPWR sky130_fd_sc_hd__decap_3
Xinput125 Tile_X0Y0_FrameData[1] VGND VGND VPWR VPWR net125 sky130_fd_sc_hd__clkbuf_4
Xinput136 Tile_X0Y0_FrameData[2] VGND VGND VPWR VPWR net136 sky130_fd_sc_hd__clkbuf_4
Xinput114 Tile_X0Y0_FrameData[0] VGND VGND VPWR VPWR net114 sky130_fd_sc_hd__clkbuf_4
Xinput103 Tile_X0Y0_EE4END[14] VGND VGND VPWR VPWR net103 sky130_fd_sc_hd__buf_1
XFILLER_102_141 VGND VGND VPWR VPWR sky130_fd_sc_hd__decap_3
Xinput147 Tile_X0Y0_S1END[1] VGND VGND VPWR VPWR net147 sky130_fd_sc_hd__buf_2
Xinput158 Tile_X0Y0_S2MID[0] VGND VGND VPWR VPWR net158 sky130_fd_sc_hd__clkbuf_2
Xinput169 Tile_X0Y0_S4END[3] VGND VGND VPWR VPWR net169 sky130_fd_sc_hd__clkbuf_2
XFILLER_56_55 VGND VGND VPWR VPWR sky130_fd_sc_hd__decap_3
XFILLER_16_103 VGND VGND VPWR VPWR sky130_fd_sc_hd__decap_3
XFILLER_56_88 VGND VGND VPWR VPWR sky130_fd_sc_hd__decap_3
XTAP_TAPCELL_ROW_141_934 VGND VPWR sky130_fd_sc_hd__tapvpwrvgnd_1
XFILLER_112_50 VGND VGND VPWR VPWR sky130_fd_sc_hd__decap_3
XFILLER_16_147 VGND VGND VPWR VPWR sky130_fd_sc_hd__decap_3
XFILLER_16_136 VGND VGND VPWR VPWR sky130_fd_sc_hd__decap_3
XFILLER_112_94 VGND VGND VPWR VPWR sky130_fd_sc_hd__decap_3
XFILLER_112_83 VGND VGND VPWR VPWR sky130_fd_sc_hd__fill_1
XFILLER_31_106 VGND VGND VPWR VPWR sky130_fd_sc_hd__decap_3
XFILLER_72_21 VGND VGND VPWR VPWR sky130_fd_sc_hd__decap_3
XFILLER_72_32 VGND VGND VPWR VPWR sky130_fd_sc_hd__decap_3
XFILLER_31_128 VGND VGND VPWR VPWR sky130_fd_sc_hd__decap_3
XFILLER_72_65 VGND VGND VPWR VPWR sky130_fd_sc_hd__decap_3
XFILLER_24_191 VGND VGND VPWR VPWR sky130_fd_sc_hd__decap_3
XFILLER_169_196 VGND VGND VPWR VPWR sky130_fd_sc_hd__decap_3
XFILLER_140_203 VGND VGND VPWR VPWR sky130_fd_sc_hd__decap_3
XFILLER_98_128 VGND VGND VPWR VPWR sky130_fd_sc_hd__decap_3
XFILLER_98_106 VGND VGND VPWR VPWR sky130_fd_sc_hd__decap_3
X_0430_ net107 net100 net91 _0095_ Tile_X0Y0_OpenRAM_top.Inst_OpenRAM_top_ConfigMem.Inst_frame3_bit26.Q
+ Tile_X0Y0_OpenRAM_top.Inst_OpenRAM_top_ConfigMem.Inst_frame3_bit27.Q VGND VGND VPWR
+ VPWR net396 sky130_fd_sc_hd__mux4_2
X_0361_ net66 Tile_X0Y0_OpenRAM_top.Inst_OpenRAM_top_switch_matrix.J_NS4_BEG12 net96
+ _0090_ Tile_X0Y0_OpenRAM_top.Inst_OpenRAM_top_ConfigMem.Inst_frame7_bit17.Q Tile_X0Y0_OpenRAM_top.Inst_OpenRAM_top_ConfigMem.Inst_frame7_bit16.Q
+ VGND VGND VPWR VPWR _0091_ sky130_fd_sc_hd__mux4_2
XFILLER_39_217 VGND VGND VPWR VPWR sky130_fd_sc_hd__decap_3
X_0292_ Tile_X0Y0_OpenRAM_top.Inst_OpenRAM_top_switch_matrix.N1END1 net89 Tile_X0Y0_OpenRAM_top.Inst_OpenRAM_top_ConfigMem.Inst_frame0_bit26.Q
+ VGND VGND VPWR VPWR _0060_ sky130_fd_sc_hd__mux2_1
XFILLER_54_209 VGND VGND VPWR VPWR sky130_fd_sc_hd__decap_3
XTAP_TAPCELL_ROW_132_901 VGND VPWR sky130_fd_sc_hd__tapvpwrvgnd_1
XFILLER_22_106 VGND VGND VPWR VPWR sky130_fd_sc_hd__decap_3
XFILLER_175_122 VGND VGND VPWR VPWR sky130_fd_sc_hd__decap_3
XFILLER_175_111 VGND VGND VPWR VPWR sky130_fd_sc_hd__fill_1
XFILLER_30_150 VGND VGND VPWR VPWR sky130_fd_sc_hd__decap_3
XFILLER_175_155 VGND VGND VPWR VPWR sky130_fd_sc_hd__decap_3
XFILLER_30_183 VGND VGND VPWR VPWR sky130_fd_sc_hd__decap_3
XFILLER_175_199 VGND VGND VPWR VPWR sky130_fd_sc_hd__decap_3
XFILLER_7_60 VGND VGND VPWR VPWR sky130_fd_sc_hd__decap_3
XFILLER_117_17 VGND VGND VPWR VPWR sky130_fd_sc_hd__decap_3
XFILLER_7_93 VGND VGND VPWR VPWR sky130_fd_sc_hd__decap_3
XFILLER_89_128 VGND VGND VPWR VPWR sky130_fd_sc_hd__decap_3
XFILLER_131_225 VGND VGND VPWR VPWR sky130_fd_sc_hd__fill_1
X_0628_ _0152_ _0148_ Tile_X0Y1_OpenRAM_bot.Inst_OpenRAM_bot_ConfigMem.Inst_frame8_bit24.Q
+ VGND VGND VPWR VPWR _0173_ sky130_fd_sc_hd__mux2_1
XFILLER_97_150 VGND VGND VPWR VPWR sky130_fd_sc_hd__decap_3
X_0559_ net32 net64 _0149_ _0087_ Tile_X0Y1_OpenRAM_bot.Inst_OpenRAM_bot_ConfigMem.Inst_frame4_bit0.Q
+ Tile_X0Y1_OpenRAM_bot.Inst_OpenRAM_bot_ConfigMem.Inst_frame4_bit1.Q VGND VGND VPWR
+ VPWR Tile_X0Y1_OpenRAM_bot.Inst_OpenRAM_bot_switch_matrix.WW4BEG8 sky130_fd_sc_hd__mux4_1
XFILLER_97_194 VGND VGND VPWR VPWR sky130_fd_sc_hd__decap_3
XFILLER_133_49 VGND VGND VPWR VPWR sky130_fd_sc_hd__decap_3
XFILLER_172_9 VGND VGND VPWR VPWR sky130_fd_sc_hd__decap_3
XFILLER_26_14 VGND VGND VPWR VPWR sky130_fd_sc_hd__decap_3
XFILLER_42_24 VGND VGND VPWR VPWR sky130_fd_sc_hd__decap_3
XFILLER_42_35 VGND VGND VPWR VPWR sky130_fd_sc_hd__decap_3
XFILLER_166_122 VGND VGND VPWR VPWR sky130_fd_sc_hd__decap_3
XFILLER_21_161 VGND VGND VPWR VPWR sky130_fd_sc_hd__decap_3
XFILLER_21_172 VGND VGND VPWR VPWR sky130_fd_sc_hd__decap_3
XFILLER_42_68 VGND VGND VPWR VPWR sky130_fd_sc_hd__decap_3
XFILLER_166_144 VGND VGND VPWR VPWR sky130_fd_sc_hd__decap_3
XFILLER_158_68 VGND VGND VPWR VPWR sky130_fd_sc_hd__decap_3
XFILLER_181_125 VGND VGND VPWR VPWR sky130_fd_sc_hd__decap_3
XFILLER_166_177 VGND VGND VPWR VPWR sky130_fd_sc_hd__decap_3
XFILLER_107_200 VGND VGND VPWR VPWR sky130_fd_sc_hd__decap_3
XFILLER_181_169 VGND VGND VPWR VPWR sky130_fd_sc_hd__decap_3
XFILLER_174_12 VGND VGND VPWR VPWR sky130_fd_sc_hd__decap_3
XFILLER_174_56 VGND VGND VPWR VPWR sky130_fd_sc_hd__decap_3
XFILLER_101_3 VGND VGND VPWR VPWR sky130_fd_sc_hd__decap_3
XFILLER_122_225 VGND VGND VPWR VPWR sky130_fd_sc_hd__decap_3
XFILLER_3_18 VGND VGND VPWR VPWR sky130_fd_sc_hd__decap_3
XFILLER_107_72 VGND VGND VPWR VPWR sky130_fd_sc_hd__decap_3
XFILLER_88_150 VGND VGND VPWR VPWR sky130_fd_sc_hd__decap_3
XFILLER_67_54 VGND VGND VPWR VPWR sky130_fd_sc_hd__fill_2
XFILLER_88_194 VGND VGND VPWR VPWR sky130_fd_sc_hd__fill_2
XFILLER_123_60 VGND VGND VPWR VPWR sky130_fd_sc_hd__fill_2
XFILLER_36_209 VGND VGND VPWR VPWR sky130_fd_sc_hd__fill_2
XFILLER_123_93 VGND VGND VPWR VPWR sky130_fd_sc_hd__decap_3
XFILLER_83_42 VGND VGND VPWR VPWR sky130_fd_sc_hd__decap_3
XFILLER_83_75 VGND VGND VPWR VPWR sky130_fd_sc_hd__decap_3
XFILLER_16_80 VGND VGND VPWR VPWR sky130_fd_sc_hd__decap_3
XFILLER_16_91 VGND VGND VPWR VPWR sky130_fd_sc_hd__decap_3
XFILLER_8_121 VGND VGND VPWR VPWR sky130_fd_sc_hd__decap_3
XTAP_TAPCELL_ROW_174_1068 VGND VPWR sky130_fd_sc_hd__tapvpwrvgnd_1
XFILLER_172_103 VGND VGND VPWR VPWR sky130_fd_sc_hd__decap_3
XFILLER_8_165 VGND VGND VPWR VPWR sky130_fd_sc_hd__decap_3
Xoutput407 net490 VGND VGND VPWR VPWR Tile_X0Y0_N4BEG[10] sky130_fd_sc_hd__buf_2
XFILLER_172_147 VGND VGND VPWR VPWR sky130_fd_sc_hd__decap_3
XFILLER_172_136 VGND VGND VPWR VPWR sky130_fd_sc_hd__decap_3
Xoutput418 net501 VGND VGND VPWR VPWR Tile_X0Y0_N4BEG[6] sky130_fd_sc_hd__buf_2
XFILLER_113_214 VGND VGND VPWR VPWR sky130_fd_sc_hd__decap_3
Xoutput429 net512 VGND VGND VPWR VPWR Tile_X0Y0_W2BEG[2] sky130_fd_sc_hd__buf_2
XFILLER_180_191 VGND VGND VPWR VPWR sky130_fd_sc_hd__decap_3
X_1462_ Tile_X0Y1_OpenRAM_bot.Inst_OpenRAM_bot_switch_matrix.W1BEG0 VGND VGND VPWR
+ VPWR net622 sky130_fd_sc_hd__buf_1
X_0413_ Tile_X0Y0_OpenRAM_top.Inst_OpenRAM_top_switch_matrix.N1END0 net361 net146
+ net166 Tile_X0Y0_OpenRAM_top.Inst_OpenRAM_top_ConfigMem.Inst_frame1_bit8.Q Tile_X0Y0_OpenRAM_top.Inst_OpenRAM_top_ConfigMem.Inst_frame1_bit9.Q
+ VGND VGND VPWR VPWR Tile_X0Y0_OpenRAM_top.Inst_OpenRAM_top_switch_matrix.J_NS4_BEG0
+ sky130_fd_sc_hd__mux4_2
XFILLER_79_150 VGND VGND VPWR VPWR sky130_fd_sc_hd__decap_3
XFILLER_86_109 VGND VGND VPWR VPWR sky130_fd_sc_hd__decap_3
X_1393_ Tile_X0Y0_OpenRAM_top.Inst_OpenRAM_top_switch_matrix.WW4BEG15 VGND VGND VPWR
+ VPWR net544 sky130_fd_sc_hd__buf_1
XFILLER_79_172 VGND VGND VPWR VPWR sky130_fd_sc_hd__decap_3
X_0344_ net354 net346 Tile_X0Y0_OpenRAM_top.Inst_OpenRAM_top_switch_matrix.S2BEG5
+ net163 Tile_X0Y1_OpenRAM_bot.Inst_OpenRAM_bot_ConfigMem.Inst_frame0_bit18.Q Tile_X0Y1_OpenRAM_bot.Inst_OpenRAM_bot_ConfigMem.Inst_frame0_bit19.Q
+ VGND VGND VPWR VPWR _0085_ sky130_fd_sc_hd__mux4_2
XFILLER_27_209 VGND VGND VPWR VPWR sky130_fd_sc_hd__decap_3
X_0275_ Tile_X0Y1_OpenRAM_bot.Inst_OpenRAM_bot_ConfigMem.Inst_frame3_bit11.Q _0037_
+ _0044_ _0000_ VGND VGND VPWR VPWR net383 sky130_fd_sc_hd__a211o_1
XFILLER_94_186 VGND VGND VPWR VPWR sky130_fd_sc_hd__fill_2
XFILLER_148_133 VGND VGND VPWR VPWR sky130_fd_sc_hd__decap_3
XFILLER_148_100 VGND VGND VPWR VPWR sky130_fd_sc_hd__decap_3
XFILLER_10_109 VGND VGND VPWR VPWR sky130_fd_sc_hd__decap_3
XFILLER_12_27 VGND VGND VPWR VPWR sky130_fd_sc_hd__fill_1
XFILLER_163_125 VGND VGND VPWR VPWR sky130_fd_sc_hd__decap_3
XFILLER_163_103 VGND VGND VPWR VPWR sky130_fd_sc_hd__decap_3
XFILLER_148_177 VGND VGND VPWR VPWR sky130_fd_sc_hd__decap_3
XFILLER_12_38 VGND VGND VPWR VPWR sky130_fd_sc_hd__decap_3
XFILLER_128_49 VGND VGND VPWR VPWR sky130_fd_sc_hd__decap_3
XFILLER_104_203 VGND VGND VPWR VPWR sky130_fd_sc_hd__decap_3
XFILLER_144_48 VGND VGND VPWR VPWR sky130_fd_sc_hd__decap_3
XFILLER_77_109 VGND VGND VPWR VPWR sky130_fd_sc_hd__decap_3
XFILLER_37_24 VGND VGND VPWR VPWR sky130_fd_sc_hd__decap_3
XFILLER_18_209 VGND VGND VPWR VPWR sky130_fd_sc_hd__decap_3
XFILLER_37_57 VGND VGND VPWR VPWR sky130_fd_sc_hd__decap_3
XFILLER_85_164 VGND VGND VPWR VPWR sky130_fd_sc_hd__decap_3
XFILLER_85_175 VGND VGND VPWR VPWR sky130_fd_sc_hd__decap_3
XFILLER_160_47 VGND VGND VPWR VPWR sky130_fd_sc_hd__decap_3
XTAP_TAPCELL_ROW_1_374 VGND VPWR sky130_fd_sc_hd__tapvpwrvgnd_1
XFILLER_41_223 VGND VGND VPWR VPWR sky130_fd_sc_hd__fill_1
XFILLER_53_12 VGND VGND VPWR VPWR sky130_fd_sc_hd__decap_3
XFILLER_169_45 VGND VGND VPWR VPWR sky130_fd_sc_hd__decap_3
XFILLER_53_78 VGND VGND VPWR VPWR sky130_fd_sc_hd__fill_2
XFILLER_169_78 VGND VGND VPWR VPWR sky130_fd_sc_hd__decap_3
XFILLER_139_100 VGND VGND VPWR VPWR sky130_fd_sc_hd__decap_3
XFILLER_139_166 VGND VGND VPWR VPWR sky130_fd_sc_hd__fill_2
XFILLER_154_125 VGND VGND VPWR VPWR sky130_fd_sc_hd__decap_3
XFILLER_5_113 VGND VGND VPWR VPWR sky130_fd_sc_hd__decap_3
XFILLER_5_102 VGND VGND VPWR VPWR sky130_fd_sc_hd__decap_3
XFILLER_154_147 VGND VGND VPWR VPWR sky130_fd_sc_hd__decap_3
XFILLER_5_146 VGND VGND VPWR VPWR sky130_fd_sc_hd__decap_3
XFILLER_78_53 VGND VGND VPWR VPWR sky130_fd_sc_hd__decap_3
XFILLER_94_41 VGND VGND VPWR VPWR sky130_fd_sc_hd__decap_3
XFILLER_91_145 VGND VGND VPWR VPWR sky130_fd_sc_hd__decap_3
XFILLER_94_85 VGND VGND VPWR VPWR sky130_fd_sc_hd__decap_3
XFILLER_27_90 VGND VGND VPWR VPWR sky130_fd_sc_hd__decap_3
XFILLER_91_178 VGND VGND VPWR VPWR sky130_fd_sc_hd__decap_3
XFILLER_32_212 VGND VGND VPWR VPWR sky130_fd_sc_hd__decap_3
XFILLER_177_217 VGND VGND VPWR VPWR sky130_fd_sc_hd__decap_3
XTAP_TAPCELL_ROW_15_432 VGND VPWR sky130_fd_sc_hd__tapvpwrvgnd_1
XTAP_TAPCELL_ROW_55_590 VGND VPWR sky130_fd_sc_hd__tapvpwrvgnd_1
XFILLER_177_228 VGND VGND VPWR VPWR sky130_fd_sc_hd__fill_2
X_0962_ net121 net269 VGND VGND VPWR VPWR Tile_X0Y0_OpenRAM_top.Inst_OpenRAM_top_ConfigMem.Inst_frame8_bit16.Q
+ sky130_fd_sc_hd__dlxtp_1
XFILLER_145_125 VGND VGND VPWR VPWR sky130_fd_sc_hd__decap_3
X_0893_ net127 net283 VGND VGND VPWR VPWR Tile_X0Y0_OpenRAM_top.Inst_OpenRAM_top_ConfigMem.Inst_frame6_bit21.Q
+ sky130_fd_sc_hd__dlxtp_1
XFILLER_145_169 VGND VGND VPWR VPWR sky130_fd_sc_hd__decap_3
XFILLER_160_139 VGND VGND VPWR VPWR sky130_fd_sc_hd__fill_1
XFILLER_4_50 VGND VGND VPWR VPWR sky130_fd_sc_hd__decap_3
X_1445_ Tile_X0Y0_OpenRAM_top.Inst_OpenRAM_top_switch_matrix.S2BEG7 VGND VGND VPWR
+ VPWR net605 sky130_fd_sc_hd__buf_4
XFILLER_4_83 VGND VGND VPWR VPWR sky130_fd_sc_hd__fill_1
XFILLER_4_94 VGND VGND VPWR VPWR sky130_fd_sc_hd__decap_3
X_1376_ Tile_X0Y0_OpenRAM_top.Inst_OpenRAM_top_switch_matrix.W6BEG10 VGND VGND VPWR
+ VPWR net527 sky130_fd_sc_hd__clkbuf_1
XFILLER_114_29 VGND VGND VPWR VPWR sky130_fd_sc_hd__decap_3
X_0327_ net84 net76 net94 Tile_X0Y0_OpenRAM_top.Inst_OpenRAM_top_switch_matrix.J_NS2_BEG1
+ Tile_X0Y0_OpenRAM_top.Inst_OpenRAM_top_ConfigMem.Inst_frame8_bit22.Q Tile_X0Y0_OpenRAM_top.Inst_OpenRAM_top_ConfigMem.Inst_frame8_bit23.Q
+ VGND VGND VPWR VPWR Tile_X0Y0_OpenRAM_top.Inst_OpenRAM_top_switch_matrix.N2BEG1
+ sky130_fd_sc_hd__mux4_1
XFILLER_82_101 VGND VGND VPWR VPWR sky130_fd_sc_hd__decap_3
XTAP_TAPCELL_ROW_38_524 VGND VPWR sky130_fd_sc_hd__tapvpwrvgnd_1
XFILLER_67_197 VGND VGND VPWR VPWR sky130_fd_sc_hd__decap_3
XTAP_TAPCELL_ROW_78_682 VGND VPWR sky130_fd_sc_hd__tapvpwrvgnd_1
X_0258_ net349 net341 Tile_X0Y0_OpenRAM_top.Inst_OpenRAM_top_switch_matrix.S2BEG0
+ net158 Tile_X0Y1_OpenRAM_bot.Inst_OpenRAM_bot_ConfigMem.Inst_frame0_bit8.Q Tile_X0Y1_OpenRAM_bot.Inst_OpenRAM_bot_ConfigMem.Inst_frame0_bit9.Q
+ VGND VGND VPWR VPWR _0030_ sky130_fd_sc_hd__mux4_2
XFILLER_168_206 VGND VGND VPWR VPWR sky130_fd_sc_hd__decap_3
XFILLER_23_48 VGND VGND VPWR VPWR sky130_fd_sc_hd__decap_3
XFILLER_139_48 VGND VGND VPWR VPWR sky130_fd_sc_hd__decap_3
XTAP_TAPCELL_ROW_21_457 VGND VPWR sky130_fd_sc_hd__tapvpwrvgnd_1
XFILLER_136_147 VGND VGND VPWR VPWR sky130_fd_sc_hd__decap_3
XFILLER_136_125 VGND VGND VPWR VPWR sky130_fd_sc_hd__decap_3
XFILLER_144_180 VGND VGND VPWR VPWR sky130_fd_sc_hd__decap_3
XFILLER_2_127 VGND VGND VPWR VPWR sky130_fd_sc_hd__decap_3
XFILLER_155_69 VGND VGND VPWR VPWR sky130_fd_sc_hd__decap_3
XFILLER_48_12 VGND VGND VPWR VPWR sky130_fd_sc_hd__decap_3
XFILLER_171_24 VGND VGND VPWR VPWR sky130_fd_sc_hd__decap_3
XFILLER_48_56 VGND VGND VPWR VPWR sky130_fd_sc_hd__decap_3
XFILLER_58_131 VGND VGND VPWR VPWR sky130_fd_sc_hd__decap_3
XFILLER_171_57 VGND VGND VPWR VPWR sky130_fd_sc_hd__decap_3
XFILLER_58_153 VGND VGND VPWR VPWR sky130_fd_sc_hd__decap_3
XFILLER_73_101 VGND VGND VPWR VPWR sky130_fd_sc_hd__decap_3
XFILLER_104_62 VGND VGND VPWR VPWR sky130_fd_sc_hd__decap_3
XFILLER_58_186 VGND VGND VPWR VPWR sky130_fd_sc_hd__decap_3
XFILLER_58_197 VGND VGND VPWR VPWR sky130_fd_sc_hd__decap_3
XFILLER_73_134 VGND VGND VPWR VPWR sky130_fd_sc_hd__decap_3
XFILLER_73_167 VGND VGND VPWR VPWR sky130_fd_sc_hd__fill_1
XFILLER_14_212 VGND VGND VPWR VPWR sky130_fd_sc_hd__decap_3
XFILLER_64_88 VGND VGND VPWR VPWR sky130_fd_sc_hd__decap_3
XTAP_TAPCELL_ROW_44_549 VGND VPWR sky130_fd_sc_hd__tapvpwrvgnd_1
XFILLER_159_228 VGND VGND VPWR VPWR sky130_fd_sc_hd__fill_2
XFILLER_9_39 VGND VGND VPWR VPWR sky130_fd_sc_hd__decap_3
XFILLER_174_209 VGND VGND VPWR VPWR sky130_fd_sc_hd__decap_3
XFILLER_127_136 VGND VGND VPWR VPWR sky130_fd_sc_hd__decap_3
XFILLER_142_117 VGND VGND VPWR VPWR sky130_fd_sc_hd__decap_3
XFILLER_129_81 VGND VGND VPWR VPWR sky130_fd_sc_hd__decap_3
XFILLER_127_169 VGND VGND VPWR VPWR sky130_fd_sc_hd__decap_3
XFILLER_89_41 VGND VGND VPWR VPWR sky130_fd_sc_hd__decap_3
XFILLER_142_139 VGND VGND VPWR VPWR sky130_fd_sc_hd__fill_1
XFILLER_89_96 VGND VGND VPWR VPWR sky130_fd_sc_hd__decap_3
XFILLER_150_183 VGND VGND VPWR VPWR sky130_fd_sc_hd__decap_3
XFILLER_1_193 VGND VGND VPWR VPWR sky130_fd_sc_hd__decap_3
XFILLER_49_131 VGND VGND VPWR VPWR sky130_fd_sc_hd__decap_3
X_1230_ net238 net264 VGND VGND VPWR VPWR Tile_X0Y1_OpenRAM_bot.Inst_OpenRAM_bot_ConfigMem.Inst_frame8_bit24.Q
+ sky130_fd_sc_hd__dlxtp_1
XTAP_TAPCELL_ROW_182_1101 VGND VPWR sky130_fd_sc_hd__tapvpwrvgnd_1
X_1161_ net243 net280 VGND VGND VPWR VPWR Tile_X0Y1_OpenRAM_bot.Inst_OpenRAM_bot_ConfigMem.Inst_frame6_bit29.Q
+ sky130_fd_sc_hd__dlxtp_1
XFILLER_49_164 VGND VGND VPWR VPWR sky130_fd_sc_hd__decap_3
XFILLER_49_175 VGND VGND VPWR VPWR sky130_fd_sc_hd__decap_3
XFILLER_49_197 VGND VGND VPWR VPWR sky130_fd_sc_hd__decap_3
XFILLER_64_112 VGND VGND VPWR VPWR sky130_fd_sc_hd__decap_3
X_1092_ net244 net307 VGND VGND VPWR VPWR Tile_X0Y1_OpenRAM_bot.Inst_OpenRAM_bot_ConfigMem.Inst_frame3_bit2.Q
+ sky130_fd_sc_hd__dlxtp_1
XFILLER_64_178 VGND VGND VPWR VPWR sky130_fd_sc_hd__decap_3
XTAP_TAPCELL_ROW_102_778 VGND VPWR sky130_fd_sc_hd__tapvpwrvgnd_1
XFILLER_20_215 VGND VGND VPWR VPWR sky130_fd_sc_hd__decap_3
XFILLER_118_114 VGND VGND VPWR VPWR sky130_fd_sc_hd__decap_3
X_0945_ net125 net277 VGND VGND VPWR VPWR Tile_X0Y0_OpenRAM_top.Inst_OpenRAM_top_ConfigMem.Inst_frame7_bit1.Q
+ sky130_fd_sc_hd__dlxtp_1
XFILLER_173_220 VGND VGND VPWR VPWR sky130_fd_sc_hd__decap_3
X_0876_ net142 net294 VGND VGND VPWR VPWR Tile_X0Y0_OpenRAM_top.Inst_OpenRAM_top_ConfigMem.Inst_frame5_bit6.Q
+ sky130_fd_sc_hd__dlxtp_1
XFILLER_118_147 VGND VGND VPWR VPWR sky130_fd_sc_hd__decap_3
XFILLER_126_180 VGND VGND VPWR VPWR sky130_fd_sc_hd__decap_3
XFILLER_125_39 VGND VGND VPWR VPWR sky130_fd_sc_hd__decap_3
X_1428_ Tile_X0Y1_OpenRAM_bot.Inst_OpenRAM_bot_switch_matrix.S1BEG2 VGND VGND VPWR
+ VPWR net588 sky130_fd_sc_hd__clkbuf_2
XFILLER_18_15 VGND VGND VPWR VPWR sky130_fd_sc_hd__decap_3
X_1359_ Tile_X0Y0_OpenRAM_top.Inst_OpenRAM_top_switch_matrix.W2BEGb1 VGND VGND VPWR
+ VPWR net519 sky130_fd_sc_hd__buf_1
XFILLER_55_101 VGND VGND VPWR VPWR sky130_fd_sc_hd__fill_1
XFILLER_141_49 VGND VGND VPWR VPWR sky130_fd_sc_hd__decap_3
XFILLER_55_145 VGND VGND VPWR VPWR sky130_fd_sc_hd__decap_3
XFILLER_55_178 VGND VGND VPWR VPWR sky130_fd_sc_hd__fill_2
XPHY_EDGE_ROW_174_Right_174 VGND VGND VPWR VPWR sky130_fd_sc_hd__decap_3
XFILLER_140_7 VGND VGND VPWR VPWR sky130_fd_sc_hd__fill_2
XFILLER_156_209 VGND VGND VPWR VPWR sky130_fd_sc_hd__decap_3
XFILLER_7_208 VGND VGND VPWR VPWR sky130_fd_sc_hd__decap_3
XFILLER_166_24 VGND VGND VPWR VPWR sky130_fd_sc_hd__decap_3
XFILLER_109_125 VGND VGND VPWR VPWR sky130_fd_sc_hd__decap_3
XFILLER_50_35 VGND VGND VPWR VPWR sky130_fd_sc_hd__decap_3
XFILLER_166_35 VGND VGND VPWR VPWR sky130_fd_sc_hd__decap_3
XFILLER_109_169 VGND VGND VPWR VPWR sky130_fd_sc_hd__decap_3
XFILLER_50_68 VGND VGND VPWR VPWR sky130_fd_sc_hd__decap_3
XFILLER_166_79 VGND VGND VPWR VPWR sky130_fd_sc_hd__decap_3
XFILLER_124_139 VGND VGND VPWR VPWR sky130_fd_sc_hd__fill_1
XFILLER_182_12 VGND VGND VPWR VPWR sky130_fd_sc_hd__decap_3
XFILLER_59_55 VGND VGND VPWR VPWR sky130_fd_sc_hd__fill_1
XFILLER_59_66 VGND VGND VPWR VPWR sky130_fd_sc_hd__decap_3
Xoutput590 net673 VGND VGND VPWR VPWR WMASK_A_SRAM2 sky130_fd_sc_hd__buf_2
XFILLER_132_183 VGND VGND VPWR VPWR sky130_fd_sc_hd__decap_3
XFILLER_59_99 VGND VGND VPWR VPWR sky130_fd_sc_hd__decap_3
XFILLER_115_72 VGND VGND VPWR VPWR sky130_fd_sc_hd__decap_3
Xfanout283 net286 VGND VGND VPWR VPWR net283 sky130_fd_sc_hd__dlymetal6s2s_1
Xfanout272 net273 VGND VGND VPWR VPWR net272 sky130_fd_sc_hd__buf_2
Xfanout261 _0082_ VGND VGND VPWR VPWR net261 sky130_fd_sc_hd__clkbuf_4
Xfanout294 net295 VGND VGND VPWR VPWR net294 sky130_fd_sc_hd__buf_2
XFILLER_46_101 VGND VGND VPWR VPWR sky130_fd_sc_hd__decap_3
XFILLER_75_43 VGND VGND VPWR VPWR sky130_fd_sc_hd__fill_2
XTAP_TAPCELL_ROW_156_995 VGND VPWR sky130_fd_sc_hd__tapvpwrvgnd_1
XTAP_TAPCELL_ROW_116_837 VGND VPWR sky130_fd_sc_hd__tapvpwrvgnd_1
XPHY_EDGE_ROW_141_Right_141 VGND VGND VPWR VPWR sky130_fd_sc_hd__decap_3
XFILLER_131_93 VGND VGND VPWR VPWR sky130_fd_sc_hd__decap_3
XFILLER_91_42 VGND VGND VPWR VPWR sky130_fd_sc_hd__decap_3
XFILLER_98_9 VGND VGND VPWR VPWR sky130_fd_sc_hd__decap_3
XFILLER_91_75 VGND VGND VPWR VPWR sky130_fd_sc_hd__decap_3
XTAP_TAPCELL_ROW_40_530 VGND VPWR sky130_fd_sc_hd__tapvpwrvgnd_1
X_0730_ net130 net327 VGND VGND VPWR VPWR Tile_X0Y0_OpenRAM_top.Inst_OpenRAM_top_ConfigMem.Inst_frame1_bit24.Q
+ sky130_fd_sc_hd__dlxtp_1
XFILLER_170_212 VGND VGND VPWR VPWR sky130_fd_sc_hd__decap_3
X_0661_ Tile_X0Y1_OpenRAM_bot.Inst_OpenRAM_bot_ConfigMem.Inst_frame6_bit0.Q _0200_
+ Tile_X0Y1_OpenRAM_bot.Inst_OpenRAM_bot_ConfigMem.Inst_frame6_bit1.Q VGND VGND VPWR
+ VPWR _0201_ sky130_fd_sc_hd__a21bo_1
XFILLER_108_180 VGND VGND VPWR VPWR sky130_fd_sc_hd__decap_3
X_0592_ net179 _0023_ _0159_ VGND VGND VPWR VPWR _0160_ sky130_fd_sc_hd__o21a_1
XFILLER_123_172 VGND VGND VPWR VPWR sky130_fd_sc_hd__decap_3
XFILLER_123_161 VGND VGND VPWR VPWR sky130_fd_sc_hd__decap_3
XTAP_TAPCELL_ROW_139_929 VGND VPWR sky130_fd_sc_hd__tapvpwrvgnd_1
X_1213_ net253 net271 VGND VGND VPWR VPWR Tile_X0Y1_OpenRAM_bot.Inst_OpenRAM_bot_ConfigMem.Inst_frame7_bit9.Q
+ sky130_fd_sc_hd__dlxtp_1
XFILLER_37_123 VGND VGND VPWR VPWR sky130_fd_sc_hd__decap_3
X_1144_ net227 net288 VGND VGND VPWR VPWR Tile_X0Y1_OpenRAM_bot.Inst_OpenRAM_bot_ConfigMem.Inst_frame5_bit14.Q
+ sky130_fd_sc_hd__dlxtp_1
XFILLER_1_84 VGND VGND VPWR VPWR sky130_fd_sc_hd__decap_3
XFILLER_37_167 VGND VGND VPWR VPWR sky130_fd_sc_hd__fill_1
XFILLER_37_178 VGND VGND VPWR VPWR sky130_fd_sc_hd__decap_3
XTAP_TAPCELL_ROW_63_622 VGND VPWR sky130_fd_sc_hd__tapvpwrvgnd_1
X_1075_ net232 net304 VGND VGND VPWR VPWR Tile_X0Y1_OpenRAM_bot.Inst_OpenRAM_bot_ConfigMem.Inst_frame3_bit19.Q
+ sky130_fd_sc_hd__dlxtp_1
X_0928_ net123 net276 VGND VGND VPWR VPWR Tile_X0Y0_OpenRAM_top.Inst_OpenRAM_top_ConfigMem.Inst_frame7_bit18.Q
+ sky130_fd_sc_hd__dlxtp_1
XFILLER_106_106 VGND VGND VPWR VPWR sky130_fd_sc_hd__decap_3
XFILLER_20_49 VGND VGND VPWR VPWR sky130_fd_sc_hd__decap_3
X_0859_ net129 net295 VGND VGND VPWR VPWR Tile_X0Y0_OpenRAM_top.Inst_OpenRAM_top_ConfigMem.Inst_frame5_bit23.Q
+ sky130_fd_sc_hd__dlxtp_1
XFILLER_136_38 VGND VGND VPWR VPWR sky130_fd_sc_hd__decap_3
XFILLER_114_194 VGND VGND VPWR VPWR sky130_fd_sc_hd__fill_2
XTAP_TAPCELL_ROW_86_714 VGND VPWR sky130_fd_sc_hd__tapvpwrvgnd_1
XFILLER_152_59 VGND VGND VPWR VPWR sky130_fd_sc_hd__decap_3
XFILLER_28_112 VGND VGND VPWR VPWR sky130_fd_sc_hd__decap_3
XTAP_TAPCELL_ROW_161_1015 VGND VPWR sky130_fd_sc_hd__tapvpwrvgnd_1
XFILLER_28_134 VGND VGND VPWR VPWR sky130_fd_sc_hd__decap_3
XFILLER_45_35 VGND VGND VPWR VPWR sky130_fd_sc_hd__decap_3
XFILLER_43_137 VGND VGND VPWR VPWR sky130_fd_sc_hd__decap_3
XFILLER_101_52 VGND VGND VPWR VPWR sky130_fd_sc_hd__decap_3
XFILLER_177_12 VGND VGND VPWR VPWR sky130_fd_sc_hd__decap_3
XFILLER_131_3 VGND VGND VPWR VPWR sky130_fd_sc_hd__fill_2
XFILLER_177_45 VGND VGND VPWR VPWR sky130_fd_sc_hd__decap_3
XFILLER_61_78 VGND VGND VPWR VPWR sky130_fd_sc_hd__decap_3
XFILLER_6_29 VGND VGND VPWR VPWR sky130_fd_sc_hd__decap_3
XFILLER_6_18 VGND VGND VPWR VPWR sky130_fd_sc_hd__decap_3
XFILLER_152_223 VGND VGND VPWR VPWR sky130_fd_sc_hd__decap_3
XFILLER_3_211 VGND VGND VPWR VPWR sky130_fd_sc_hd__decap_3
XFILLER_105_161 VGND VGND VPWR VPWR sky130_fd_sc_hd__decap_3
XFILLER_10_71 VGND VGND VPWR VPWR sky130_fd_sc_hd__decap_3
XFILLER_120_197 VGND VGND VPWR VPWR sky130_fd_sc_hd__decap_3
XFILLER_19_134 VGND VGND VPWR VPWR sky130_fd_sc_hd__decap_3
XFILLER_19_178 VGND VGND VPWR VPWR sky130_fd_sc_hd__decap_3
XFILLER_19_167 VGND VGND VPWR VPWR sky130_fd_sc_hd__fill_1
XTAP_TAPCELL_ROW_92_739 VGND VPWR sky130_fd_sc_hd__tapvpwrvgnd_1
XFILLER_42_170 VGND VGND VPWR VPWR sky130_fd_sc_hd__decap_3
XFILLER_96_6 VGND VGND VPWR VPWR sky130_fd_sc_hd__decap_3
X_0713_ net145 net338 VGND VGND VPWR VPWR Tile_X0Y0_OpenRAM_top.Inst_OpenRAM_top_ConfigMem.Inst_frame0_bit9.Q
+ sky130_fd_sc_hd__dlxtp_1
X_0644_ net176 net195 net214 _0154_ Tile_X0Y1_OpenRAM_bot.Inst_OpenRAM_bot_ConfigMem.Inst_frame8_bit31.Q
+ Tile_X0Y1_OpenRAM_bot.Inst_OpenRAM_bot_ConfigMem.Inst_frame8_bit30.Q VGND VGND VPWR
+ VPWR _0187_ sky130_fd_sc_hd__mux4_1
X_0575_ net358 net171 _0146_ Tile_X0Y1_OpenRAM_bot.Inst_OpenRAM_bot_switch_matrix.J_NS4_BEG14
+ Tile_X0Y1_OpenRAM_bot.Inst_OpenRAM_bot_ConfigMem.Inst_frame4_bit18.Q Tile_X0Y1_OpenRAM_bot.Inst_OpenRAM_bot_ConfigMem.Inst_frame4_bit19.Q
+ VGND VGND VPWR VPWR Tile_X0Y1_OpenRAM_bot.Inst_OpenRAM_bot_switch_matrix.W6BEG1
+ sky130_fd_sc_hd__mux4_1
XFILLER_111_142 VGND VGND VPWR VPWR sky130_fd_sc_hd__decap_3
XFILLER_57_207 VGND VGND VPWR VPWR sky130_fd_sc_hd__decap_3
XTAP_TAPCELL_ROW_135_910 VGND VPWR sky130_fd_sc_hd__tapvpwrvgnd_1
XFILLER_122_29 VGND VGND VPWR VPWR sky130_fd_sc_hd__decap_3
X_1127_ net246 net290 VGND VGND VPWR VPWR Tile_X0Y1_OpenRAM_bot.Inst_OpenRAM_bot_ConfigMem.Inst_frame5_bit31.Q
+ sky130_fd_sc_hd__dlxtp_1
XFILLER_25_126 VGND VGND VPWR VPWR sky130_fd_sc_hd__fill_2
XFILLER_25_137 VGND VGND VPWR VPWR sky130_fd_sc_hd__decap_3
X_1058_ net248 net315 VGND VGND VPWR VPWR Tile_X0Y1_OpenRAM_bot.Inst_OpenRAM_bot_ConfigMem.Inst_frame2_bit4.Q
+ sky130_fd_sc_hd__dlxtp_1
XFILLER_40_118 VGND VGND VPWR VPWR sky130_fd_sc_hd__decap_3
XFILLER_178_153 VGND VGND VPWR VPWR sky130_fd_sc_hd__decap_3
XFILLER_178_197 VGND VGND VPWR VPWR sky130_fd_sc_hd__decap_3
XFILLER_178_186 VGND VGND VPWR VPWR sky130_fd_sc_hd__decap_3
XFILLER_147_37 VGND VGND VPWR VPWR sky130_fd_sc_hd__decap_3
XPHY_EDGE_ROW_1_Right_1 VGND VGND VPWR VPWR sky130_fd_sc_hd__decap_3
XFILLER_0_203 VGND VGND VPWR VPWR sky130_fd_sc_hd__decap_3
XFILLER_0_225 VGND VGND VPWR VPWR sky130_fd_sc_hd__fill_2
Xinput126 Tile_X0Y0_FrameData[20] VGND VGND VPWR VPWR net126 sky130_fd_sc_hd__buf_4
Xinput115 Tile_X0Y0_FrameData[10] VGND VGND VPWR VPWR net115 sky130_fd_sc_hd__clkbuf_4
Xinput104 Tile_X0Y0_EE4END[15] VGND VGND VPWR VPWR net104 sky130_fd_sc_hd__dlymetal6s2s_1
XFILLER_102_153 VGND VGND VPWR VPWR sky130_fd_sc_hd__decap_3
Xinput159 Tile_X0Y0_S2MID[1] VGND VGND VPWR VPWR net159 sky130_fd_sc_hd__clkbuf_2
Xinput148 Tile_X0Y0_S1END[2] VGND VGND VPWR VPWR net148 sky130_fd_sc_hd__buf_2
Xinput137 Tile_X0Y0_FrameData[30] VGND VGND VPWR VPWR net137 sky130_fd_sc_hd__clkbuf_4
XFILLER_48_218 VGND VGND VPWR VPWR sky130_fd_sc_hd__decap_3
XFILLER_179_3 VGND VGND VPWR VPWR sky130_fd_sc_hd__decap_3
XFILLER_56_67 VGND VGND VPWR VPWR sky130_fd_sc_hd__decap_3
XFILLER_16_115 VGND VGND VPWR VPWR sky130_fd_sc_hd__decap_3
XTAP_TAPCELL_ROW_141_935 VGND VPWR sky130_fd_sc_hd__tapvpwrvgnd_1
XFILLER_112_62 VGND VGND VPWR VPWR sky130_fd_sc_hd__decap_3
XFILLER_16_159 VGND VGND VPWR VPWR sky130_fd_sc_hd__decap_3
XFILLER_169_131 VGND VGND VPWR VPWR sky130_fd_sc_hd__fill_1
XFILLER_72_77 VGND VGND VPWR VPWR sky130_fd_sc_hd__decap_3
XFILLER_169_175 VGND VGND VPWR VPWR sky130_fd_sc_hd__decap_3
XFILLER_72_88 VGND VGND VPWR VPWR sky130_fd_sc_hd__fill_2
XPHY_EDGE_ROW_136_Left_319 VGND VGND VPWR VPWR sky130_fd_sc_hd__decap_3
XFILLER_125_223 VGND VGND VPWR VPWR sky130_fd_sc_hd__fill_1
XFILLER_21_81 VGND VGND VPWR VPWR sky130_fd_sc_hd__decap_3
XFILLER_140_215 VGND VGND VPWR VPWR sky130_fd_sc_hd__decap_3
XFILLER_97_41 VGND VGND VPWR VPWR sky130_fd_sc_hd__decap_3
XFILLER_97_30 VGND VGND VPWR VPWR sky130_fd_sc_hd__decap_3
XFILLER_97_63 VGND VGND VPWR VPWR sky130_fd_sc_hd__decap_3
X_0360_ _0018_ _0088_ _0089_ VGND VGND VPWR VPWR _0090_ sky130_fd_sc_hd__a21o_1
XFILLER_39_229 VGND VGND VPWR VPWR sky130_fd_sc_hd__fill_2
X_0291_ _0052_ _0059_ net1 VGND VGND VPWR VPWR net384 sky130_fd_sc_hd__or3b_2
XPHY_EDGE_ROW_145_Left_328 VGND VGND VPWR VPWR sky130_fd_sc_hd__decap_3
XFILLER_22_118 VGND VGND VPWR VPWR sky130_fd_sc_hd__decap_3
XFILLER_15_192 VGND VGND VPWR VPWR sky130_fd_sc_hd__decap_3
XFILLER_94_3 VGND VGND VPWR VPWR sky130_fd_sc_hd__decap_3
XFILLER_175_134 VGND VGND VPWR VPWR sky130_fd_sc_hd__decap_3
XFILLER_30_162 VGND VGND VPWR VPWR sky130_fd_sc_hd__decap_3
XFILLER_175_167 VGND VGND VPWR VPWR sky130_fd_sc_hd__fill_1
XPHY_EDGE_ROW_154_Left_337 VGND VGND VPWR VPWR sky130_fd_sc_hd__decap_3
XFILLER_30_195 VGND VGND VPWR VPWR sky130_fd_sc_hd__fill_1
XFILLER_175_178 VGND VGND VPWR VPWR sky130_fd_sc_hd__decap_3
XFILLER_116_212 VGND VGND VPWR VPWR sky130_fd_sc_hd__decap_3
XFILLER_7_72 VGND VGND VPWR VPWR sky130_fd_sc_hd__decap_3
XFILLER_131_215 VGND VGND VPWR VPWR sky130_fd_sc_hd__decap_3
XFILLER_117_29 VGND VGND VPWR VPWR sky130_fd_sc_hd__decap_3
X_0627_ _0029_ Tile_X0Y1_OpenRAM_bot.Inst_OpenRAM_bot_ConfigMem.Inst_frame1_bit7.Q
+ net260 _0172_ VGND VGND VPWR VPWR net376 sky130_fd_sc_hd__a31o_2
XFILLER_97_140 VGND VGND VPWR VPWR sky130_fd_sc_hd__fill_1
X_0558_ net340 net360 _0077_ net173 Tile_X0Y1_OpenRAM_bot.Inst_OpenRAM_bot_ConfigMem.Inst_frame1_bit22.Q
+ Tile_X0Y1_OpenRAM_bot.Inst_OpenRAM_bot_ConfigMem.Inst_frame1_bit23.Q VGND VGND VPWR
+ VPWR _0149_ sky130_fd_sc_hd__mux4_2
XPHY_EDGE_ROW_163_Left_346 VGND VGND VPWR VPWR sky130_fd_sc_hd__decap_3
XFILLER_97_162 VGND VGND VPWR VPWR sky130_fd_sc_hd__decap_3
X_0489_ net69 Tile_X0Y0_OpenRAM_top.Inst_OpenRAM_top_switch_matrix.J_NS4_BEG7 Tile_X0Y0_OpenRAM_top.Inst_OpenRAM_top_ConfigMem.Inst_frame7_bit15.Q
+ VGND VGND VPWR VPWR _0130_ sky130_fd_sc_hd__mux2_1
XFILLER_26_26 VGND VGND VPWR VPWR sky130_fd_sc_hd__fill_2
XPHY_EDGE_ROW_172_Left_355 VGND VGND VPWR VPWR sky130_fd_sc_hd__decap_3
XFILLER_166_134 VGND VGND VPWR VPWR sky130_fd_sc_hd__decap_3
XFILLER_21_140 VGND VGND VPWR VPWR sky130_fd_sc_hd__decap_3
XFILLER_42_47 VGND VGND VPWR VPWR sky130_fd_sc_hd__decap_3
XFILLER_166_156 VGND VGND VPWR VPWR sky130_fd_sc_hd__decap_3
XFILLER_166_189 VGND VGND VPWR VPWR sky130_fd_sc_hd__decap_3
XFILLER_181_159 VGND VGND VPWR VPWR sky130_fd_sc_hd__decap_3
XFILLER_107_223 VGND VGND VPWR VPWR sky130_fd_sc_hd__fill_1
XFILLER_174_35 VGND VGND VPWR VPWR sky130_fd_sc_hd__decap_3
XFILLER_174_24 VGND VGND VPWR VPWR sky130_fd_sc_hd__decap_3
XFILLER_174_68 VGND VGND VPWR VPWR sky130_fd_sc_hd__decap_3
XPHY_EDGE_ROW_181_Left_364 VGND VGND VPWR VPWR sky130_fd_sc_hd__decap_3
XFILLER_107_84 VGND VGND VPWR VPWR sky130_fd_sc_hd__decap_3
XFILLER_67_33 VGND VGND VPWR VPWR sky130_fd_sc_hd__decap_3
XFILLER_67_66 VGND VGND VPWR VPWR sky130_fd_sc_hd__fill_1
XFILLER_88_173 VGND VGND VPWR VPWR sky130_fd_sc_hd__decap_3
XFILLER_67_88 VGND VGND VPWR VPWR sky130_fd_sc_hd__decap_3
XFILLER_123_72 VGND VGND VPWR VPWR sky130_fd_sc_hd__decap_3
XFILLER_83_21 VGND VGND VPWR VPWR sky130_fd_sc_hd__decap_3
XFILLER_83_54 VGND VGND VPWR VPWR sky130_fd_sc_hd__fill_2
XFILLER_83_87 VGND VGND VPWR VPWR sky130_fd_sc_hd__decap_3
XFILLER_8_100 VGND VGND VPWR VPWR sky130_fd_sc_hd__decap_3
XFILLER_80_9 VGND VGND VPWR VPWR sky130_fd_sc_hd__fill_2
XFILLER_157_156 VGND VGND VPWR VPWR sky130_fd_sc_hd__decap_3
XFILLER_12_184 VGND VGND VPWR VPWR sky130_fd_sc_hd__decap_3
XFILLER_8_144 VGND VGND VPWR VPWR sky130_fd_sc_hd__decap_3
XFILLER_8_133 VGND VGND VPWR VPWR sky130_fd_sc_hd__decap_3
XTAP_TAPCELL_ROW_174_1069 VGND VPWR sky130_fd_sc_hd__tapvpwrvgnd_1
XFILLER_172_115 VGND VGND VPWR VPWR sky130_fd_sc_hd__decap_3
XFILLER_8_177 VGND VGND VPWR VPWR sky130_fd_sc_hd__decap_3
XFILLER_32_91 VGND VGND VPWR VPWR sky130_fd_sc_hd__decap_3
Xoutput408 net491 VGND VGND VPWR VPWR Tile_X0Y0_N4BEG[11] sky130_fd_sc_hd__buf_2
XFILLER_172_159 VGND VGND VPWR VPWR sky130_fd_sc_hd__decap_3
XFILLER_148_91 VGND VGND VPWR VPWR sky130_fd_sc_hd__decap_3
Xoutput419 net502 VGND VGND VPWR VPWR Tile_X0Y0_N4BEG[7] sky130_fd_sc_hd__buf_2
XFILLER_180_181 VGND VGND VPWR VPWR sky130_fd_sc_hd__decap_3
X_1461_ Tile_X0Y1_OpenRAM_bot.Inst_OpenRAM_bot_switch_matrix.S4BEG3 VGND VGND VPWR
+ VPWR net612 sky130_fd_sc_hd__clkbuf_2
X_1392_ Tile_X0Y0_OpenRAM_top.Inst_OpenRAM_top_switch_matrix.WW4BEG14 VGND VGND VPWR
+ VPWR net543 sky130_fd_sc_hd__buf_1
X_0412_ net26 net58 Tile_X0Y0_OpenRAM_top.Inst_OpenRAM_top_switch_matrix.J_NS4_BEG1
+ net258 Tile_X0Y0_OpenRAM_top.Inst_OpenRAM_top_ConfigMem.Inst_frame4_bit24.Q Tile_X0Y0_OpenRAM_top.Inst_OpenRAM_top_ConfigMem.Inst_frame4_bit25.Q
+ VGND VGND VPWR VPWR Tile_X0Y0_OpenRAM_top.Inst_OpenRAM_top_switch_matrix.WW4BEG14
+ sky130_fd_sc_hd__mux4_1
X_0343_ net67 net80 net72 Tile_X0Y0_OpenRAM_top.Inst_OpenRAM_top_switch_matrix.J_NS2_BEG5
+ Tile_X0Y0_OpenRAM_top.Inst_OpenRAM_top_ConfigMem.Inst_frame6_bit2.Q Tile_X0Y0_OpenRAM_top.Inst_OpenRAM_top_ConfigMem.Inst_frame6_bit3.Q
+ VGND VGND VPWR VPWR Tile_X0Y0_OpenRAM_top.Inst_OpenRAM_top_switch_matrix.S2BEG5
+ sky130_fd_sc_hd__mux4_2
XFILLER_94_121 VGND VGND VPWR VPWR sky130_fd_sc_hd__decap_3
X_0274_ _0040_ _0043_ Tile_X0Y1_OpenRAM_bot.Inst_OpenRAM_bot_ConfigMem.Inst_frame3_bit11.Q
+ VGND VGND VPWR VPWR _0044_ sky130_fd_sc_hd__a21oi_1
XFILLER_94_165 VGND VGND VPWR VPWR sky130_fd_sc_hd__decap_3
XFILLER_35_232 VGND VGND VPWR VPWR sky130_fd_sc_hd__fill_2
XFILLER_148_112 VGND VGND VPWR VPWR sky130_fd_sc_hd__decap_3
XFILLER_148_156 VGND VGND VPWR VPWR sky130_fd_sc_hd__decap_3
XFILLER_148_189 VGND VGND VPWR VPWR sky130_fd_sc_hd__decap_3
XFILLER_171_181 VGND VGND VPWR VPWR sky130_fd_sc_hd__decap_3
XFILLER_104_215 VGND VGND VPWR VPWR sky130_fd_sc_hd__decap_3
XFILLER_160_15 VGND VGND VPWR VPWR sky130_fd_sc_hd__decap_3
XFILLER_37_36 VGND VGND VPWR VPWR sky130_fd_sc_hd__decap_3
XFILLER_160_59 VGND VGND VPWR VPWR sky130_fd_sc_hd__decap_3
XFILLER_37_69 VGND VGND VPWR VPWR sky130_fd_sc_hd__decap_3
XFILLER_85_187 VGND VGND VPWR VPWR sky130_fd_sc_hd__decap_3
XTAP_TAPCELL_ROW_1_375 VGND VPWR sky130_fd_sc_hd__tapvpwrvgnd_1
XFILLER_41_202 VGND VGND VPWR VPWR sky130_fd_sc_hd__decap_3
XFILLER_53_24 VGND VGND VPWR VPWR sky130_fd_sc_hd__decap_3
XFILLER_169_24 VGND VGND VPWR VPWR sky130_fd_sc_hd__decap_3
XFILLER_169_57 VGND VGND VPWR VPWR sky130_fd_sc_hd__decap_3
XTAP_TAPCELL_ROW_24_466 VGND VPWR sky130_fd_sc_hd__tapvpwrvgnd_1
XFILLER_154_104 VGND VGND VPWR VPWR sky130_fd_sc_hd__decap_3
XFILLER_154_159 VGND VGND VPWR VPWR sky130_fd_sc_hd__decap_3
XFILLER_154_137 VGND VGND VPWR VPWR sky130_fd_sc_hd__decap_3
XFILLER_5_125 VGND VGND VPWR VPWR sky130_fd_sc_hd__decap_3
XFILLER_5_169 VGND VGND VPWR VPWR sky130_fd_sc_hd__decap_3
XFILLER_5_158 VGND VGND VPWR VPWR sky130_fd_sc_hd__decap_3
XFILLER_118_83 VGND VGND VPWR VPWR sky130_fd_sc_hd__fill_1
XFILLER_78_21 VGND VGND VPWR VPWR sky130_fd_sc_hd__decap_3
XFILLER_78_32 VGND VGND VPWR VPWR sky130_fd_sc_hd__decap_3
XFILLER_78_65 VGND VGND VPWR VPWR sky130_fd_sc_hd__decap_3
XFILLER_134_60 VGND VGND VPWR VPWR sky130_fd_sc_hd__decap_3
XFILLER_76_121 VGND VGND VPWR VPWR sky130_fd_sc_hd__decap_3
XFILLER_76_165 VGND VGND VPWR VPWR sky130_fd_sc_hd__fill_1
XFILLER_91_102 VGND VGND VPWR VPWR sky130_fd_sc_hd__decap_3
XFILLER_17_221 VGND VGND VPWR VPWR sky130_fd_sc_hd__decap_3
XFILLER_76_187 VGND VGND VPWR VPWR sky130_fd_sc_hd__decap_3
XFILLER_91_113 VGND VGND VPWR VPWR sky130_fd_sc_hd__decap_3
XTAP_TAPCELL_ROW_47_558 VGND VPWR sky130_fd_sc_hd__tapvpwrvgnd_1
XFILLER_94_97 VGND VGND VPWR VPWR sky130_fd_sc_hd__decap_3
XTAP_TAPCELL_ROW_15_433 VGND VPWR sky130_fd_sc_hd__tapvpwrvgnd_1
XTAP_TAPCELL_ROW_55_591 VGND VPWR sky130_fd_sc_hd__tapvpwrvgnd_1
X_0961_ net122 net269 VGND VGND VPWR VPWR Tile_X0Y0_OpenRAM_top.Inst_OpenRAM_top_ConfigMem.Inst_frame8_bit17.Q
+ sky130_fd_sc_hd__dlxtp_1
XFILLER_43_90 VGND VGND VPWR VPWR sky130_fd_sc_hd__decap_3
X_0892_ net128 net283 VGND VGND VPWR VPWR Tile_X0Y0_OpenRAM_top.Inst_OpenRAM_top_ConfigMem.Inst_frame6_bit22.Q
+ sky130_fd_sc_hd__dlxtp_1
XFILLER_160_107 VGND VGND VPWR VPWR sky130_fd_sc_hd__fill_2
XFILLER_99_213 VGND VGND VPWR VPWR sky130_fd_sc_hd__decap_3
XFILLER_4_180 VGND VGND VPWR VPWR sky130_fd_sc_hd__decap_3
XFILLER_101_229 VGND VGND VPWR VPWR sky130_fd_sc_hd__fill_1
XFILLER_4_62 VGND VGND VPWR VPWR sky130_fd_sc_hd__decap_3
X_1444_ Tile_X0Y0_OpenRAM_top.Inst_OpenRAM_top_switch_matrix.S2BEG6 VGND VGND VPWR
+ VPWR net604 sky130_fd_sc_hd__buf_2
XPHY_EDGE_ROW_155_Right_155 VGND VGND VPWR VPWR sky130_fd_sc_hd__decap_3
X_1375_ Tile_X0Y0_OpenRAM_top.Inst_OpenRAM_top_switch_matrix.W6BEG9 VGND VGND VPWR
+ VPWR net537 sky130_fd_sc_hd__clkbuf_1
X_0326_ Tile_X0Y0_OpenRAM_top.Inst_OpenRAM_top_switch_matrix.N2BEGb1 net159 net350
+ net151 Tile_X0Y0_OpenRAM_top.Inst_OpenRAM_top_ConfigMem.Inst_frame0_bit11.Q Tile_X0Y0_OpenRAM_top.Inst_OpenRAM_top_ConfigMem.Inst_frame0_bit10.Q
+ VGND VGND VPWR VPWR Tile_X0Y0_OpenRAM_top.Inst_OpenRAM_top_switch_matrix.J_NS2_BEG1
+ sky130_fd_sc_hd__mux4_2
X_0257_ net85 net77 net96 net259 Tile_X0Y0_OpenRAM_top.Inst_OpenRAM_top_ConfigMem.Inst_frame7_bit24.Q
+ Tile_X0Y0_OpenRAM_top.Inst_OpenRAM_top_ConfigMem.Inst_frame7_bit25.Q VGND VGND VPWR
+ VPWR Tile_X0Y0_OpenRAM_top.Inst_OpenRAM_top_switch_matrix.S2BEG0 sky130_fd_sc_hd__mux4_2
XTAP_TAPCELL_ROW_38_525 VGND VPWR sky130_fd_sc_hd__tapvpwrvgnd_1
XTAP_TAPCELL_ROW_78_683 VGND VPWR sky130_fd_sc_hd__tapvpwrvgnd_1
XFILLER_82_113 VGND VGND VPWR VPWR sky130_fd_sc_hd__decap_3
XFILLER_82_179 VGND VGND VPWR VPWR sky130_fd_sc_hd__decap_3
XFILLER_168_218 VGND VGND VPWR VPWR sky130_fd_sc_hd__decap_3
XFILLER_90_190 VGND VGND VPWR VPWR sky130_fd_sc_hd__fill_1
XFILLER_139_27 VGND VGND VPWR VPWR sky130_fd_sc_hd__decap_3
XFILLER_136_104 VGND VGND VPWR VPWR sky130_fd_sc_hd__decap_3
XFILLER_136_137 VGND VGND VPWR VPWR sky130_fd_sc_hd__decap_3
XFILLER_136_159 VGND VGND VPWR VPWR sky130_fd_sc_hd__decap_3
XFILLER_155_37 VGND VGND VPWR VPWR sky130_fd_sc_hd__decap_3
XFILLER_2_106 VGND VGND VPWR VPWR sky130_fd_sc_hd__decap_3
XFILLER_144_192 VGND VGND VPWR VPWR sky130_fd_sc_hd__decap_3
XFILLER_2_139 VGND VGND VPWR VPWR sky130_fd_sc_hd__fill_1
XFILLER_48_24 VGND VGND VPWR VPWR sky130_fd_sc_hd__decap_3
XFILLER_171_36 VGND VGND VPWR VPWR sky130_fd_sc_hd__decap_3
XFILLER_48_35 VGND VGND VPWR VPWR sky130_fd_sc_hd__decap_3
XFILLER_171_69 VGND VGND VPWR VPWR sky130_fd_sc_hd__decap_3
XPHY_EDGE_ROW_122_Right_122 VGND VGND VPWR VPWR sky130_fd_sc_hd__decap_3
XFILLER_48_68 VGND VGND VPWR VPWR sky130_fd_sc_hd__decap_3
XFILLER_58_165 VGND VGND VPWR VPWR sky130_fd_sc_hd__decap_3
XFILLER_104_41 VGND VGND VPWR VPWR sky130_fd_sc_hd__decap_3
XFILLER_73_113 VGND VGND VPWR VPWR sky130_fd_sc_hd__decap_3
XFILLER_104_85 VGND VGND VPWR VPWR sky130_fd_sc_hd__decap_3
XFILLER_104_74 VGND VGND VPWR VPWR sky130_fd_sc_hd__decap_3
XFILLER_73_146 VGND VGND VPWR VPWR sky130_fd_sc_hd__decap_3
XFILLER_159_207 VGND VGND VPWR VPWR sky130_fd_sc_hd__decap_3
XFILLER_14_224 VGND VGND VPWR VPWR sky130_fd_sc_hd__decap_3
XFILLER_9_18 VGND VGND VPWR VPWR sky130_fd_sc_hd__decap_3
XFILLER_182_221 VGND VGND VPWR VPWR sky130_fd_sc_hd__decap_3
XFILLER_127_148 VGND VGND VPWR VPWR sky130_fd_sc_hd__decap_3
XFILLER_129_93 VGND VGND VPWR VPWR sky130_fd_sc_hd__decap_3
XFILLER_150_162 VGND VGND VPWR VPWR sky130_fd_sc_hd__decap_3
XFILLER_150_195 VGND VGND VPWR VPWR sky130_fd_sc_hd__fill_1
XFILLER_145_92 VGND VGND VPWR VPWR sky130_fd_sc_hd__decap_3
XFILLER_29_7 VGND VGND VPWR VPWR sky130_fd_sc_hd__fill_1
XTAP_TAPCELL_ROW_182_1102 VGND VPWR sky130_fd_sc_hd__tapvpwrvgnd_1
XTAP_TAPCELL_ROW_119_846 VGND VPWR sky130_fd_sc_hd__tapvpwrvgnd_1
X_1160_ net245 net280 VGND VGND VPWR VPWR Tile_X0Y1_OpenRAM_bot.Inst_OpenRAM_bot_ConfigMem.Inst_frame6_bit30.Q
+ sky130_fd_sc_hd__dlxtp_1
XFILLER_49_143 VGND VGND VPWR VPWR sky130_fd_sc_hd__decap_3
XFILLER_64_124 VGND VGND VPWR VPWR sky130_fd_sc_hd__decap_3
X_1091_ net247 net307 VGND VGND VPWR VPWR Tile_X0Y1_OpenRAM_bot.Inst_OpenRAM_bot_ConfigMem.Inst_frame3_bit3.Q
+ sky130_fd_sc_hd__dlxtp_1
XTAP_TAPCELL_ROW_102_779 VGND VPWR sky130_fd_sc_hd__tapvpwrvgnd_1
XFILLER_20_227 VGND VGND VPWR VPWR sky130_fd_sc_hd__fill_1
X_0944_ net136 net277 VGND VGND VPWR VPWR Tile_X0Y0_OpenRAM_top.Inst_OpenRAM_top_ConfigMem.Inst_frame7_bit2.Q
+ sky130_fd_sc_hd__dlxtp_1
X_0875_ net143 net294 VGND VGND VPWR VPWR Tile_X0Y0_OpenRAM_top.Inst_OpenRAM_top_ConfigMem.Inst_frame5_bit7.Q
+ sky130_fd_sc_hd__dlxtp_1
XFILLER_118_126 VGND VGND VPWR VPWR sky130_fd_sc_hd__decap_3
XFILLER_118_159 VGND VGND VPWR VPWR sky130_fd_sc_hd__decap_3
XFILLER_126_192 VGND VGND VPWR VPWR sky130_fd_sc_hd__decap_3
XFILLER_141_184 VGND VGND VPWR VPWR sky130_fd_sc_hd__decap_3
X_1427_ Tile_X0Y1_OpenRAM_bot.Inst_OpenRAM_bot_switch_matrix.S1BEG1 VGND VGND VPWR
+ VPWR net587 sky130_fd_sc_hd__clkbuf_2
XFILLER_141_28 VGND VGND VPWR VPWR sky130_fd_sc_hd__decap_3
X_1358_ Tile_X0Y0_OpenRAM_top.Inst_OpenRAM_top_switch_matrix.W2BEGb0 VGND VGND VPWR
+ VPWR net518 sky130_fd_sc_hd__buf_1
XFILLER_18_38 VGND VGND VPWR VPWR sky130_fd_sc_hd__decap_3
XFILLER_18_27 VGND VGND VPWR VPWR sky130_fd_sc_hd__fill_1
XFILLER_55_113 VGND VGND VPWR VPWR sky130_fd_sc_hd__decap_3
X_1289_ net336 VGND VGND VPWR VPWR net449 sky130_fd_sc_hd__buf_1
XFILLER_55_157 VGND VGND VPWR VPWR sky130_fd_sc_hd__decap_3
X_0309_ net176 Tile_X0Y1_OpenRAM_bot.Inst_OpenRAM_bot_switch_matrix.J_NS4_BEG14 net202
+ _0073_ Tile_X0Y1_OpenRAM_bot.Inst_OpenRAM_bot_ConfigMem.Inst_frame8_bit5.Q Tile_X0Y1_OpenRAM_bot.Inst_OpenRAM_bot_ConfigMem.Inst_frame8_bit4.Q
+ VGND VGND VPWR VPWR Tile_X0Y0_OpenRAM_top.Inst_OpenRAM_top_switch_matrix.N1END2
+ sky130_fd_sc_hd__mux4_2
XFILLER_63_190 VGND VGND VPWR VPWR sky130_fd_sc_hd__decap_3
XFILLER_70_127 VGND VGND VPWR VPWR sky130_fd_sc_hd__decap_3
XFILLER_164_221 VGND VGND VPWR VPWR sky130_fd_sc_hd__decap_3
XFILLER_109_137 VGND VGND VPWR VPWR sky130_fd_sc_hd__decap_3
XFILLER_50_25 VGND VGND VPWR VPWR sky130_fd_sc_hd__decap_3
XFILLER_50_47 VGND VGND VPWR VPWR sky130_fd_sc_hd__decap_3
XFILLER_166_47 VGND VGND VPWR VPWR sky130_fd_sc_hd__decap_3
XTAP_TAPCELL_ROW_170_1050 VGND VPWR sky130_fd_sc_hd__tapvpwrvgnd_1
XFILLER_124_118 VGND VGND VPWR VPWR sky130_fd_sc_hd__decap_3
XFILLER_117_181 VGND VGND VPWR VPWR sky130_fd_sc_hd__decap_3
XFILLER_132_162 VGND VGND VPWR VPWR sky130_fd_sc_hd__decap_3
Xoutput580 net663 VGND VGND VPWR VPWR Tile_X0Y1_WW4BEG[3] sky130_fd_sc_hd__buf_2
XFILLER_182_57 VGND VGND VPWR VPWR sky130_fd_sc_hd__decap_3
XFILLER_132_195 VGND VGND VPWR VPWR sky130_fd_sc_hd__fill_1
Xoutput591 net674 VGND VGND VPWR VPWR WMASK_A_SRAM3 sky130_fd_sc_hd__buf_2
XFILLER_115_51 VGND VGND VPWR VPWR sky130_fd_sc_hd__decap_3
Xfanout273 Tile_X0Y1_FrameStrobe[7] VGND VGND VPWR VPWR net273 sky130_fd_sc_hd__clkbuf_2
Xfanout262 _0081_ VGND VGND VPWR VPWR net262 sky130_fd_sc_hd__clkbuf_4
XFILLER_93_208 VGND VGND VPWR VPWR sky130_fd_sc_hd__decap_3
Xfanout284 net286 VGND VGND VPWR VPWR net284 sky130_fd_sc_hd__clkbuf_4
XFILLER_115_84 VGND VGND VPWR VPWR sky130_fd_sc_hd__decap_3
XFILLER_75_55 VGND VGND VPWR VPWR sky130_fd_sc_hd__fill_1
Xfanout295 Tile_X0Y1_FrameStrobe[5] VGND VGND VPWR VPWR net295 sky130_fd_sc_hd__dlymetal6s2s_1
XTAP_TAPCELL_ROW_156_996 VGND VPWR sky130_fd_sc_hd__tapvpwrvgnd_1
XFILLER_75_88 VGND VGND VPWR VPWR sky130_fd_sc_hd__decap_3
XFILLER_61_116 VGND VGND VPWR VPWR sky130_fd_sc_hd__decap_3
XFILLER_131_72 VGND VGND VPWR VPWR sky130_fd_sc_hd__decap_3
XFILLER_24_92 VGND VGND VPWR VPWR sky130_fd_sc_hd__decap_3
XTAP_TAPCELL_ROW_40_531 VGND VPWR sky130_fd_sc_hd__tapvpwrvgnd_1
XFILLER_155_221 VGND VGND VPWR VPWR sky130_fd_sc_hd__decap_3
XFILLER_170_224 VGND VGND VPWR VPWR sky130_fd_sc_hd__decap_3
X_0660_ Tile_X0Y1_OpenRAM_bot.Inst_OpenRAM_bot_switch_matrix.J_NS4_BEG13 _0085_ Tile_X0Y1_OpenRAM_bot.Inst_OpenRAM_bot_ConfigMem.Inst_frame7_bit31.Q
+ VGND VGND VPWR VPWR _0200_ sky130_fd_sc_hd__mux2_1
XFILLER_108_192 VGND VGND VPWR VPWR sky130_fd_sc_hd__decap_3
X_0591_ net187 Tile_X0Y1_OpenRAM_bot.Inst_OpenRAM_bot_ConfigMem.Inst_frame3_bit22.Q
+ Tile_X0Y1_OpenRAM_bot.Inst_OpenRAM_bot_ConfigMem.Inst_frame3_bit23.Q VGND VGND VPWR
+ VPWR _0159_ sky130_fd_sc_hd__o21ba_1
XFILLER_156_91 VGND VGND VPWR VPWR sky130_fd_sc_hd__decap_3
XFILLER_123_140 VGND VGND VPWR VPWR sky130_fd_sc_hd__decap_3
XFILLER_69_205 VGND VGND VPWR VPWR sky130_fd_sc_hd__fill_1
X_1212_ net223 net270 VGND VGND VPWR VPWR Tile_X0Y1_OpenRAM_bot.Inst_OpenRAM_bot_ConfigMem.Inst_frame7_bit10.Q
+ sky130_fd_sc_hd__dlxtp_1
XFILLER_37_102 VGND VGND VPWR VPWR sky130_fd_sc_hd__decap_3
X_1143_ net228 net288 VGND VGND VPWR VPWR Tile_X0Y1_OpenRAM_bot.Inst_OpenRAM_bot_ConfigMem.Inst_frame5_bit15.Q
+ sky130_fd_sc_hd__dlxtp_1
XFILLER_1_96 VGND VGND VPWR VPWR sky130_fd_sc_hd__decap_3
X_1074_ net234 net305 VGND VGND VPWR VPWR Tile_X0Y1_OpenRAM_bot.Inst_OpenRAM_bot_ConfigMem.Inst_frame3_bit20.Q
+ sky130_fd_sc_hd__dlxtp_1
XTAP_TAPCELL_ROW_63_623 VGND VPWR sky130_fd_sc_hd__tapvpwrvgnd_1
X_0927_ net124 net275 VGND VGND VPWR VPWR Tile_X0Y0_OpenRAM_top.Inst_OpenRAM_top_ConfigMem.Inst_frame7_bit19.Q
+ sky130_fd_sc_hd__dlxtp_1
X_0858_ net130 net292 VGND VGND VPWR VPWR Tile_X0Y0_OpenRAM_top.Inst_OpenRAM_top_ConfigMem.Inst_frame5_bit24.Q
+ sky130_fd_sc_hd__dlxtp_1
XFILLER_106_129 VGND VGND VPWR VPWR sky130_fd_sc_hd__decap_3
X_0789_ net135 net310 VGND VGND VPWR VPWR Tile_X0Y0_OpenRAM_top.Inst_OpenRAM_top_ConfigMem.Inst_frame3_bit29.Q
+ sky130_fd_sc_hd__dlxtp_1
XFILLER_114_162 VGND VGND VPWR VPWR sky130_fd_sc_hd__decap_3
XFILLER_29_26 VGND VGND VPWR VPWR sky130_fd_sc_hd__fill_1
XFILLER_29_48 VGND VGND VPWR VPWR sky130_fd_sc_hd__decap_3
XTAP_TAPCELL_ROW_86_715 VGND VPWR sky130_fd_sc_hd__tapvpwrvgnd_1
XTAP_TAPCELL_ROW_161_1016 VGND VPWR sky130_fd_sc_hd__tapvpwrvgnd_1
XFILLER_43_105 VGND VGND VPWR VPWR sky130_fd_sc_hd__decap_3
XFILLER_43_116 VGND VGND VPWR VPWR sky130_fd_sc_hd__decap_3
XFILLER_45_14 VGND VGND VPWR VPWR sky130_fd_sc_hd__decap_3
XFILLER_45_47 VGND VGND VPWR VPWR sky130_fd_sc_hd__fill_1
XFILLER_43_149 VGND VGND VPWR VPWR sky130_fd_sc_hd__decap_3
XFILLER_101_31 VGND VGND VPWR VPWR sky130_fd_sc_hd__decap_3
XFILLER_177_24 VGND VGND VPWR VPWR sky130_fd_sc_hd__decap_3
XPHY_EDGE_ROW_49_Left_232 VGND VGND VPWR VPWR sky130_fd_sc_hd__decap_3
XFILLER_177_57 VGND VGND VPWR VPWR sky130_fd_sc_hd__decap_3
XFILLER_3_223 VGND VGND VPWR VPWR sky130_fd_sc_hd__fill_1
XFILLER_10_50 VGND VGND VPWR VPWR sky130_fd_sc_hd__decap_3
XFILLER_126_61 VGND VGND VPWR VPWR sky130_fd_sc_hd__decap_3
XFILLER_120_110 VGND VGND VPWR VPWR sky130_fd_sc_hd__decap_3
XFILLER_105_184 VGND VGND VPWR VPWR sky130_fd_sc_hd__decap_3
XFILLER_10_94 VGND VGND VPWR VPWR sky130_fd_sc_hd__decap_3
XFILLER_10_83 VGND VGND VPWR VPWR sky130_fd_sc_hd__fill_1
XFILLER_86_21 VGND VGND VPWR VPWR sky130_fd_sc_hd__decap_3
XPHY_EDGE_ROW_58_Left_241 VGND VGND VPWR VPWR sky130_fd_sc_hd__decap_3
XFILLER_86_54 VGND VGND VPWR VPWR sky130_fd_sc_hd__fill_1
XFILLER_120_187 VGND VGND VPWR VPWR sky130_fd_sc_hd__decap_3
XFILLER_19_146 VGND VGND VPWR VPWR sky130_fd_sc_hd__decap_3
XFILLER_142_82 VGND VGND VPWR VPWR sky130_fd_sc_hd__fill_2
XFILLER_34_105 VGND VGND VPWR VPWR sky130_fd_sc_hd__decap_3
XFILLER_42_182 VGND VGND VPWR VPWR sky130_fd_sc_hd__decap_3
XPHY_EDGE_ROW_67_Left_250 VGND VGND VPWR VPWR sky130_fd_sc_hd__decap_3
XFILLER_89_6 VGND VGND VPWR VPWR sky130_fd_sc_hd__decap_3
XTAP_TAPCELL_ROW_177_1078 VGND VPWR sky130_fd_sc_hd__tapvpwrvgnd_1
XFILLER_128_221 VGND VGND VPWR VPWR sky130_fd_sc_hd__decap_3
X_0712_ net115 net335 VGND VGND VPWR VPWR Tile_X0Y0_OpenRAM_top.Inst_OpenRAM_top_ConfigMem.Inst_frame0_bit10.Q
+ sky130_fd_sc_hd__dlxtp_1
X_0643_ Tile_X0Y1_OpenRAM_bot.Inst_OpenRAM_bot_ConfigMem.Inst_frame8_bit31.Q _0185_
+ Tile_X0Y1_OpenRAM_bot.Inst_OpenRAM_bot_ConfigMem.Inst_frame7_bit0.Q VGND VGND VPWR
+ VPWR _0186_ sky130_fd_sc_hd__a21bo_1
XFILLER_111_110 VGND VGND VPWR VPWR sky130_fd_sc_hd__fill_2
X_0574_ net357 net170 _0145_ Tile_X0Y1_OpenRAM_bot.Inst_OpenRAM_bot_switch_matrix.J_NS4_BEG15
+ Tile_X0Y1_OpenRAM_bot.Inst_OpenRAM_bot_ConfigMem.Inst_frame4_bit16.Q Tile_X0Y1_OpenRAM_bot.Inst_OpenRAM_bot_ConfigMem.Inst_frame4_bit17.Q
+ VGND VGND VPWR VPWR Tile_X0Y1_OpenRAM_bot.Inst_OpenRAM_bot_switch_matrix.W6BEG0
+ sky130_fd_sc_hd__mux4_1
XFILLER_111_154 VGND VGND VPWR VPWR sky130_fd_sc_hd__fill_2
XTAP_TAPCELL_ROW_135_911 VGND VPWR sky130_fd_sc_hd__tapvpwrvgnd_1
X_1126_ net222 net296 VGND VGND VPWR VPWR Tile_X0Y1_OpenRAM_bot.Inst_OpenRAM_bot_ConfigMem.Inst_frame4_bit0.Q
+ sky130_fd_sc_hd__dlxtp_1
XFILLER_80_200 VGND VGND VPWR VPWR sky130_fd_sc_hd__decap_3
XFILLER_25_116 VGND VGND VPWR VPWR sky130_fd_sc_hd__decap_3
XFILLER_25_149 VGND VGND VPWR VPWR sky130_fd_sc_hd__decap_3
XFILLER_15_28 VGND VGND VPWR VPWR sky130_fd_sc_hd__decap_3
X_1057_ net249 net315 VGND VGND VPWR VPWR Tile_X0Y1_OpenRAM_bot.Inst_OpenRAM_bot_ConfigMem.Inst_frame2_bit5.Q
+ sky130_fd_sc_hd__dlxtp_1
XFILLER_178_121 VGND VGND VPWR VPWR sky130_fd_sc_hd__decap_3
XFILLER_178_165 VGND VGND VPWR VPWR sky130_fd_sc_hd__decap_3
XFILLER_119_210 VGND VGND VPWR VPWR sky130_fd_sc_hd__decap_3
XFILLER_147_16 VGND VGND VPWR VPWR sky130_fd_sc_hd__decap_3
XFILLER_31_38 VGND VGND VPWR VPWR sky130_fd_sc_hd__decap_3
XFILLER_147_49 VGND VGND VPWR VPWR sky130_fd_sc_hd__decap_3
XFILLER_134_224 VGND VGND VPWR VPWR sky130_fd_sc_hd__decap_3
XFILLER_0_215 VGND VGND VPWR VPWR sky130_fd_sc_hd__decap_3
Xinput127 Tile_X0Y0_FrameData[21] VGND VGND VPWR VPWR net127 sky130_fd_sc_hd__clkbuf_4
XFILLER_163_48 VGND VGND VPWR VPWR sky130_fd_sc_hd__decap_3
Xinput116 Tile_X0Y0_FrameData[11] VGND VGND VPWR VPWR net116 sky130_fd_sc_hd__clkbuf_4
Xinput105 Tile_X0Y0_EE4END[1] VGND VGND VPWR VPWR net105 sky130_fd_sc_hd__buf_1
XFILLER_102_132 VGND VGND VPWR VPWR sky130_fd_sc_hd__decap_3
Xinput149 Tile_X0Y0_S1END[3] VGND VGND VPWR VPWR net149 sky130_fd_sc_hd__buf_2
Xinput138 Tile_X0Y0_FrameData[31] VGND VGND VPWR VPWR net138 sky130_fd_sc_hd__clkbuf_4
XFILLER_102_187 VGND VGND VPWR VPWR sky130_fd_sc_hd__decap_3
XFILLER_102_165 VGND VGND VPWR VPWR sky130_fd_sc_hd__decap_3
XFILLER_56_24 VGND VGND VPWR VPWR sky130_fd_sc_hd__decap_3
XFILLER_56_35 VGND VGND VPWR VPWR sky130_fd_sc_hd__decap_3
XFILLER_56_79 VGND VGND VPWR VPWR sky130_fd_sc_hd__decap_3
XFILLER_112_41 VGND VGND VPWR VPWR sky130_fd_sc_hd__decap_3
XFILLER_16_127 VGND VGND VPWR VPWR sky130_fd_sc_hd__decap_3
XFILLER_71_233 VGND VGND VPWR VPWR sky130_fd_sc_hd__fill_1
XTAP_TAPCELL_ROW_141_936 VGND VPWR sky130_fd_sc_hd__tapvpwrvgnd_1
XFILLER_112_85 VGND VGND VPWR VPWR sky130_fd_sc_hd__decap_3
XFILLER_31_119 VGND VGND VPWR VPWR sky130_fd_sc_hd__decap_3
XFILLER_72_56 VGND VGND VPWR VPWR sky130_fd_sc_hd__decap_3
XFILLER_169_165 VGND VGND VPWR VPWR sky130_fd_sc_hd__decap_3
XFILLER_24_182 VGND VGND VPWR VPWR sky130_fd_sc_hd__decap_3
XFILLER_169_187 VGND VGND VPWR VPWR sky130_fd_sc_hd__decap_3
XFILLER_21_60 VGND VGND VPWR VPWR sky130_fd_sc_hd__decap_3
XFILLER_137_82 VGND VGND VPWR VPWR sky130_fd_sc_hd__decap_3
XFILLER_21_93 VGND VGND VPWR VPWR sky130_fd_sc_hd__decap_3
XFILLER_140_227 VGND VGND VPWR VPWR sky130_fd_sc_hd__decap_3
XFILLER_97_75 VGND VGND VPWR VPWR sky130_fd_sc_hd__decap_3
X_0290_ _0056_ _0058_ Tile_X0Y1_OpenRAM_bot.Inst_OpenRAM_bot_ConfigMem.Inst_frame2_bit31.Q
+ VGND VGND VPWR VPWR _0059_ sky130_fd_sc_hd__a21oi_1
XFILLER_11_7 VGND VGND VPWR VPWR sky130_fd_sc_hd__decap_3
XFILLER_62_200 VGND VGND VPWR VPWR sky130_fd_sc_hd__decap_3
XFILLER_175_113 VGND VGND VPWR VPWR sky130_fd_sc_hd__decap_3
XFILLER_175_102 VGND VGND VPWR VPWR sky130_fd_sc_hd__decap_3
XFILLER_87_3 VGND VGND VPWR VPWR sky130_fd_sc_hd__decap_3
XFILLER_175_146 VGND VGND VPWR VPWR sky130_fd_sc_hd__decap_3
XFILLER_30_174 VGND VGND VPWR VPWR sky130_fd_sc_hd__decap_3
XFILLER_7_51 VGND VGND VPWR VPWR sky130_fd_sc_hd__decap_3
XFILLER_116_224 VGND VGND VPWR VPWR sky130_fd_sc_hd__decap_3
XFILLER_7_84 VGND VGND VPWR VPWR sky130_fd_sc_hd__decap_3
XFILLER_89_108 VGND VGND VPWR VPWR sky130_fd_sc_hd__decap_3
XFILLER_89_119 VGND VGND VPWR VPWR sky130_fd_sc_hd__decap_3
XPHY_EDGE_ROW_15_Right_15 VGND VGND VPWR VPWR sky130_fd_sc_hd__decap_3
X_0626_ net181 _0029_ _0171_ VGND VGND VPWR VPWR _0172_ sky130_fd_sc_hd__o21a_1
X_0557_ net31 net63 _0148_ net263 Tile_X0Y1_OpenRAM_bot.Inst_OpenRAM_bot_ConfigMem.Inst_frame5_bit30.Q
+ Tile_X0Y1_OpenRAM_bot.Inst_OpenRAM_bot_ConfigMem.Inst_frame5_bit31.Q VGND VGND VPWR
+ VPWR Tile_X0Y1_OpenRAM_bot.Inst_OpenRAM_bot_switch_matrix.WW4BEG7 sky130_fd_sc_hd__mux4_1
XFILLER_133_29 VGND VGND VPWR VPWR sky130_fd_sc_hd__decap_3
XFILLER_97_185 VGND VGND VPWR VPWR sky130_fd_sc_hd__decap_3
X_0488_ net107 Tile_X0Y0_OpenRAM_top.Inst_OpenRAM_top_switch_matrix.J_NS4_BEG11 Tile_X0Y0_OpenRAM_top.Inst_OpenRAM_top_ConfigMem.Inst_frame7_bit15.Q
+ VGND VGND VPWR VPWR _0129_ sky130_fd_sc_hd__mux2_1
XFILLER_26_38 VGND VGND VPWR VPWR sky130_fd_sc_hd__decap_3
XPHY_EDGE_ROW_24_Right_24 VGND VGND VPWR VPWR sky130_fd_sc_hd__decap_3
X_1109_ net230 net296 VGND VGND VPWR VPWR Tile_X0Y1_OpenRAM_bot.Inst_OpenRAM_bot_ConfigMem.Inst_frame4_bit17.Q
+ sky130_fd_sc_hd__dlxtp_1
XFILLER_42_15 VGND VGND VPWR VPWR sky130_fd_sc_hd__decap_3
XFILLER_166_113 VGND VGND VPWR VPWR sky130_fd_sc_hd__decap_3
XFILLER_158_26 VGND VGND VPWR VPWR sky130_fd_sc_hd__fill_2
XFILLER_21_152 VGND VGND VPWR VPWR sky130_fd_sc_hd__decap_3
XFILLER_42_59 VGND VGND VPWR VPWR sky130_fd_sc_hd__decap_3
XFILLER_21_196 VGND VGND VPWR VPWR sky130_fd_sc_hd__fill_1
XFILLER_166_168 VGND VGND VPWR VPWR sky130_fd_sc_hd__decap_3
XFILLER_174_47 VGND VGND VPWR VPWR sky130_fd_sc_hd__decap_3
XPHY_EDGE_ROW_169_Right_169 VGND VGND VPWR VPWR sky130_fd_sc_hd__decap_3
XPHY_EDGE_ROW_33_Right_33 VGND VGND VPWR VPWR sky130_fd_sc_hd__decap_3
XFILLER_122_216 VGND VGND VPWR VPWR sky130_fd_sc_hd__decap_3
XFILLER_107_52 VGND VGND VPWR VPWR sky130_fd_sc_hd__decap_3
XFILLER_88_141 VGND VGND VPWR VPWR sky130_fd_sc_hd__decap_3
XFILLER_107_96 VGND VGND VPWR VPWR sky130_fd_sc_hd__decap_3
XFILLER_67_45 VGND VGND VPWR VPWR sky130_fd_sc_hd__decap_3
XFILLER_88_185 VGND VGND VPWR VPWR sky130_fd_sc_hd__decap_3
XFILLER_123_51 VGND VGND VPWR VPWR sky130_fd_sc_hd__decap_3
XFILLER_123_84 VGND VGND VPWR VPWR sky130_fd_sc_hd__decap_3
XPHY_EDGE_ROW_42_Right_42 VGND VGND VPWR VPWR sky130_fd_sc_hd__decap_3
XFILLER_44_200 VGND VGND VPWR VPWR sky130_fd_sc_hd__decap_3
XFILLER_83_33 VGND VGND VPWR VPWR sky130_fd_sc_hd__decap_3
XFILLER_44_233 VGND VGND VPWR VPWR sky130_fd_sc_hd__fill_1
XFILLER_83_66 VGND VGND VPWR VPWR sky130_fd_sc_hd__decap_3
XFILLER_16_71 VGND VGND VPWR VPWR sky130_fd_sc_hd__decap_3
XFILLER_83_99 VGND VGND VPWR VPWR sky130_fd_sc_hd__decap_3
XFILLER_157_113 VGND VGND VPWR VPWR sky130_fd_sc_hd__decap_3
XFILLER_8_112 VGND VGND VPWR VPWR sky130_fd_sc_hd__decap_3
XFILLER_8_156 VGND VGND VPWR VPWR sky130_fd_sc_hd__decap_3
XPHY_EDGE_ROW_51_Right_51 VGND VGND VPWR VPWR sky130_fd_sc_hd__decap_3
XFILLER_172_127 VGND VGND VPWR VPWR sky130_fd_sc_hd__decap_3
XFILLER_148_70 VGND VGND VPWR VPWR sky130_fd_sc_hd__decap_3
XFILLER_8_189 VGND VGND VPWR VPWR sky130_fd_sc_hd__decap_3
Xoutput409 net492 VGND VGND VPWR VPWR Tile_X0Y0_N4BEG[12] sky130_fd_sc_hd__buf_2
XPHY_EDGE_ROW_136_Right_136 VGND VGND VPWR VPWR sky130_fd_sc_hd__decap_3
XFILLER_113_205 VGND VGND VPWR VPWR sky130_fd_sc_hd__decap_3
XFILLER_180_160 VGND VGND VPWR VPWR sky130_fd_sc_hd__decap_3
X_1460_ Tile_X0Y1_OpenRAM_bot.Inst_OpenRAM_bot_switch_matrix.S4BEG2 VGND VGND VPWR
+ VPWR net611 sky130_fd_sc_hd__buf_1
X_0411_ Tile_X0Y0_OpenRAM_top.Inst_OpenRAM_top_switch_matrix.N1END1 net362 net147
+ net167 Tile_X0Y0_OpenRAM_top.Inst_OpenRAM_top_ConfigMem.Inst_frame1_bit10.Q Tile_X0Y0_OpenRAM_top.Inst_OpenRAM_top_ConfigMem.Inst_frame1_bit11.Q
+ VGND VGND VPWR VPWR Tile_X0Y0_OpenRAM_top.Inst_OpenRAM_top_switch_matrix.J_NS4_BEG1
+ sky130_fd_sc_hd__mux4_2
X_1391_ Tile_X0Y0_OpenRAM_top.Inst_OpenRAM_top_switch_matrix.WW4BEG13 VGND VGND VPWR
+ VPWR net542 sky130_fd_sc_hd__buf_1
X_0342_ net81 net73 net91 Tile_X0Y0_OpenRAM_top.Inst_OpenRAM_top_switch_matrix.J_NS2_BEG4
+ Tile_X0Y0_OpenRAM_top.Inst_OpenRAM_top_ConfigMem.Inst_frame8_bit28.Q Tile_X0Y0_OpenRAM_top.Inst_OpenRAM_top_ConfigMem.Inst_frame8_bit29.Q
+ VGND VGND VPWR VPWR Tile_X0Y0_OpenRAM_top.Inst_OpenRAM_top_switch_matrix.N2BEG4
+ sky130_fd_sc_hd__mux4_1
XFILLER_94_100 VGND VGND VPWR VPWR sky130_fd_sc_hd__decap_3
XFILLER_79_196 VGND VGND VPWR VPWR sky130_fd_sc_hd__decap_3
XFILLER_94_133 VGND VGND VPWR VPWR sky130_fd_sc_hd__decap_3
XPHY_EDGE_ROW_60_Right_60 VGND VGND VPWR VPWR sky130_fd_sc_hd__decap_3
X_0273_ Tile_X0Y1_OpenRAM_bot.Inst_OpenRAM_bot_ConfigMem.Inst_frame3_bit10.Q _0038_
+ _0042_ VGND VGND VPWR VPWR _0043_ sky130_fd_sc_hd__a21oi_1
XFILLER_94_177 VGND VGND VPWR VPWR sky130_fd_sc_hd__decap_3
XFILLER_35_222 VGND VGND VPWR VPWR sky130_fd_sc_hd__fill_2
XTAP_TAPCELL_ROW_18_442 VGND VPWR sky130_fd_sc_hd__tapvpwrvgnd_1
XFILLER_148_124 VGND VGND VPWR VPWR sky130_fd_sc_hd__decap_3
XFILLER_12_18 VGND VGND VPWR VPWR sky130_fd_sc_hd__decap_3
XFILLER_163_116 VGND VGND VPWR VPWR sky130_fd_sc_hd__decap_3
XFILLER_148_168 VGND VGND VPWR VPWR sky130_fd_sc_hd__decap_3
XFILLER_156_190 VGND VGND VPWR VPWR sky130_fd_sc_hd__decap_3
XFILLER_128_29 VGND VGND VPWR VPWR sky130_fd_sc_hd__decap_3
XPHY_EDGE_ROW_103_Right_103 VGND VGND VPWR VPWR sky130_fd_sc_hd__decap_3
XFILLER_104_227 VGND VGND VPWR VPWR sky130_fd_sc_hd__decap_3
XFILLER_171_193 VGND VGND VPWR VPWR sky130_fd_sc_hd__decap_3
XFILLER_144_39 VGND VGND VPWR VPWR sky130_fd_sc_hd__decap_3
X_0609_ net213 net221 net205 _0147_ Tile_X0Y1_OpenRAM_bot.Inst_OpenRAM_bot_ConfigMem.Inst_frame2_bit14.Q
+ Tile_X0Y1_OpenRAM_bot.Inst_OpenRAM_bot_ConfigMem.Inst_frame2_bit15.Q VGND VGND VPWR
+ VPWR net416 sky130_fd_sc_hd__mux4_1
XFILLER_37_15 VGND VGND VPWR VPWR sky130_fd_sc_hd__decap_3
XPHY_EDGE_ROW_13_Left_196 VGND VGND VPWR VPWR sky130_fd_sc_hd__decap_3
XFILLER_37_48 VGND VGND VPWR VPWR sky130_fd_sc_hd__decap_3
XFILLER_85_155 VGND VGND VPWR VPWR sky130_fd_sc_hd__decap_3
XFILLER_160_38 VGND VGND VPWR VPWR sky130_fd_sc_hd__decap_3
XFILLER_160_27 VGND VGND VPWR VPWR sky130_fd_sc_hd__fill_1
XFILLER_26_200 VGND VGND VPWR VPWR sky130_fd_sc_hd__decap_3
XFILLER_26_222 VGND VGND VPWR VPWR sky130_fd_sc_hd__decap_3
XFILLER_85_199 VGND VGND VPWR VPWR sky130_fd_sc_hd__decap_3
XTAP_TAPCELL_ROW_1_376 VGND VPWR sky130_fd_sc_hd__tapvpwrvgnd_1
XFILLER_41_214 VGND VGND VPWR VPWR sky130_fd_sc_hd__decap_3
XFILLER_53_36 VGND VGND VPWR VPWR sky130_fd_sc_hd__decap_3
XFILLER_169_36 VGND VGND VPWR VPWR sky130_fd_sc_hd__decap_3
XFILLER_41_225 VGND VGND VPWR VPWR sky130_fd_sc_hd__decap_3
XFILLER_53_69 VGND VGND VPWR VPWR sky130_fd_sc_hd__decap_3
XFILLER_169_69 VGND VGND VPWR VPWR sky130_fd_sc_hd__decap_3
XFILLER_139_113 VGND VGND VPWR VPWR sky130_fd_sc_hd__decap_3
XTAP_TAPCELL_ROW_24_467 VGND VPWR sky130_fd_sc_hd__tapvpwrvgnd_1
XFILLER_139_157 VGND VGND VPWR VPWR sky130_fd_sc_hd__decap_3
XFILLER_154_116 VGND VGND VPWR VPWR sky130_fd_sc_hd__decap_3
XFILLER_5_137 VGND VGND VPWR VPWR sky130_fd_sc_hd__decap_3
XFILLER_147_190 VGND VGND VPWR VPWR sky130_fd_sc_hd__decap_3
XFILLER_78_44 VGND VGND VPWR VPWR sky130_fd_sc_hd__decap_3
XFILLER_76_100 VGND VGND VPWR VPWR sky130_fd_sc_hd__decap_3
XFILLER_78_77 VGND VGND VPWR VPWR sky130_fd_sc_hd__decap_3
XFILLER_78_88 VGND VGND VPWR VPWR sky130_fd_sc_hd__decap_3
XFILLER_134_83 VGND VGND VPWR VPWR sky130_fd_sc_hd__fill_1
XFILLER_94_32 VGND VGND VPWR VPWR sky130_fd_sc_hd__decap_3
XFILLER_91_125 VGND VGND VPWR VPWR sky130_fd_sc_hd__decap_3
XFILLER_94_76 VGND VGND VPWR VPWR sky130_fd_sc_hd__decap_3
XFILLER_27_81 VGND VGND VPWR VPWR sky130_fd_sc_hd__decap_3
XTAP_TAPCELL_ROW_47_559 VGND VPWR sky130_fd_sc_hd__tapvpwrvgnd_1
XFILLER_91_169 VGND VGND VPWR VPWR sky130_fd_sc_hd__decap_3
XFILLER_177_208 VGND VGND VPWR VPWR sky130_fd_sc_hd__decap_3
XTAP_TAPCELL_ROW_55_592 VGND VPWR sky130_fd_sc_hd__tapvpwrvgnd_1
X_0960_ net123 net268 VGND VGND VPWR VPWR Tile_X0Y0_OpenRAM_top.Inst_OpenRAM_top_ConfigMem.Inst_frame8_bit18.Q
+ sky130_fd_sc_hd__dlxtp_1
X_0891_ net129 net283 VGND VGND VPWR VPWR Tile_X0Y0_OpenRAM_top.Inst_OpenRAM_top_ConfigMem.Inst_frame6_bit23.Q
+ sky130_fd_sc_hd__dlxtp_1
XFILLER_153_160 VGND VGND VPWR VPWR sky130_fd_sc_hd__decap_3
XFILLER_99_225 VGND VGND VPWR VPWR sky130_fd_sc_hd__decap_3
XFILLER_175_90 VGND VGND VPWR VPWR sky130_fd_sc_hd__decap_3
X_1443_ Tile_X0Y0_OpenRAM_top.Inst_OpenRAM_top_switch_matrix.S2BEG5 VGND VGND VPWR
+ VPWR net603 sky130_fd_sc_hd__buf_4
XFILLER_4_41 VGND VGND VPWR VPWR sky130_fd_sc_hd__decap_3
XFILLER_4_192 VGND VGND VPWR VPWR sky130_fd_sc_hd__decap_3
XFILLER_4_74 VGND VGND VPWR VPWR sky130_fd_sc_hd__decap_3
XFILLER_4_85 VGND VGND VPWR VPWR sky130_fd_sc_hd__decap_3
X_1374_ Tile_X0Y0_OpenRAM_top.Inst_OpenRAM_top_switch_matrix.W6BEG8 VGND VGND VPWR
+ VPWR net536 sky130_fd_sc_hd__buf_1
XFILLER_67_166 VGND VGND VPWR VPWR sky130_fd_sc_hd__fill_2
X_0325_ net192 net184 net202 net262 Tile_X0Y1_OpenRAM_bot.Inst_OpenRAM_bot_ConfigMem.Inst_frame8_bit10.Q
+ Tile_X0Y1_OpenRAM_bot.Inst_OpenRAM_bot_ConfigMem.Inst_frame8_bit11.Q VGND VGND VPWR
+ VPWR Tile_X0Y0_OpenRAM_top.Inst_OpenRAM_top_switch_matrix.N2BEGb1 sky130_fd_sc_hd__mux4_1
X_0256_ Tile_X0Y1_OpenRAM_bot.Inst_OpenRAM_bot_ConfigMem.Inst_frame1_bit6.Q VGND VGND
+ VPWR VPWR _0029_ sky130_fd_sc_hd__inv_2
XFILLER_67_188 VGND VGND VPWR VPWR sky130_fd_sc_hd__decap_3
XTAP_TAPCELL_ROW_78_684 VGND VPWR sky130_fd_sc_hd__tapvpwrvgnd_1
XFILLER_82_125 VGND VGND VPWR VPWR sky130_fd_sc_hd__decap_3
XFILLER_82_147 VGND VGND VPWR VPWR sky130_fd_sc_hd__decap_3
XFILLER_23_225 VGND VGND VPWR VPWR sky130_fd_sc_hd__fill_1
XFILLER_139_39 VGND VGND VPWR VPWR sky130_fd_sc_hd__decap_3
XFILLER_136_116 VGND VGND VPWR VPWR sky130_fd_sc_hd__decap_3
XFILLER_151_108 VGND VGND VPWR VPWR sky130_fd_sc_hd__decap_3
XFILLER_155_49 VGND VGND VPWR VPWR sky130_fd_sc_hd__decap_3
XFILLER_144_171 VGND VGND VPWR VPWR sky130_fd_sc_hd__decap_3
XFILLER_2_118 VGND VGND VPWR VPWR sky130_fd_sc_hd__decap_3
XFILLER_3_9 VGND VGND VPWR VPWR sky130_fd_sc_hd__decap_3
XFILLER_171_15 VGND VGND VPWR VPWR sky130_fd_sc_hd__decap_3
XPHY_EDGE_ROW_21_Left_204 VGND VGND VPWR VPWR sky130_fd_sc_hd__decap_3
XFILLER_48_47 VGND VGND VPWR VPWR sky130_fd_sc_hd__decap_3
XFILLER_58_100 VGND VGND VPWR VPWR sky130_fd_sc_hd__fill_1
XFILLER_171_48 VGND VGND VPWR VPWR sky130_fd_sc_hd__decap_3
XFILLER_58_144 VGND VGND VPWR VPWR sky130_fd_sc_hd__decap_3
XFILLER_104_53 VGND VGND VPWR VPWR sky130_fd_sc_hd__decap_3
XFILLER_58_177 VGND VGND VPWR VPWR sky130_fd_sc_hd__decap_3
XFILLER_73_125 VGND VGND VPWR VPWR sky130_fd_sc_hd__decap_3
XFILLER_104_97 VGND VGND VPWR VPWR sky130_fd_sc_hd__decap_3
XFILLER_73_158 VGND VGND VPWR VPWR sky130_fd_sc_hd__decap_3
XFILLER_14_203 VGND VGND VPWR VPWR sky130_fd_sc_hd__decap_3
XFILLER_73_169 VGND VGND VPWR VPWR sky130_fd_sc_hd__decap_3
XFILLER_159_219 VGND VGND VPWR VPWR sky130_fd_sc_hd__decap_3
XFILLER_120_63 VGND VGND VPWR VPWR sky130_fd_sc_hd__decap_3
XPHY_EDGE_ROW_30_Left_213 VGND VGND VPWR VPWR sky130_fd_sc_hd__decap_3
XFILLER_80_23 VGND VGND VPWR VPWR sky130_fd_sc_hd__decap_3
XFILLER_120_85 VGND VGND VPWR VPWR sky130_fd_sc_hd__decap_3
XFILLER_127_105 VGND VGND VPWR VPWR sky130_fd_sc_hd__decap_3
XFILLER_127_116 VGND VGND VPWR VPWR sky130_fd_sc_hd__decap_3
XFILLER_13_72 VGND VGND VPWR VPWR sky130_fd_sc_hd__fill_1
XFILLER_129_72 VGND VGND VPWR VPWR sky130_fd_sc_hd__decap_3
XFILLER_89_21 VGND VGND VPWR VPWR sky130_fd_sc_hd__fill_2
XFILLER_135_193 VGND VGND VPWR VPWR sky130_fd_sc_hd__decap_3
XFILLER_89_87 VGND VGND VPWR VPWR sky130_fd_sc_hd__decap_3
XFILLER_145_82 VGND VGND VPWR VPWR sky130_fd_sc_hd__decap_3
XFILLER_1_184 VGND VGND VPWR VPWR sky130_fd_sc_hd__decap_3
XFILLER_49_122 VGND VGND VPWR VPWR sky130_fd_sc_hd__decap_3
XTAP_TAPCELL_ROW_182_1103 VGND VPWR sky130_fd_sc_hd__tapvpwrvgnd_1
XTAP_TAPCELL_ROW_119_847 VGND VPWR sky130_fd_sc_hd__tapvpwrvgnd_1
XFILLER_49_155 VGND VGND VPWR VPWR sky130_fd_sc_hd__decap_3
XFILLER_49_188 VGND VGND VPWR VPWR sky130_fd_sc_hd__decap_3
XFILLER_64_103 VGND VGND VPWR VPWR sky130_fd_sc_hd__decap_3
XTAP_TAPCELL_ROW_127_880 VGND VPWR sky130_fd_sc_hd__tapvpwrvgnd_1
X_1090_ net248 net307 VGND VGND VPWR VPWR Tile_X0Y1_OpenRAM_bot.Inst_OpenRAM_bot_ConfigMem.Inst_frame3_bit4.Q
+ sky130_fd_sc_hd__dlxtp_1
XFILLER_38_91 VGND VGND VPWR VPWR sky130_fd_sc_hd__decap_3
XFILLER_64_136 VGND VGND VPWR VPWR sky130_fd_sc_hd__decap_3
XFILLER_64_158 VGND VGND VPWR VPWR sky130_fd_sc_hd__decap_3
XFILLER_72_191 VGND VGND VPWR VPWR sky130_fd_sc_hd__decap_3
XFILLER_20_206 VGND VGND VPWR VPWR sky130_fd_sc_hd__decap_3
X_0943_ net139 net277 VGND VGND VPWR VPWR Tile_X0Y0_OpenRAM_top.Inst_OpenRAM_top_ConfigMem.Inst_frame7_bit3.Q
+ sky130_fd_sc_hd__dlxtp_1
XFILLER_118_105 VGND VGND VPWR VPWR sky130_fd_sc_hd__decap_3
XFILLER_173_211 VGND VGND VPWR VPWR sky130_fd_sc_hd__decap_3
X_0874_ net144 net293 VGND VGND VPWR VPWR Tile_X0Y0_OpenRAM_top.Inst_OpenRAM_top_ConfigMem.Inst_frame5_bit8.Q
+ sky130_fd_sc_hd__dlxtp_1
XFILLER_118_138 VGND VGND VPWR VPWR sky130_fd_sc_hd__fill_2
XFILLER_133_119 VGND VGND VPWR VPWR sky130_fd_sc_hd__decap_3
X_1426_ Tile_X0Y1_OpenRAM_bot.Inst_OpenRAM_bot_switch_matrix.S1BEG0 VGND VGND VPWR
+ VPWR net586 sky130_fd_sc_hd__clkbuf_2
XFILLER_87_228 VGND VGND VPWR VPWR sky130_fd_sc_hd__fill_2
X_1357_ Tile_X0Y0_OpenRAM_top.Inst_OpenRAM_top_switch_matrix.W2BEG7 VGND VGND VPWR
+ VPWR net517 sky130_fd_sc_hd__clkbuf_2
X_0308_ _0020_ Tile_X0Y1_OpenRAM_bot.Inst_OpenRAM_bot_ConfigMem.Inst_frame0_bit29.Q
+ _0070_ _0072_ VGND VGND VPWR VPWR _0073_ sky130_fd_sc_hd__a31o_1
X_1288_ net138 VGND VGND VPWR VPWR net441 sky130_fd_sc_hd__buf_1
XFILLER_55_136 VGND VGND VPWR VPWR sky130_fd_sc_hd__decap_3
X_0239_ Tile_X0Y0_OpenRAM_top.Inst_OpenRAM_top_ConfigMem.Inst_frame1_bit6.Q VGND VGND
+ VPWR VPWR _0012_ sky130_fd_sc_hd__inv_2
XFILLER_55_169 VGND VGND VPWR VPWR sky130_fd_sc_hd__decap_3
XFILLER_70_106 VGND VGND VPWR VPWR sky130_fd_sc_hd__decap_3
XFILLER_70_139 VGND VGND VPWR VPWR sky130_fd_sc_hd__fill_1
XFILLER_11_228 VGND VGND VPWR VPWR sky130_fd_sc_hd__decap_3
XFILLER_11_217 VGND VGND VPWR VPWR sky130_fd_sc_hd__decap_3
XFILLER_166_15 VGND VGND VPWR VPWR sky130_fd_sc_hd__decap_3
XFILLER_109_116 VGND VGND VPWR VPWR sky130_fd_sc_hd__decap_3
XFILLER_109_149 VGND VGND VPWR VPWR sky130_fd_sc_hd__decap_3
XFILLER_50_59 VGND VGND VPWR VPWR sky130_fd_sc_hd__decap_3
XTAP_TAPCELL_ROW_170_1051 VGND VPWR sky130_fd_sc_hd__tapvpwrvgnd_1
XFILLER_117_193 VGND VGND VPWR VPWR sky130_fd_sc_hd__decap_3
XFILLER_1_6 VGND VGND VPWR VPWR sky130_fd_sc_hd__decap_3
Xoutput581 net664 VGND VGND VPWR VPWR Tile_X0Y1_WW4BEG[4] sky130_fd_sc_hd__buf_2
Xoutput570 net653 VGND VGND VPWR VPWR Tile_X0Y1_W6BEG[9] sky130_fd_sc_hd__buf_2
XFILLER_59_46 VGND VGND VPWR VPWR sky130_fd_sc_hd__decap_3
XFILLER_59_57 VGND VGND VPWR VPWR sky130_fd_sc_hd__decap_3
XFILLER_132_174 VGND VGND VPWR VPWR sky130_fd_sc_hd__decap_3
Xfanout274 net277 VGND VGND VPWR VPWR net274 sky130_fd_sc_hd__clkbuf_2
Xfanout263 _0030_ VGND VGND VPWR VPWR net263 sky130_fd_sc_hd__clkbuf_4
Xclkbuf_1_1__f_Tile_X0Y1_UserCLK clknet_0_Tile_X0Y1_UserCLK VGND VGND VPWR VPWR clknet_1_1__leaf_Tile_X0Y1_UserCLK
+ sky130_fd_sc_hd__clkbuf_16
Xfanout285 net286 VGND VGND VPWR VPWR net285 sky130_fd_sc_hd__clkbuf_2
XFILLER_115_96 VGND VGND VPWR VPWR sky130_fd_sc_hd__decap_3
Xfanout296 net298 VGND VGND VPWR VPWR net296 sky130_fd_sc_hd__buf_2
XFILLER_75_34 VGND VGND VPWR VPWR sky130_fd_sc_hd__decap_3
XTAP_TAPCELL_ROW_156_997 VGND VPWR sky130_fd_sc_hd__tapvpwrvgnd_1
XFILLER_46_125 VGND VGND VPWR VPWR sky130_fd_sc_hd__fill_1
XFILLER_131_51 VGND VGND VPWR VPWR sky130_fd_sc_hd__decap_3
XFILLER_131_84 VGND VGND VPWR VPWR sky130_fd_sc_hd__decap_3
XFILLER_54_180 VGND VGND VPWR VPWR sky130_fd_sc_hd__decap_3
XFILLER_61_128 VGND VGND VPWR VPWR sky130_fd_sc_hd__fill_1
XFILLER_61_139 VGND VGND VPWR VPWR sky130_fd_sc_hd__decap_3
XFILLER_91_33 VGND VGND VPWR VPWR sky130_fd_sc_hd__decap_3
XFILLER_91_99 VGND VGND VPWR VPWR sky130_fd_sc_hd__decap_3
XFILLER_24_71 VGND VGND VPWR VPWR sky130_fd_sc_hd__fill_1
XTAP_TAPCELL_ROW_40_532 VGND VPWR sky130_fd_sc_hd__tapvpwrvgnd_1
XTAP_TAPCELL_ROW_80_690 VGND VPWR sky130_fd_sc_hd__tapvpwrvgnd_1
XFILLER_170_203 VGND VGND VPWR VPWR sky130_fd_sc_hd__decap_3
XFILLER_40_81 VGND VGND VPWR VPWR sky130_fd_sc_hd__decap_3
XFILLER_108_171 VGND VGND VPWR VPWR sky130_fd_sc_hd__decap_3
X_0590_ _0022_ Tile_X0Y1_OpenRAM_bot.Inst_OpenRAM_bot_ConfigMem.Inst_frame3_bit21.Q
+ _0030_ _0158_ VGND VGND VPWR VPWR net365 sky130_fd_sc_hd__a31o_1
XFILLER_123_152 VGND VGND VPWR VPWR sky130_fd_sc_hd__decap_3
XFILLER_123_196 VGND VGND VPWR VPWR sky130_fd_sc_hd__decap_3
XFILLER_49_90 VGND VGND VPWR VPWR sky130_fd_sc_hd__decap_3
X_1211_ net224 net270 VGND VGND VPWR VPWR Tile_X0Y1_OpenRAM_bot.Inst_OpenRAM_bot_ConfigMem.Inst_frame7_bit11.Q
+ sky130_fd_sc_hd__dlxtp_1
XFILLER_172_91 VGND VGND VPWR VPWR sky130_fd_sc_hd__decap_3
XFILLER_172_80 VGND VGND VPWR VPWR sky130_fd_sc_hd__decap_3
X_1142_ net229 net287 VGND VGND VPWR VPWR Tile_X0Y1_OpenRAM_bot.Inst_OpenRAM_bot_ConfigMem.Inst_frame5_bit16.Q
+ sky130_fd_sc_hd__dlxtp_1
XFILLER_37_169 VGND VGND VPWR VPWR sky130_fd_sc_hd__decap_3
X_1073_ net235 net305 VGND VGND VPWR VPWR Tile_X0Y1_OpenRAM_bot.Inst_OpenRAM_bot_ConfigMem.Inst_frame3_bit21.Q
+ sky130_fd_sc_hd__dlxtp_1
XTAP_TAPCELL_ROW_63_624 VGND VPWR sky130_fd_sc_hd__tapvpwrvgnd_1
XFILLER_60_150 VGND VGND VPWR VPWR sky130_fd_sc_hd__decap_3
XFILLER_60_183 VGND VGND VPWR VPWR sky130_fd_sc_hd__fill_1
X_0926_ net126 net275 VGND VGND VPWR VPWR Tile_X0Y0_OpenRAM_top.Inst_OpenRAM_top_ConfigMem.Inst_frame7_bit20.Q
+ sky130_fd_sc_hd__dlxtp_1
X_0857_ net131 net292 VGND VGND VPWR VPWR Tile_X0Y0_OpenRAM_top.Inst_OpenRAM_top_ConfigMem.Inst_frame5_bit25.Q
+ sky130_fd_sc_hd__dlxtp_1
XFILLER_20_29 VGND VGND VPWR VPWR sky130_fd_sc_hd__decap_3
X_0788_ net137 net309 VGND VGND VPWR VPWR Tile_X0Y0_OpenRAM_top.Inst_OpenRAM_top_ConfigMem.Inst_frame3_bit30.Q
+ sky130_fd_sc_hd__dlxtp_1
XFILLER_161_225 VGND VGND VPWR VPWR sky130_fd_sc_hd__decap_3
XFILLER_114_130 VGND VGND VPWR VPWR sky130_fd_sc_hd__decap_3
XFILLER_114_185 VGND VGND VPWR VPWR sky130_fd_sc_hd__decap_3
XPHY_EDGE_ROW_89_Right_89 VGND VGND VPWR VPWR sky130_fd_sc_hd__decap_3
X_1409_ net228 VGND VGND VPWR VPWR net560 sky130_fd_sc_hd__clkbuf_2
XFILLER_28_103 VGND VGND VPWR VPWR sky130_fd_sc_hd__decap_3
XTAP_TAPCELL_ROW_86_716 VGND VPWR sky130_fd_sc_hd__tapvpwrvgnd_1
XTAP_TAPCELL_ROW_161_1017 VGND VPWR sky130_fd_sc_hd__tapvpwrvgnd_1
XFILLER_45_26 VGND VGND VPWR VPWR sky130_fd_sc_hd__decap_3
XFILLER_36_180 VGND VGND VPWR VPWR sky130_fd_sc_hd__decap_3
XFILLER_43_128 VGND VGND VPWR VPWR sky130_fd_sc_hd__decap_3
XPHY_EDGE_ROW_98_Right_98 VGND VGND VPWR VPWR sky130_fd_sc_hd__decap_3
XFILLER_51_161 VGND VGND VPWR VPWR sky130_fd_sc_hd__decap_3
XFILLER_101_87 VGND VGND VPWR VPWR sky130_fd_sc_hd__decap_3
XFILLER_177_36 VGND VGND VPWR VPWR sky130_fd_sc_hd__decap_3
XFILLER_61_69 VGND VGND VPWR VPWR sky130_fd_sc_hd__decap_3
XFILLER_177_69 VGND VGND VPWR VPWR sky130_fd_sc_hd__decap_3
XFILLER_152_203 VGND VGND VPWR VPWR sky130_fd_sc_hd__fill_2
XFILLER_3_202 VGND VGND VPWR VPWR sky130_fd_sc_hd__decap_3
XFILLER_105_141 VGND VGND VPWR VPWR sky130_fd_sc_hd__fill_2
XFILLER_10_62 VGND VGND VPWR VPWR sky130_fd_sc_hd__decap_3
XFILLER_120_100 VGND VGND VPWR VPWR sky130_fd_sc_hd__decap_3
XFILLER_105_196 VGND VGND VPWR VPWR sky130_fd_sc_hd__decap_3
XPHY_EDGE_ROW_5_Left_188 VGND VGND VPWR VPWR sky130_fd_sc_hd__decap_3
XFILLER_66_209 VGND VGND VPWR VPWR sky130_fd_sc_hd__decap_3
XFILLER_120_166 VGND VGND VPWR VPWR sky130_fd_sc_hd__decap_3
XFILLER_142_94 VGND VGND VPWR VPWR sky130_fd_sc_hd__decap_3
XFILLER_19_169 VGND VGND VPWR VPWR sky130_fd_sc_hd__decap_3
XFILLER_19_93 VGND VGND VPWR VPWR sky130_fd_sc_hd__decap_3
XFILLER_34_139 VGND VGND VPWR VPWR sky130_fd_sc_hd__fill_1
XTAP_TAPCELL_ROW_112_820 VGND VPWR sky130_fd_sc_hd__tapvpwrvgnd_1
XFILLER_27_191 VGND VGND VPWR VPWR sky130_fd_sc_hd__decap_3
XFILLER_42_150 VGND VGND VPWR VPWR sky130_fd_sc_hd__decap_3
XFILLER_42_194 VGND VGND VPWR VPWR sky130_fd_sc_hd__fill_2
XTAP_TAPCELL_ROW_177_1079 VGND VPWR sky130_fd_sc_hd__tapvpwrvgnd_1
XFILLER_128_200 VGND VGND VPWR VPWR sky130_fd_sc_hd__decap_3
X_0711_ net116 net335 VGND VGND VPWR VPWR Tile_X0Y0_OpenRAM_top.Inst_OpenRAM_top_ConfigMem.Inst_frame0_bit11.Q
+ sky130_fd_sc_hd__dlxtp_1
XFILLER_167_91 VGND VGND VPWR VPWR sky130_fd_sc_hd__decap_3
XFILLER_143_203 VGND VGND VPWR VPWR sky130_fd_sc_hd__decap_3
XFILLER_143_225 VGND VGND VPWR VPWR sky130_fd_sc_hd__fill_1
X_0642_ Tile_X0Y1_OpenRAM_bot.Inst_OpenRAM_bot_switch_matrix.J_NS4_BEG14 net261 Tile_X0Y1_OpenRAM_bot.Inst_OpenRAM_bot_ConfigMem.Inst_frame8_bit30.Q
+ VGND VGND VPWR VPWR _0185_ sky130_fd_sc_hd__mux2_1
X_0573_ net9 net41 _0156_ net263 Tile_X0Y1_OpenRAM_bot.Inst_OpenRAM_bot_ConfigMem.Inst_frame4_bit14.Q
+ Tile_X0Y1_OpenRAM_bot.Inst_OpenRAM_bot_ConfigMem.Inst_frame4_bit15.Q VGND VGND VPWR
+ VPWR Tile_X0Y1_OpenRAM_bot.Inst_OpenRAM_bot_switch_matrix.WW4BEG15 sky130_fd_sc_hd__mux4_1
XFILLER_111_122 VGND VGND VPWR VPWR sky130_fd_sc_hd__fill_2
XTAP_TAPCELL_ROW_135_912 VGND VPWR sky130_fd_sc_hd__tapvpwrvgnd_1
XFILLER_65_220 VGND VGND VPWR VPWR sky130_fd_sc_hd__decap_3
X_1125_ net233 net296 VGND VGND VPWR VPWR Tile_X0Y1_OpenRAM_bot.Inst_OpenRAM_bot_ConfigMem.Inst_frame4_bit1.Q
+ sky130_fd_sc_hd__dlxtp_1
XFILLER_80_212 VGND VGND VPWR VPWR sky130_fd_sc_hd__fill_2
XFILLER_178_100 VGND VGND VPWR VPWR sky130_fd_sc_hd__decap_3
X_1056_ net250 net314 VGND VGND VPWR VPWR Tile_X0Y1_OpenRAM_bot.Inst_OpenRAM_bot_ConfigMem.Inst_frame2_bit6.Q
+ sky130_fd_sc_hd__dlxtp_1
XFILLER_178_133 VGND VGND VPWR VPWR sky130_fd_sc_hd__decap_3
XFILLER_33_150 VGND VGND VPWR VPWR sky130_fd_sc_hd__fill_1
XFILLER_40_109 VGND VGND VPWR VPWR sky130_fd_sc_hd__decap_3
XFILLER_178_144 VGND VGND VPWR VPWR sky130_fd_sc_hd__decap_3
XFILLER_178_177 VGND VGND VPWR VPWR sky130_fd_sc_hd__decap_3
XFILLER_147_28 VGND VGND VPWR VPWR sky130_fd_sc_hd__decap_3
XFILLER_134_203 VGND VGND VPWR VPWR sky130_fd_sc_hd__decap_3
X_0909_ net141 net282 VGND VGND VPWR VPWR Tile_X0Y0_OpenRAM_top.Inst_OpenRAM_top_ConfigMem.Inst_frame6_bit5.Q
+ sky130_fd_sc_hd__dlxtp_1
XFILLER_103_9 VGND VGND VPWR VPWR sky130_fd_sc_hd__decap_3
XFILLER_102_100 VGND VGND VPWR VPWR sky130_fd_sc_hd__fill_1
Xinput117 Tile_X0Y0_FrameData[12] VGND VGND VPWR VPWR net117 sky130_fd_sc_hd__buf_4
Xinput106 Tile_X0Y0_EE4END[2] VGND VGND VPWR VPWR net106 sky130_fd_sc_hd__buf_1
XFILLER_102_144 VGND VGND VPWR VPWR sky130_fd_sc_hd__decap_3
Xinput128 Tile_X0Y0_FrameData[22] VGND VGND VPWR VPWR net128 sky130_fd_sc_hd__clkbuf_4
Xinput139 Tile_X0Y0_FrameData[3] VGND VGND VPWR VPWR net139 sky130_fd_sc_hd__clkbuf_4
XFILLER_56_220 VGND VGND VPWR VPWR sky130_fd_sc_hd__decap_3
XFILLER_56_58 VGND VGND VPWR VPWR sky130_fd_sc_hd__decap_3
XFILLER_16_139 VGND VGND VPWR VPWR sky130_fd_sc_hd__fill_1
XFILLER_16_106 VGND VGND VPWR VPWR sky130_fd_sc_hd__decap_3
XFILLER_71_223 VGND VGND VPWR VPWR sky130_fd_sc_hd__fill_1
XTAP_TAPCELL_ROW_141_937 VGND VPWR sky130_fd_sc_hd__tapvpwrvgnd_1
XFILLER_112_53 VGND VGND VPWR VPWR sky130_fd_sc_hd__decap_3
XFILLER_72_24 VGND VGND VPWR VPWR sky130_fd_sc_hd__decap_3
XFILLER_169_122 VGND VGND VPWR VPWR sky130_fd_sc_hd__decap_3
XFILLER_169_111 VGND VGND VPWR VPWR sky130_fd_sc_hd__fill_1
XFILLER_112_97 VGND VGND VPWR VPWR sky130_fd_sc_hd__decap_3
XFILLER_24_150 VGND VGND VPWR VPWR sky130_fd_sc_hd__decap_3
XFILLER_31_109 VGND VGND VPWR VPWR sky130_fd_sc_hd__decap_3
XFILLER_72_35 VGND VGND VPWR VPWR sky130_fd_sc_hd__decap_3
XFILLER_72_68 VGND VGND VPWR VPWR sky130_fd_sc_hd__decap_3
XFILLER_24_194 VGND VGND VPWR VPWR sky130_fd_sc_hd__fill_2
XFILLER_169_199 VGND VGND VPWR VPWR sky130_fd_sc_hd__decap_3
XPHY_EDGE_ROW_117_Right_117 VGND VGND VPWR VPWR sky130_fd_sc_hd__decap_3
XFILLER_125_225 VGND VGND VPWR VPWR sky130_fd_sc_hd__fill_1
XFILLER_21_72 VGND VGND VPWR VPWR sky130_fd_sc_hd__decap_3
XFILLER_140_206 VGND VGND VPWR VPWR sky130_fd_sc_hd__decap_3
XFILLER_137_72 VGND VGND VPWR VPWR sky130_fd_sc_hd__fill_1
XFILLER_98_109 VGND VGND VPWR VPWR sky130_fd_sc_hd__decap_3
XFILLER_97_21 VGND VGND VPWR VPWR sky130_fd_sc_hd__decap_3
XFILLER_62_212 VGND VGND VPWR VPWR sky130_fd_sc_hd__fill_1
XFILLER_15_161 VGND VGND VPWR VPWR sky130_fd_sc_hd__decap_3
XFILLER_22_109 VGND VGND VPWR VPWR sky130_fd_sc_hd__decap_3
XFILLER_15_172 VGND VGND VPWR VPWR sky130_fd_sc_hd__fill_2
XFILLER_175_125 VGND VGND VPWR VPWR sky130_fd_sc_hd__decap_3
XFILLER_30_153 VGND VGND VPWR VPWR sky130_fd_sc_hd__decap_3
XFILLER_175_158 VGND VGND VPWR VPWR sky130_fd_sc_hd__decap_3
XFILLER_7_30 VGND VGND VPWR VPWR sky130_fd_sc_hd__decap_3
XFILLER_30_186 VGND VGND VPWR VPWR sky130_fd_sc_hd__decap_3
XFILLER_30_197 VGND VGND VPWR VPWR sky130_fd_sc_hd__decap_3
XFILLER_175_169 VGND VGND VPWR VPWR sky130_fd_sc_hd__decap_3
XFILLER_7_63 VGND VGND VPWR VPWR sky130_fd_sc_hd__decap_3
XFILLER_7_96 VGND VGND VPWR VPWR sky130_fd_sc_hd__decap_3
X_0625_ net189 Tile_X0Y1_OpenRAM_bot.Inst_OpenRAM_bot_ConfigMem.Inst_frame1_bit6.Q
+ Tile_X0Y1_OpenRAM_bot.Inst_OpenRAM_bot_ConfigMem.Inst_frame1_bit7.Q VGND VGND VPWR
+ VPWR _0171_ sky130_fd_sc_hd__o21ba_1
XFILLER_97_131 VGND VGND VPWR VPWR sky130_fd_sc_hd__decap_3
X_0556_ net254 net357 _0091_ net170 Tile_X0Y1_OpenRAM_bot.Inst_OpenRAM_bot_ConfigMem.Inst_frame1_bit24.Q
+ Tile_X0Y1_OpenRAM_bot.Inst_OpenRAM_bot_ConfigMem.Inst_frame1_bit25.Q VGND VGND VPWR
+ VPWR _0148_ sky130_fd_sc_hd__mux4_2
X_0487_ _0095_ net256 Tile_X0Y0_OpenRAM_top.Inst_OpenRAM_top_ConfigMem.Inst_frame7_bit15.Q
+ VGND VGND VPWR VPWR _0128_ sky130_fd_sc_hd__mux2_1
XFILLER_97_153 VGND VGND VPWR VPWR sky130_fd_sc_hd__decap_3
XFILLER_97_197 VGND VGND VPWR VPWR sky130_fd_sc_hd__fill_1
XFILLER_26_17 VGND VGND VPWR VPWR sky130_fd_sc_hd__decap_3
X_1108_ net231 net297 VGND VGND VPWR VPWR Tile_X0Y1_OpenRAM_bot.Inst_OpenRAM_bot_ConfigMem.Inst_frame4_bit18.Q
+ sky130_fd_sc_hd__dlxtp_1
X_1039_ net237 net313 VGND VGND VPWR VPWR Tile_X0Y1_OpenRAM_bot.Inst_OpenRAM_bot_ConfigMem.Inst_frame2_bit23.Q
+ sky130_fd_sc_hd__dlxtp_1
XFILLER_166_125 VGND VGND VPWR VPWR sky130_fd_sc_hd__decap_3
XFILLER_21_131 VGND VGND VPWR VPWR sky130_fd_sc_hd__decap_3
XFILLER_42_27 VGND VGND VPWR VPWR sky130_fd_sc_hd__fill_1
XFILLER_42_38 VGND VGND VPWR VPWR sky130_fd_sc_hd__decap_3
XFILLER_166_147 VGND VGND VPWR VPWR sky130_fd_sc_hd__decap_3
XFILLER_21_164 VGND VGND VPWR VPWR sky130_fd_sc_hd__decap_3
XFILLER_107_203 VGND VGND VPWR VPWR sky130_fd_sc_hd__decap_3
XFILLER_181_128 VGND VGND VPWR VPWR sky130_fd_sc_hd__decap_3
XFILLER_174_180 VGND VGND VPWR VPWR sky130_fd_sc_hd__decap_3
XFILLER_107_225 VGND VGND VPWR VPWR sky130_fd_sc_hd__fill_1
XPHY_EDGE_ROW_86_Left_269 VGND VGND VPWR VPWR sky130_fd_sc_hd__decap_3
XFILLER_174_15 VGND VGND VPWR VPWR sky130_fd_sc_hd__decap_3
XFILLER_101_6 VGND VGND VPWR VPWR sky130_fd_sc_hd__decap_3
XFILLER_174_59 VGND VGND VPWR VPWR sky130_fd_sc_hd__decap_3
XFILLER_122_228 VGND VGND VPWR VPWR sky130_fd_sc_hd__fill_2
XFILLER_107_20 VGND VGND VPWR VPWR sky130_fd_sc_hd__fill_2
XFILLER_107_75 VGND VGND VPWR VPWR sky130_fd_sc_hd__decap_3
XFILLER_67_57 VGND VGND VPWR VPWR sky130_fd_sc_hd__decap_3
XFILLER_88_153 VGND VGND VPWR VPWR sky130_fd_sc_hd__decap_3
XPHY_EDGE_ROW_95_Left_278 VGND VGND VPWR VPWR sky130_fd_sc_hd__decap_3
XFILLER_83_12 VGND VGND VPWR VPWR sky130_fd_sc_hd__decap_3
XFILLER_123_96 VGND VGND VPWR VPWR sky130_fd_sc_hd__decap_3
XFILLER_83_45 VGND VGND VPWR VPWR sky130_fd_sc_hd__decap_3
XFILLER_83_78 VGND VGND VPWR VPWR sky130_fd_sc_hd__decap_3
XFILLER_16_50 VGND VGND VPWR VPWR sky130_fd_sc_hd__decap_3
XFILLER_16_94 VGND VGND VPWR VPWR sky130_fd_sc_hd__decap_3
XFILLER_16_83 VGND VGND VPWR VPWR sky130_fd_sc_hd__fill_1
XFILLER_8_124 VGND VGND VPWR VPWR sky130_fd_sc_hd__decap_3
XFILLER_172_106 VGND VGND VPWR VPWR sky130_fd_sc_hd__decap_3
XFILLER_157_169 VGND VGND VPWR VPWR sky130_fd_sc_hd__decap_3
XFILLER_8_168 VGND VGND VPWR VPWR sky130_fd_sc_hd__decap_3
XFILLER_32_82 VGND VGND VPWR VPWR sky130_fd_sc_hd__fill_2
XFILLER_172_139 VGND VGND VPWR VPWR sky130_fd_sc_hd__fill_1
XFILLER_148_82 VGND VGND VPWR VPWR sky130_fd_sc_hd__fill_2
XFILLER_66_9 VGND VGND VPWR VPWR sky130_fd_sc_hd__decap_3
XFILLER_180_172 VGND VGND VPWR VPWR sky130_fd_sc_hd__decap_3
XFILLER_113_228 VGND VGND VPWR VPWR sky130_fd_sc_hd__fill_2
XFILLER_113_217 VGND VGND VPWR VPWR sky130_fd_sc_hd__decap_3
XFILLER_180_194 VGND VGND VPWR VPWR sky130_fd_sc_hd__fill_2
XFILLER_164_70 VGND VGND VPWR VPWR sky130_fd_sc_hd__fill_2
X_1390_ Tile_X0Y0_OpenRAM_top.Inst_OpenRAM_top_switch_matrix.WW4BEG12 VGND VGND VPWR
+ VPWR net541 sky130_fd_sc_hd__clkbuf_2
X_0410_ net24 net56 _0096_ net257 Tile_X0Y0_OpenRAM_top.Inst_OpenRAM_top_ConfigMem.Inst_frame4_bit22.Q
+ Tile_X0Y0_OpenRAM_top.Inst_OpenRAM_top_ConfigMem.Inst_frame4_bit23.Q VGND VGND VPWR
+ VPWR Tile_X0Y0_OpenRAM_top.Inst_OpenRAM_top_switch_matrix.WW4BEG13 sky130_fd_sc_hd__mux4_1
XFILLER_79_153 VGND VGND VPWR VPWR sky130_fd_sc_hd__decap_3
XFILLER_79_175 VGND VGND VPWR VPWR sky130_fd_sc_hd__decap_3
X_0341_ Tile_X0Y0_OpenRAM_top.Inst_OpenRAM_top_switch_matrix.N2BEGb4 net162 net353
+ net154 Tile_X0Y0_OpenRAM_top.Inst_OpenRAM_top_ConfigMem.Inst_frame0_bit17.Q Tile_X0Y0_OpenRAM_top.Inst_OpenRAM_top_ConfigMem.Inst_frame0_bit16.Q
+ VGND VGND VPWR VPWR Tile_X0Y0_OpenRAM_top.Inst_OpenRAM_top_switch_matrix.J_NS2_BEG4
+ sky130_fd_sc_hd__mux4_2
XFILLER_94_112 VGND VGND VPWR VPWR sky130_fd_sc_hd__decap_3
X_0272_ Tile_X0Y1_OpenRAM_bot.Inst_OpenRAM_bot_ConfigMem.Inst_frame3_bit10.Q _0041_
+ Tile_X0Y1_OpenRAM_bot.Inst_OpenRAM_bot_ConfigMem.Inst_frame3_bit9.Q VGND VGND VPWR
+ VPWR _0042_ sky130_fd_sc_hd__and3b_1
XFILLER_180_91 VGND VGND VPWR VPWR sky130_fd_sc_hd__decap_3
XFILLER_57_90 VGND VGND VPWR VPWR sky130_fd_sc_hd__decap_3
XTAP_TAPCELL_ROW_18_443 VGND VPWR sky130_fd_sc_hd__tapvpwrvgnd_1
XFILLER_148_103 VGND VGND VPWR VPWR sky130_fd_sc_hd__decap_3
XFILLER_148_136 VGND VGND VPWR VPWR sky130_fd_sc_hd__decap_3
XFILLER_163_106 VGND VGND VPWR VPWR sky130_fd_sc_hd__decap_3
XFILLER_7_190 VGND VGND VPWR VPWR sky130_fd_sc_hd__decap_3
XFILLER_171_172 VGND VGND VPWR VPWR sky130_fd_sc_hd__decap_3
XFILLER_171_161 VGND VGND VPWR VPWR sky130_fd_sc_hd__decap_3
XFILLER_104_206 VGND VGND VPWR VPWR sky130_fd_sc_hd__decap_3
XFILLER_144_29 VGND VGND VPWR VPWR sky130_fd_sc_hd__fill_1
X_0608_ net206 net220 net204 _0148_ Tile_X0Y1_OpenRAM_bot.Inst_OpenRAM_bot_ConfigMem.Inst_frame2_bit12.Q
+ Tile_X0Y1_OpenRAM_bot.Inst_OpenRAM_bot_ConfigMem.Inst_frame2_bit13.Q VGND VGND VPWR
+ VPWR net415 sky130_fd_sc_hd__mux4_2
X_0539_ net33 net65 net262 _0086_ Tile_X0Y1_OpenRAM_bot.Inst_OpenRAM_bot_ConfigMem.Inst_frame5_bit2.Q
+ Tile_X0Y1_OpenRAM_bot.Inst_OpenRAM_bot_ConfigMem.Inst_frame5_bit3.Q VGND VGND VPWR
+ VPWR Tile_X0Y1_OpenRAM_bot.Inst_OpenRAM_bot_switch_matrix.W2BEGb1 sky130_fd_sc_hd__mux4_1
XFILLER_85_134 VGND VGND VPWR VPWR sky130_fd_sc_hd__decap_3
XFILLER_37_27 VGND VGND VPWR VPWR sky130_fd_sc_hd__decap_3
XFILLER_85_167 VGND VGND VPWR VPWR sky130_fd_sc_hd__fill_1
XFILLER_85_178 VGND VGND VPWR VPWR sky130_fd_sc_hd__decap_3
XTAP_TAPCELL_ROW_1_377 VGND VPWR sky130_fd_sc_hd__tapvpwrvgnd_1
XFILLER_53_15 VGND VGND VPWR VPWR sky130_fd_sc_hd__decap_3
XFILLER_169_15 VGND VGND VPWR VPWR sky130_fd_sc_hd__decap_3
XFILLER_156_7 VGND VGND VPWR VPWR sky130_fd_sc_hd__fill_1
XFILLER_169_48 VGND VGND VPWR VPWR sky130_fd_sc_hd__decap_3
XFILLER_139_103 VGND VGND VPWR VPWR sky130_fd_sc_hd__decap_3
XTAP_TAPCELL_ROW_24_468 VGND VPWR sky130_fd_sc_hd__tapvpwrvgnd_1
XFILLER_139_169 VGND VGND VPWR VPWR sky130_fd_sc_hd__fill_2
XFILLER_154_128 VGND VGND VPWR VPWR sky130_fd_sc_hd__decap_3
XFILLER_5_116 VGND VGND VPWR VPWR sky130_fd_sc_hd__decap_3
XFILLER_5_105 VGND VGND VPWR VPWR sky130_fd_sc_hd__decap_3
XFILLER_118_41 VGND VGND VPWR VPWR sky130_fd_sc_hd__decap_3
XFILLER_5_149 VGND VGND VPWR VPWR sky130_fd_sc_hd__decap_3
XFILLER_78_12 VGND VGND VPWR VPWR sky130_fd_sc_hd__decap_3
XFILLER_118_85 VGND VGND VPWR VPWR sky130_fd_sc_hd__fill_2
XFILLER_78_56 VGND VGND VPWR VPWR sky130_fd_sc_hd__decap_3
XFILLER_110_209 VGND VGND VPWR VPWR sky130_fd_sc_hd__decap_3
XFILLER_76_112 VGND VGND VPWR VPWR sky130_fd_sc_hd__decap_3
XFILLER_134_95 VGND VGND VPWR VPWR sky130_fd_sc_hd__decap_3
XFILLER_76_178 VGND VGND VPWR VPWR sky130_fd_sc_hd__decap_3
XFILLER_27_60 VGND VGND VPWR VPWR sky130_fd_sc_hd__decap_3
XFILLER_91_148 VGND VGND VPWR VPWR sky130_fd_sc_hd__decap_3
XFILLER_94_88 VGND VGND VPWR VPWR sky130_fd_sc_hd__decap_3
XFILLER_150_83 VGND VGND VPWR VPWR sky130_fd_sc_hd__fill_1
XFILLER_150_50 VGND VGND VPWR VPWR sky130_fd_sc_hd__decap_3
XFILLER_27_93 VGND VGND VPWR VPWR sky130_fd_sc_hd__decap_3
XFILLER_32_215 VGND VGND VPWR VPWR sky130_fd_sc_hd__decap_3
XTAP_TAPCELL_ROW_55_593 VGND VPWR sky130_fd_sc_hd__tapvpwrvgnd_1
X_0890_ net130 net282 VGND VGND VPWR VPWR Tile_X0Y0_OpenRAM_top.Inst_OpenRAM_top_ConfigMem.Inst_frame6_bit24.Q
+ sky130_fd_sc_hd__dlxtp_1
XFILLER_43_81 VGND VGND VPWR VPWR sky130_fd_sc_hd__decap_3
XFILLER_138_180 VGND VGND VPWR VPWR sky130_fd_sc_hd__decap_3
XFILLER_153_172 VGND VGND VPWR VPWR sky130_fd_sc_hd__decap_3
X_1442_ Tile_X0Y0_OpenRAM_top.Inst_OpenRAM_top_switch_matrix.S2BEG4 VGND VGND VPWR
+ VPWR net602 sky130_fd_sc_hd__buf_6
XFILLER_4_171 VGND VGND VPWR VPWR sky130_fd_sc_hd__decap_3
XFILLER_4_53 VGND VGND VPWR VPWR sky130_fd_sc_hd__decap_3
X_1373_ Tile_X0Y0_OpenRAM_top.Inst_OpenRAM_top_switch_matrix.W6BEG7 VGND VGND VPWR
+ VPWR net535 sky130_fd_sc_hd__clkbuf_2
XFILLER_4_97 VGND VGND VPWR VPWR sky130_fd_sc_hd__decap_3
X_0324_ net350 net342 Tile_X0Y0_OpenRAM_top.Inst_OpenRAM_top_switch_matrix.S2BEG1
+ net159 Tile_X0Y1_OpenRAM_bot.Inst_OpenRAM_bot_ConfigMem.Inst_frame0_bit10.Q Tile_X0Y1_OpenRAM_bot.Inst_OpenRAM_bot_ConfigMem.Inst_frame0_bit11.Q
+ VGND VGND VPWR VPWR _0081_ sky130_fd_sc_hd__mux4_1
X_0255_ Tile_X0Y1_OpenRAM_bot.Inst_OpenRAM_bot_ConfigMem.Inst_frame1_bit4.Q VGND VGND
+ VPWR VPWR _0028_ sky130_fd_sc_hd__inv_2
XTAP_TAPCELL_ROW_78_685 VGND VPWR sky130_fd_sc_hd__tapvpwrvgnd_1
XFILLER_82_104 VGND VGND VPWR VPWR sky130_fd_sc_hd__decap_3
XFILLER_82_137 VGND VGND VPWR VPWR sky130_fd_sc_hd__decap_3
XFILLER_168_209 VGND VGND VPWR VPWR sky130_fd_sc_hd__decap_3
XFILLER_23_215 VGND VGND VPWR VPWR sky130_fd_sc_hd__decap_3
XFILLER_90_181 VGND VGND VPWR VPWR sky130_fd_sc_hd__decap_3
XTAP_TAPCELL_ROW_157_1000 VGND VPWR sky130_fd_sc_hd__tapvpwrvgnd_1
XFILLER_136_128 VGND VGND VPWR VPWR sky130_fd_sc_hd__decap_3
XFILLER_144_150 VGND VGND VPWR VPWR sky130_fd_sc_hd__decap_3
XFILLER_144_183 VGND VGND VPWR VPWR sky130_fd_sc_hd__decap_3
XFILLER_48_15 VGND VGND VPWR VPWR sky130_fd_sc_hd__decap_3
XFILLER_171_27 VGND VGND VPWR VPWR sky130_fd_sc_hd__decap_3
XTAP_TAPCELL_ROW_164_1026 VGND VPWR sky130_fd_sc_hd__tapvpwrvgnd_1
XFILLER_104_21 VGND VGND VPWR VPWR sky130_fd_sc_hd__decap_3
XFILLER_48_59 VGND VGND VPWR VPWR sky130_fd_sc_hd__decap_3
XFILLER_58_134 VGND VGND VPWR VPWR sky130_fd_sc_hd__decap_3
XFILLER_58_156 VGND VGND VPWR VPWR sky130_fd_sc_hd__decap_3
XFILLER_104_32 VGND VGND VPWR VPWR sky130_fd_sc_hd__decap_3
XFILLER_58_189 VGND VGND VPWR VPWR sky130_fd_sc_hd__decap_3
XFILLER_73_104 VGND VGND VPWR VPWR sky130_fd_sc_hd__decap_3
XFILLER_104_65 VGND VGND VPWR VPWR sky130_fd_sc_hd__decap_3
XFILLER_73_137 VGND VGND VPWR VPWR sky130_fd_sc_hd__decap_3
XPHY_EDGE_ROW_169_Left_352 VGND VGND VPWR VPWR sky130_fd_sc_hd__decap_3
XFILLER_14_215 VGND VGND VPWR VPWR sky130_fd_sc_hd__decap_3
XFILLER_147_3 VGND VGND VPWR VPWR sky130_fd_sc_hd__fill_1
XFILLER_167_220 VGND VGND VPWR VPWR sky130_fd_sc_hd__decap_3
XFILLER_13_51 VGND VGND VPWR VPWR sky130_fd_sc_hd__decap_3
XFILLER_129_51 VGND VGND VPWR VPWR sky130_fd_sc_hd__decap_3
XFILLER_127_139 VGND VGND VPWR VPWR sky130_fd_sc_hd__decap_3
XPHY_EDGE_ROW_178_Left_361 VGND VGND VPWR VPWR sky130_fd_sc_hd__decap_3
XFILLER_129_84 VGND VGND VPWR VPWR sky130_fd_sc_hd__decap_3
XFILLER_135_150 VGND VGND VPWR VPWR sky130_fd_sc_hd__decap_3
XFILLER_150_131 VGND VGND VPWR VPWR sky130_fd_sc_hd__decap_3
XFILLER_89_99 VGND VGND VPWR VPWR sky130_fd_sc_hd__decap_3
XFILLER_150_153 VGND VGND VPWR VPWR sky130_fd_sc_hd__decap_3
XFILLER_150_197 VGND VGND VPWR VPWR sky130_fd_sc_hd__decap_3
XFILLER_150_186 VGND VGND VPWR VPWR sky130_fd_sc_hd__decap_3
XTAP_TAPCELL_ROW_182_1104 VGND VPWR sky130_fd_sc_hd__tapvpwrvgnd_1
XTAP_TAPCELL_ROW_119_848 VGND VPWR sky130_fd_sc_hd__tapvpwrvgnd_1
XFILLER_1_196 VGND VGND VPWR VPWR sky130_fd_sc_hd__decap_3
XFILLER_49_134 VGND VGND VPWR VPWR sky130_fd_sc_hd__decap_3
XFILLER_38_81 VGND VGND VPWR VPWR sky130_fd_sc_hd__decap_3
XFILLER_49_167 VGND VGND VPWR VPWR sky130_fd_sc_hd__fill_1
XFILLER_49_178 VGND VGND VPWR VPWR sky130_fd_sc_hd__decap_3
XFILLER_64_115 VGND VGND VPWR VPWR sky130_fd_sc_hd__decap_3
XFILLER_161_82 VGND VGND VPWR VPWR sky130_fd_sc_hd__decap_3
XFILLER_161_60 VGND VGND VPWR VPWR sky130_fd_sc_hd__decap_3
XTAP_TAPCELL_ROW_127_881 VGND VPWR sky130_fd_sc_hd__tapvpwrvgnd_1
XFILLER_161_93 VGND VGND VPWR VPWR sky130_fd_sc_hd__decap_3
XFILLER_20_218 VGND VGND VPWR VPWR sky130_fd_sc_hd__decap_3
X_0942_ net140 net276 VGND VGND VPWR VPWR Tile_X0Y0_OpenRAM_top.Inst_OpenRAM_top_ConfigMem.Inst_frame7_bit4.Q
+ sky130_fd_sc_hd__dlxtp_1
XFILLER_173_223 VGND VGND VPWR VPWR sky130_fd_sc_hd__fill_1
X_0873_ net145 net293 VGND VGND VPWR VPWR Tile_X0Y0_OpenRAM_top.Inst_OpenRAM_top_ConfigMem.Inst_frame5_bit9.Q
+ sky130_fd_sc_hd__dlxtp_1
XFILLER_118_117 VGND VGND VPWR VPWR sky130_fd_sc_hd__decap_3
XFILLER_126_183 VGND VGND VPWR VPWR sky130_fd_sc_hd__decap_3
XFILLER_141_142 VGND VGND VPWR VPWR sky130_fd_sc_hd__decap_3
X_1425_ net246 VGND VGND VPWR VPWR net578 sky130_fd_sc_hd__buf_6
X_1356_ Tile_X0Y0_OpenRAM_top.Inst_OpenRAM_top_switch_matrix.W2BEG6 VGND VGND VPWR
+ VPWR net516 sky130_fd_sc_hd__buf_1
XFILLER_141_19 VGND VGND VPWR VPWR sky130_fd_sc_hd__decap_3
XFILLER_18_29 VGND VGND VPWR VPWR sky130_fd_sc_hd__decap_3
XFILLER_18_18 VGND VGND VPWR VPWR sky130_fd_sc_hd__decap_3
X_0307_ net198 _0020_ _0071_ VGND VGND VPWR VPWR _0072_ sky130_fd_sc_hd__o21a_1
X_1287_ net137 VGND VGND VPWR VPWR net440 sky130_fd_sc_hd__buf_1
XFILLER_55_148 VGND VGND VPWR VPWR sky130_fd_sc_hd__decap_3
X_0238_ Tile_X0Y0_OpenRAM_top.Inst_OpenRAM_top_ConfigMem.Inst_frame1_bit4.Q VGND VGND
+ VPWR VPWR _0011_ sky130_fd_sc_hd__inv_2
XFILLER_63_181 VGND VGND VPWR VPWR sky130_fd_sc_hd__decap_3
XFILLER_164_212 VGND VGND VPWR VPWR sky130_fd_sc_hd__decap_3
XFILLER_50_38 VGND VGND VPWR VPWR sky130_fd_sc_hd__decap_3
XFILLER_166_38 VGND VGND VPWR VPWR sky130_fd_sc_hd__decap_3
XFILLER_166_27 VGND VGND VPWR VPWR sky130_fd_sc_hd__fill_1
XFILLER_117_161 VGND VGND VPWR VPWR sky130_fd_sc_hd__decap_3
XTAP_TAPCELL_ROW_170_1052 VGND VPWR sky130_fd_sc_hd__tapvpwrvgnd_1
XFILLER_117_172 VGND VGND VPWR VPWR sky130_fd_sc_hd__decap_3
XFILLER_182_15 VGND VGND VPWR VPWR sky130_fd_sc_hd__fill_1
XFILLER_132_153 VGND VGND VPWR VPWR sky130_fd_sc_hd__decap_3
XFILLER_132_131 VGND VGND VPWR VPWR sky130_fd_sc_hd__decap_3
Xoutput571 net654 VGND VGND VPWR VPWR Tile_X0Y1_WW4BEG[0] sky130_fd_sc_hd__buf_2
Xoutput560 net643 VGND VGND VPWR VPWR Tile_X0Y1_W6BEG[10] sky130_fd_sc_hd__buf_2
XFILLER_132_197 VGND VGND VPWR VPWR sky130_fd_sc_hd__decap_3
XFILLER_132_186 VGND VGND VPWR VPWR sky130_fd_sc_hd__decap_3
Xoutput582 net665 VGND VGND VPWR VPWR Tile_X0Y1_WW4BEG[5] sky130_fd_sc_hd__buf_2
XFILLER_59_69 VGND VGND VPWR VPWR sky130_fd_sc_hd__fill_2
XFILLER_115_42 VGND VGND VPWR VPWR sky130_fd_sc_hd__decap_3
Xfanout264 net265 VGND VGND VPWR VPWR net264 sky130_fd_sc_hd__buf_2
Xfanout286 Tile_X0Y1_FrameStrobe[6] VGND VGND VPWR VPWR net286 sky130_fd_sc_hd__buf_2
Xfanout275 net277 VGND VGND VPWR VPWR net275 sky130_fd_sc_hd__buf_2
XFILLER_115_75 VGND VGND VPWR VPWR sky130_fd_sc_hd__decap_3
Xfanout297 net298 VGND VGND VPWR VPWR net297 sky130_fd_sc_hd__clkbuf_2
XFILLER_46_104 VGND VGND VPWR VPWR sky130_fd_sc_hd__decap_3
XTAP_TAPCELL_ROW_57_600 VGND VPWR sky130_fd_sc_hd__tapvpwrvgnd_1
XFILLER_75_57 VGND VGND VPWR VPWR sky130_fd_sc_hd__fill_1
XFILLER_75_79 VGND VGND VPWR VPWR sky130_fd_sc_hd__decap_3
XFILLER_131_30 VGND VGND VPWR VPWR sky130_fd_sc_hd__decap_3
XFILLER_46_159 VGND VGND VPWR VPWR sky130_fd_sc_hd__decap_3
XFILLER_91_12 VGND VGND VPWR VPWR sky130_fd_sc_hd__decap_3
XFILLER_131_96 VGND VGND VPWR VPWR sky130_fd_sc_hd__decap_3
XFILLER_54_192 VGND VGND VPWR VPWR sky130_fd_sc_hd__decap_3
XTAP_TAPCELL_ROW_72_658 VGND VPWR sky130_fd_sc_hd__tapvpwrvgnd_1
XFILLER_91_45 VGND VGND VPWR VPWR sky130_fd_sc_hd__fill_1
XFILLER_91_78 VGND VGND VPWR VPWR sky130_fd_sc_hd__decap_3
XTAP_TAPCELL_ROW_40_533 VGND VPWR sky130_fd_sc_hd__tapvpwrvgnd_1
XTAP_TAPCELL_ROW_80_691 VGND VPWR sky130_fd_sc_hd__tapvpwrvgnd_1
XFILLER_6_200 VGND VGND VPWR VPWR sky130_fd_sc_hd__decap_3
XFILLER_170_215 VGND VGND VPWR VPWR sky130_fd_sc_hd__decap_3
XFILLER_108_150 VGND VGND VPWR VPWR sky130_fd_sc_hd__decap_3
XFILLER_108_183 VGND VGND VPWR VPWR sky130_fd_sc_hd__decap_3
XFILLER_156_82 VGND VGND VPWR VPWR sky130_fd_sc_hd__fill_2
XFILLER_123_131 VGND VGND VPWR VPWR sky130_fd_sc_hd__decap_3
XFILLER_123_164 VGND VGND VPWR VPWR sky130_fd_sc_hd__decap_3
XFILLER_69_218 VGND VGND VPWR VPWR sky130_fd_sc_hd__fill_2
X_1210_ net225 net270 VGND VGND VPWR VPWR Tile_X0Y1_OpenRAM_bot.Inst_OpenRAM_bot_ConfigMem.Inst_frame7_bit12.Q
+ sky130_fd_sc_hd__dlxtp_1
XFILLER_1_21 VGND VGND VPWR VPWR sky130_fd_sc_hd__decap_3
X_1141_ net230 net287 VGND VGND VPWR VPWR Tile_X0Y1_OpenRAM_bot.Inst_OpenRAM_bot_ConfigMem.Inst_frame5_bit17.Q
+ sky130_fd_sc_hd__dlxtp_1
XFILLER_37_126 VGND VGND VPWR VPWR sky130_fd_sc_hd__decap_3
XFILLER_92_221 VGND VGND VPWR VPWR sky130_fd_sc_hd__decap_3
XFILLER_1_87 VGND VGND VPWR VPWR sky130_fd_sc_hd__decap_3
X_1072_ net236 net304 VGND VGND VPWR VPWR Tile_X0Y1_OpenRAM_bot.Inst_OpenRAM_bot_ConfigMem.Inst_frame3_bit22.Q
+ sky130_fd_sc_hd__dlxtp_1
XTAP_TAPCELL_ROW_63_625 VGND VPWR sky130_fd_sc_hd__tapvpwrvgnd_1
XFILLER_65_90 VGND VGND VPWR VPWR sky130_fd_sc_hd__decap_3
XFILLER_146_212 VGND VGND VPWR VPWR sky130_fd_sc_hd__fill_1
X_0925_ net127 net275 VGND VGND VPWR VPWR Tile_X0Y0_OpenRAM_top.Inst_OpenRAM_top_ConfigMem.Inst_frame7_bit21.Q
+ sky130_fd_sc_hd__dlxtp_1
XFILLER_106_109 VGND VGND VPWR VPWR sky130_fd_sc_hd__decap_3
X_0856_ net132 net292 VGND VGND VPWR VPWR Tile_X0Y0_OpenRAM_top.Inst_OpenRAM_top_ConfigMem.Inst_frame5_bit26.Q
+ sky130_fd_sc_hd__dlxtp_1
X_0787_ net138 net311 VGND VGND VPWR VPWR Tile_X0Y0_OpenRAM_top.Inst_OpenRAM_top_ConfigMem.Inst_frame3_bit31.Q
+ sky130_fd_sc_hd__dlxtp_1
XFILLER_29_39 VGND VGND VPWR VPWR sky130_fd_sc_hd__decap_3
X_1408_ net227 VGND VGND VPWR VPWR net559 sky130_fd_sc_hd__buf_4
XTAP_TAPCELL_ROW_86_717 VGND VPWR sky130_fd_sc_hd__tapvpwrvgnd_1
XFILLER_28_115 VGND VGND VPWR VPWR sky130_fd_sc_hd__decap_3
XFILLER_28_137 VGND VGND VPWR VPWR sky130_fd_sc_hd__decap_3
X_1339_ Tile_X0Y0_OpenRAM_top.N4BEG_outbuf_10.A VGND VGND VPWR VPWR net490 sky130_fd_sc_hd__buf_4
XFILLER_83_221 VGND VGND VPWR VPWR sky130_fd_sc_hd__decap_3
XFILLER_45_38 VGND VGND VPWR VPWR sky130_fd_sc_hd__decap_3
XFILLER_101_22 VGND VGND VPWR VPWR sky130_fd_sc_hd__decap_3
XFILLER_36_192 VGND VGND VPWR VPWR sky130_fd_sc_hd__decap_3
XTAP_TAPCELL_ROW_121_854 VGND VPWR sky130_fd_sc_hd__tapvpwrvgnd_1
XFILLER_101_55 VGND VGND VPWR VPWR sky130_fd_sc_hd__fill_1
XFILLER_177_15 VGND VGND VPWR VPWR sky130_fd_sc_hd__decap_3
XFILLER_177_48 VGND VGND VPWR VPWR sky130_fd_sc_hd__decap_3
XFILLER_137_223 VGND VGND VPWR VPWR sky130_fd_sc_hd__fill_1
XFILLER_152_226 VGND VGND VPWR VPWR sky130_fd_sc_hd__decap_3
XFILLER_3_214 VGND VGND VPWR VPWR sky130_fd_sc_hd__decap_3
XFILLER_3_225 VGND VGND VPWR VPWR sky130_fd_sc_hd__decap_3
XFILLER_105_120 VGND VGND VPWR VPWR sky130_fd_sc_hd__decap_3
XFILLER_10_41 VGND VGND VPWR VPWR sky130_fd_sc_hd__decap_3
XFILLER_126_41 VGND VGND VPWR VPWR sky130_fd_sc_hd__decap_3
XFILLER_105_164 VGND VGND VPWR VPWR sky130_fd_sc_hd__decap_3
XFILLER_10_85 VGND VGND VPWR VPWR sky130_fd_sc_hd__decap_3
XFILLER_10_74 VGND VGND VPWR VPWR sky130_fd_sc_hd__decap_3
XFILLER_86_12 VGND VGND VPWR VPWR sky130_fd_sc_hd__decap_3
Xoutput390 net473 VGND VGND VPWR VPWR Tile_X0Y0_N2BEG[0] sky130_fd_sc_hd__buf_2
XFILLER_86_67 VGND VGND VPWR VPWR sky130_fd_sc_hd__decap_3
XFILLER_19_137 VGND VGND VPWR VPWR sky130_fd_sc_hd__decap_3
XFILLER_74_221 VGND VGND VPWR VPWR sky130_fd_sc_hd__decap_3
XTAP_TAPCELL_ROW_144_946 VGND VPWR sky130_fd_sc_hd__tapvpwrvgnd_1
XTAP_TAPCELL_ROW_112_821 VGND VPWR sky130_fd_sc_hd__tapvpwrvgnd_1
XFILLER_35_60 VGND VGND VPWR VPWR sky130_fd_sc_hd__decap_3
XFILLER_42_173 VGND VGND VPWR VPWR sky130_fd_sc_hd__decap_3
XFILLER_96_9 VGND VGND VPWR VPWR sky130_fd_sc_hd__decap_3
XPHY_EDGE_ROW_106_Left_289 VGND VGND VPWR VPWR sky130_fd_sc_hd__decap_3
XFILLER_128_212 VGND VGND VPWR VPWR sky130_fd_sc_hd__decap_3
X_0710_ net117 net334 VGND VGND VPWR VPWR Tile_X0Y0_OpenRAM_top.Inst_OpenRAM_top_ConfigMem.Inst_frame0_bit12.Q
+ sky130_fd_sc_hd__dlxtp_1
XFILLER_167_81 VGND VGND VPWR VPWR sky130_fd_sc_hd__decap_3
X_0641_ Tile_X0Y1_OpenRAM_bot.Inst_OpenRAM_bot_ConfigMem.Inst_frame8_bit31.Q _0183_
+ VGND VGND VPWR VPWR _0184_ sky130_fd_sc_hd__and2b_1
X_0572_ net254 net357 _0091_ net170 Tile_X0Y1_OpenRAM_bot.Inst_OpenRAM_bot_ConfigMem.Inst_frame1_bit8.Q
+ Tile_X0Y1_OpenRAM_bot.Inst_OpenRAM_bot_ConfigMem.Inst_frame1_bit9.Q VGND VGND VPWR
+ VPWR _0156_ sky130_fd_sc_hd__mux4_2
XPHY_EDGE_ROW_115_Left_298 VGND VGND VPWR VPWR sky130_fd_sc_hd__decap_3
XFILLER_111_145 VGND VGND VPWR VPWR sky130_fd_sc_hd__decap_3
XTAP_TAPCELL_ROW_135_913 VGND VPWR sky130_fd_sc_hd__tapvpwrvgnd_1
X_1124_ net244 net298 VGND VGND VPWR VPWR Tile_X0Y1_OpenRAM_bot.Inst_OpenRAM_bot_ConfigMem.Inst_frame4_bit2.Q
+ sky130_fd_sc_hd__dlxtp_1
X_1055_ net251 net314 VGND VGND VPWR VPWR Tile_X0Y1_OpenRAM_bot.Inst_OpenRAM_bot_ConfigMem.Inst_frame2_bit7.Q
+ sky130_fd_sc_hd__dlxtp_1
XFILLER_18_192 VGND VGND VPWR VPWR sky130_fd_sc_hd__decap_3
XFILLER_178_112 VGND VGND VPWR VPWR sky130_fd_sc_hd__decap_3
XFILLER_33_140 VGND VGND VPWR VPWR sky130_fd_sc_hd__decap_3
XFILLER_178_156 VGND VGND VPWR VPWR sky130_fd_sc_hd__decap_3
XFILLER_178_189 VGND VGND VPWR VPWR sky130_fd_sc_hd__decap_3
XFILLER_119_201 VGND VGND VPWR VPWR sky130_fd_sc_hd__decap_3
X_0908_ net142 net284 VGND VGND VPWR VPWR Tile_X0Y0_OpenRAM_top.Inst_OpenRAM_top_ConfigMem.Inst_frame6_bit6.Q
+ sky130_fd_sc_hd__dlxtp_1
X_0839_ net116 net302 VGND VGND VPWR VPWR Tile_X0Y0_OpenRAM_top.Inst_OpenRAM_top_ConfigMem.Inst_frame4_bit11.Q
+ sky130_fd_sc_hd__dlxtp_1
XFILLER_163_28 VGND VGND VPWR VPWR sky130_fd_sc_hd__fill_1
XFILLER_0_206 VGND VGND VPWR VPWR sky130_fd_sc_hd__decap_3
Xinput118 Tile_X0Y0_FrameData[13] VGND VGND VPWR VPWR net118 sky130_fd_sc_hd__buf_4
Xinput107 Tile_X0Y0_EE4END[3] VGND VGND VPWR VPWR net107 sky130_fd_sc_hd__buf_1
Xinput129 Tile_X0Y0_FrameData[23] VGND VGND VPWR VPWR net129 sky130_fd_sc_hd__clkbuf_4
XFILLER_102_156 VGND VGND VPWR VPWR sky130_fd_sc_hd__decap_3
XFILLER_179_6 VGND VGND VPWR VPWR sky130_fd_sc_hd__decap_3
XFILLER_112_32 VGND VGND VPWR VPWR sky130_fd_sc_hd__decap_3
XFILLER_112_21 VGND VGND VPWR VPWR sky130_fd_sc_hd__decap_3
XFILLER_16_118 VGND VGND VPWR VPWR sky130_fd_sc_hd__decap_3
XFILLER_112_65 VGND VGND VPWR VPWR sky130_fd_sc_hd__decap_3
XFILLER_169_156 VGND VGND VPWR VPWR sky130_fd_sc_hd__decap_3
XFILLER_24_173 VGND VGND VPWR VPWR sky130_fd_sc_hd__decap_3
XFILLER_169_178 VGND VGND VPWR VPWR sky130_fd_sc_hd__decap_3
XFILLER_21_51 VGND VGND VPWR VPWR sky130_fd_sc_hd__decap_3
XFILLER_137_51 VGND VGND VPWR VPWR sky130_fd_sc_hd__decap_3
XFILLER_21_84 VGND VGND VPWR VPWR sky130_fd_sc_hd__decap_3
XFILLER_140_218 VGND VGND VPWR VPWR sky130_fd_sc_hd__decap_3
XFILLER_97_33 VGND VGND VPWR VPWR sky130_fd_sc_hd__fill_2
XFILLER_97_66 VGND VGND VPWR VPWR sky130_fd_sc_hd__decap_3
XFILLER_153_50 VGND VGND VPWR VPWR sky130_fd_sc_hd__decap_3
XFILLER_153_83 VGND VGND VPWR VPWR sky130_fd_sc_hd__decap_3
XFILLER_15_140 VGND VGND VPWR VPWR sky130_fd_sc_hd__decap_3
XFILLER_15_195 VGND VGND VPWR VPWR sky130_fd_sc_hd__decap_3
XFILLER_94_6 VGND VGND VPWR VPWR sky130_fd_sc_hd__decap_3
XFILLER_62_91 VGND VGND VPWR VPWR sky130_fd_sc_hd__decap_3
XFILLER_178_91 VGND VGND VPWR VPWR sky130_fd_sc_hd__decap_3
XFILLER_178_80 VGND VGND VPWR VPWR sky130_fd_sc_hd__decap_3
XFILLER_175_137 VGND VGND VPWR VPWR sky130_fd_sc_hd__decap_3
XFILLER_30_165 VGND VGND VPWR VPWR sky130_fd_sc_hd__decap_3
XFILLER_7_42 VGND VGND VPWR VPWR sky130_fd_sc_hd__decap_3
XFILLER_116_215 VGND VGND VPWR VPWR sky130_fd_sc_hd__decap_3
XFILLER_7_75 VGND VGND VPWR VPWR sky130_fd_sc_hd__decap_3
XPHY_EDGE_ROW_123_Left_306 VGND VGND VPWR VPWR sky130_fd_sc_hd__decap_3
X_0624_ _0028_ Tile_X0Y1_OpenRAM_bot.Inst_OpenRAM_bot_ConfigMem.Inst_frame1_bit5.Q
+ net261 _0170_ VGND VGND VPWR VPWR net375 sky130_fd_sc_hd__a31o_1
XFILLER_131_218 VGND VGND VPWR VPWR sky130_fd_sc_hd__decap_3
X_0555_ net30 net62 _0147_ net262 Tile_X0Y1_OpenRAM_bot.Inst_OpenRAM_bot_ConfigMem.Inst_frame5_bit28.Q
+ Tile_X0Y1_OpenRAM_bot.Inst_OpenRAM_bot_ConfigMem.Inst_frame5_bit29.Q VGND VGND VPWR
+ VPWR Tile_X0Y1_OpenRAM_bot.Inst_OpenRAM_bot_switch_matrix.WW4BEG6 sky130_fd_sc_hd__mux4_1
X_0486_ net88 Tile_X0Y0_OpenRAM_top.Inst_OpenRAM_top_switch_matrix.J_NS4_BEG15 Tile_X0Y0_OpenRAM_top.Inst_OpenRAM_top_ConfigMem.Inst_frame7_bit15.Q
+ VGND VGND VPWR VPWR _0127_ sky130_fd_sc_hd__mux2_1
XFILLER_97_165 VGND VGND VPWR VPWR sky130_fd_sc_hd__decap_3
XFILLER_38_210 VGND VGND VPWR VPWR sky130_fd_sc_hd__decap_3
XFILLER_26_29 VGND VGND VPWR VPWR sky130_fd_sc_hd__decap_3
XFILLER_53_202 VGND VGND VPWR VPWR sky130_fd_sc_hd__fill_2
XPHY_EDGE_ROW_132_Left_315 VGND VGND VPWR VPWR sky130_fd_sc_hd__decap_3
XPHY_EDGE_ROW_5_Right_5 VGND VGND VPWR VPWR sky130_fd_sc_hd__decap_3
X_1107_ net232 net297 VGND VGND VPWR VPWR Tile_X0Y1_OpenRAM_bot.Inst_OpenRAM_bot_ConfigMem.Inst_frame4_bit19.Q
+ sky130_fd_sc_hd__dlxtp_1
X_1038_ net238 net313 VGND VGND VPWR VPWR Tile_X0Y1_OpenRAM_bot.Inst_OpenRAM_bot_ConfigMem.Inst_frame2_bit24.Q
+ sky130_fd_sc_hd__dlxtp_1
XFILLER_21_143 VGND VGND VPWR VPWR sky130_fd_sc_hd__decap_3
XFILLER_166_137 VGND VGND VPWR VPWR sky130_fd_sc_hd__decap_3
XFILLER_21_187 VGND VGND VPWR VPWR sky130_fd_sc_hd__decap_3
XFILLER_166_159 VGND VGND VPWR VPWR sky130_fd_sc_hd__decap_3
XPHY_EDGE_ROW_141_Left_324 VGND VGND VPWR VPWR sky130_fd_sc_hd__decap_3
XFILLER_174_192 VGND VGND VPWR VPWR sky130_fd_sc_hd__decap_3
XFILLER_174_38 VGND VGND VPWR VPWR sky130_fd_sc_hd__decap_3
XFILLER_174_27 VGND VGND VPWR VPWR sky130_fd_sc_hd__fill_1
XFILLER_107_87 VGND VGND VPWR VPWR sky130_fd_sc_hd__decap_3
XFILLER_67_36 VGND VGND VPWR VPWR sky130_fd_sc_hd__decap_3
XFILLER_88_176 VGND VGND VPWR VPWR sky130_fd_sc_hd__decap_3
XFILLER_29_221 VGND VGND VPWR VPWR sky130_fd_sc_hd__decap_3
XPHY_EDGE_ROW_150_Right_150 VGND VGND VPWR VPWR sky130_fd_sc_hd__decap_3
XFILLER_177_3 VGND VGND VPWR VPWR sky130_fd_sc_hd__decap_3
XPHY_EDGE_ROW_150_Left_333 VGND VGND VPWR VPWR sky130_fd_sc_hd__decap_3
XFILLER_123_75 VGND VGND VPWR VPWR sky130_fd_sc_hd__decap_3
XTAP_TAPCELL_ROW_4_386 VGND VPWR sky130_fd_sc_hd__tapvpwrvgnd_1
XFILLER_83_24 VGND VGND VPWR VPWR sky130_fd_sc_hd__decap_3
XFILLER_83_57 VGND VGND VPWR VPWR sky130_fd_sc_hd__decap_3
XFILLER_16_62 VGND VGND VPWR VPWR sky130_fd_sc_hd__decap_3
XFILLER_8_103 VGND VGND VPWR VPWR sky130_fd_sc_hd__decap_3
XFILLER_12_187 VGND VGND VPWR VPWR sky130_fd_sc_hd__decap_3
XFILLER_8_136 VGND VGND VPWR VPWR sky130_fd_sc_hd__decap_3
XFILLER_157_159 VGND VGND VPWR VPWR sky130_fd_sc_hd__decap_3
XFILLER_148_50 VGND VGND VPWR VPWR sky130_fd_sc_hd__decap_3
XFILLER_8_147 VGND VGND VPWR VPWR sky130_fd_sc_hd__decap_3
XFILLER_172_118 VGND VGND VPWR VPWR sky130_fd_sc_hd__decap_3
XFILLER_165_181 VGND VGND VPWR VPWR sky130_fd_sc_hd__decap_3
XFILLER_32_94 VGND VGND VPWR VPWR sky130_fd_sc_hd__decap_3
XFILLER_148_94 VGND VGND VPWR VPWR sky130_fd_sc_hd__decap_3
XFILLER_180_151 VGND VGND VPWR VPWR sky130_fd_sc_hd__decap_3
XFILLER_180_184 VGND VGND VPWR VPWR sky130_fd_sc_hd__fill_1
X_0340_ net189 net181 net199 _0084_ Tile_X0Y1_OpenRAM_bot.Inst_OpenRAM_bot_ConfigMem.Inst_frame8_bit16.Q
+ Tile_X0Y1_OpenRAM_bot.Inst_OpenRAM_bot_ConfigMem.Inst_frame8_bit17.Q VGND VGND VPWR
+ VPWR Tile_X0Y0_OpenRAM_top.Inst_OpenRAM_top_switch_matrix.N2BEGb4 sky130_fd_sc_hd__mux4_1
X_0271_ net344 net186 Tile_X0Y1_OpenRAM_bot.Inst_OpenRAM_bot_ConfigMem.Inst_frame3_bit8.Q
+ VGND VGND VPWR VPWR _0041_ sky130_fd_sc_hd__mux2_1
XFILLER_94_124 VGND VGND VPWR VPWR sky130_fd_sc_hd__decap_3
XFILLER_94_168 VGND VGND VPWR VPWR sky130_fd_sc_hd__decap_3
XTAP_TAPCELL_ROW_18_444 VGND VPWR sky130_fd_sc_hd__tapvpwrvgnd_1
XFILLER_148_115 VGND VGND VPWR VPWR sky130_fd_sc_hd__decap_3
XFILLER_92_3 VGND VGND VPWR VPWR sky130_fd_sc_hd__decap_3
XFILLER_148_159 VGND VGND VPWR VPWR sky130_fd_sc_hd__decap_3
XFILLER_156_181 VGND VGND VPWR VPWR sky130_fd_sc_hd__decap_3
XFILLER_171_140 VGND VGND VPWR VPWR sky130_fd_sc_hd__decap_3
XFILLER_104_218 VGND VGND VPWR VPWR sky130_fd_sc_hd__decap_3
XFILLER_171_184 VGND VGND VPWR VPWR sky130_fd_sc_hd__decap_3
X_0607_ net219 net212 net203 _0149_ Tile_X0Y1_OpenRAM_bot.Inst_OpenRAM_bot_ConfigMem.Inst_frame2_bit10.Q
+ Tile_X0Y1_OpenRAM_bot.Inst_OpenRAM_bot_ConfigMem.Inst_frame2_bit11.Q VGND VGND VPWR
+ VPWR net414 sky130_fd_sc_hd__mux4_2
X_0538_ net32 net64 net263 _0087_ Tile_X0Y1_OpenRAM_bot.Inst_OpenRAM_bot_ConfigMem.Inst_frame5_bit0.Q
+ Tile_X0Y1_OpenRAM_bot.Inst_OpenRAM_bot_ConfigMem.Inst_frame5_bit1.Q VGND VGND VPWR
+ VPWR Tile_X0Y1_OpenRAM_bot.Inst_OpenRAM_bot_switch_matrix.W2BEGb0 sky130_fd_sc_hd__mux4_1
X_0469_ Tile_X0Y0_OpenRAM_top.Inst_OpenRAM_top_switch_matrix.J_NS4_BEG4 Tile_X0Y0_OpenRAM_top.Inst_OpenRAM_top_switch_matrix.J_NS4_BEG8
+ Tile_X0Y0_OpenRAM_top.Inst_OpenRAM_top_switch_matrix.J_NS4_BEG12 net259 Tile_X0Y0_OpenRAM_top.Inst_OpenRAM_top_ConfigMem.Inst_frame7_bit4.Q
+ Tile_X0Y0_OpenRAM_top.Inst_OpenRAM_top_ConfigMem.Inst_frame7_bit5.Q VGND VGND VPWR
+ VPWR _0113_ sky130_fd_sc_hd__mux4_1
XFILLER_37_39 VGND VGND VPWR VPWR sky130_fd_sc_hd__decap_3
XFILLER_85_146 VGND VGND VPWR VPWR sky130_fd_sc_hd__decap_3
XFILLER_160_29 VGND VGND VPWR VPWR sky130_fd_sc_hd__decap_3
XFILLER_160_18 VGND VGND VPWR VPWR sky130_fd_sc_hd__decap_3
XFILLER_93_190 VGND VGND VPWR VPWR sky130_fd_sc_hd__decap_3
XFILLER_41_205 VGND VGND VPWR VPWR sky130_fd_sc_hd__decap_3
XFILLER_53_27 VGND VGND VPWR VPWR sky130_fd_sc_hd__decap_3
XFILLER_169_27 VGND VGND VPWR VPWR sky130_fd_sc_hd__decap_3
XTAP_TAPCELL_ROW_24_469 VGND VPWR sky130_fd_sc_hd__tapvpwrvgnd_1
XFILLER_154_107 VGND VGND VPWR VPWR sky130_fd_sc_hd__decap_3
XFILLER_5_128 VGND VGND VPWR VPWR sky130_fd_sc_hd__decap_3
XFILLER_162_173 VGND VGND VPWR VPWR sky130_fd_sc_hd__decap_3
XFILLER_78_24 VGND VGND VPWR VPWR sky130_fd_sc_hd__decap_3
XFILLER_162_195 VGND VGND VPWR VPWR sky130_fd_sc_hd__fill_1
XFILLER_78_35 VGND VGND VPWR VPWR sky130_fd_sc_hd__decap_3
XFILLER_78_68 VGND VGND VPWR VPWR sky130_fd_sc_hd__decap_3
XFILLER_134_41 VGND VGND VPWR VPWR sky130_fd_sc_hd__fill_1
XFILLER_76_124 VGND VGND VPWR VPWR sky130_fd_sc_hd__fill_1
XFILLER_134_63 VGND VGND VPWR VPWR sky130_fd_sc_hd__fill_2
XFILLER_94_12 VGND VGND VPWR VPWR sky130_fd_sc_hd__fill_2
XFILLER_91_105 VGND VGND VPWR VPWR sky130_fd_sc_hd__decap_3
XFILLER_91_116 VGND VGND VPWR VPWR sky130_fd_sc_hd__decap_3
XFILLER_27_72 VGND VGND VPWR VPWR sky130_fd_sc_hd__decap_3
XFILLER_150_62 VGND VGND VPWR VPWR sky130_fd_sc_hd__decap_3
XFILLER_43_93 VGND VGND VPWR VPWR sky130_fd_sc_hd__decap_3
XFILLER_159_60 VGND VGND VPWR VPWR sky130_fd_sc_hd__decap_3
XFILLER_138_192 VGND VGND VPWR VPWR sky130_fd_sc_hd__decap_3
XFILLER_153_151 VGND VGND VPWR VPWR sky130_fd_sc_hd__decap_3
XFILLER_99_216 VGND VGND VPWR VPWR sky130_fd_sc_hd__decap_3
XFILLER_4_150 VGND VGND VPWR VPWR sky130_fd_sc_hd__decap_3
XFILLER_175_81 VGND VGND VPWR VPWR sky130_fd_sc_hd__decap_3
XFILLER_4_21 VGND VGND VPWR VPWR sky130_fd_sc_hd__decap_3
XFILLER_4_32 VGND VGND VPWR VPWR sky130_fd_sc_hd__decap_3
XFILLER_4_183 VGND VGND VPWR VPWR sky130_fd_sc_hd__decap_3
X_1441_ Tile_X0Y0_OpenRAM_top.Inst_OpenRAM_top_switch_matrix.S2BEG3 VGND VGND VPWR
+ VPWR net601 sky130_fd_sc_hd__clkbuf_2
XFILLER_4_65 VGND VGND VPWR VPWR sky130_fd_sc_hd__decap_3
X_1372_ Tile_X0Y0_OpenRAM_top.Inst_OpenRAM_top_switch_matrix.W6BEG6 VGND VGND VPWR
+ VPWR net534 sky130_fd_sc_hd__buf_1
XFILLER_67_113 VGND VGND VPWR VPWR sky130_fd_sc_hd__decap_3
X_0323_ net84 net76 net97 Tile_X0Y0_OpenRAM_top.Inst_OpenRAM_top_switch_matrix.J_NS2_BEG1
+ Tile_X0Y0_OpenRAM_top.Inst_OpenRAM_top_ConfigMem.Inst_frame7_bit26.Q Tile_X0Y0_OpenRAM_top.Inst_OpenRAM_top_ConfigMem.Inst_frame7_bit27.Q
+ VGND VGND VPWR VPWR Tile_X0Y0_OpenRAM_top.Inst_OpenRAM_top_switch_matrix.S2BEG1
+ sky130_fd_sc_hd__mux4_2
X_0254_ Tile_X0Y1_OpenRAM_bot.Inst_OpenRAM_bot_ConfigMem.Inst_frame1_bit2.Q VGND VGND
+ VPWR VPWR _0027_ sky130_fd_sc_hd__inv_2
XFILLER_82_116 VGND VGND VPWR VPWR sky130_fd_sc_hd__decap_3
XFILLER_75_190 VGND VGND VPWR VPWR sky130_fd_sc_hd__decap_3
XFILLER_90_160 VGND VGND VPWR VPWR sky130_fd_sc_hd__decap_3
XFILLER_176_221 VGND VGND VPWR VPWR sky130_fd_sc_hd__decap_3
XTAP_TAPCELL_ROW_157_1001 VGND VPWR sky130_fd_sc_hd__tapvpwrvgnd_1
XFILLER_136_107 VGND VGND VPWR VPWR sky130_fd_sc_hd__decap_3
XFILLER_144_162 VGND VGND VPWR VPWR sky130_fd_sc_hd__decap_3
XFILLER_2_109 VGND VGND VPWR VPWR sky130_fd_sc_hd__decap_3
XFILLER_144_195 VGND VGND VPWR VPWR sky130_fd_sc_hd__fill_1
XFILLER_48_27 VGND VGND VPWR VPWR sky130_fd_sc_hd__fill_1
XFILLER_48_38 VGND VGND VPWR VPWR sky130_fd_sc_hd__decap_3
XFILLER_171_39 VGND VGND VPWR VPWR sky130_fd_sc_hd__decap_3
XTAP_TAPCELL_ROW_164_1027 VGND VPWR sky130_fd_sc_hd__tapvpwrvgnd_1
XFILLER_104_44 VGND VGND VPWR VPWR sky130_fd_sc_hd__decap_3
XFILLER_58_168 VGND VGND VPWR VPWR sky130_fd_sc_hd__decap_3
XFILLER_73_116 VGND VGND VPWR VPWR sky130_fd_sc_hd__decap_3
XFILLER_104_88 VGND VGND VPWR VPWR sky130_fd_sc_hd__decap_3
XFILLER_104_77 VGND VGND VPWR VPWR sky130_fd_sc_hd__decap_3
XFILLER_73_149 VGND VGND VPWR VPWR sky130_fd_sc_hd__decap_3
XFILLER_120_32 VGND VGND VPWR VPWR sky130_fd_sc_hd__fill_1
XFILLER_14_227 VGND VGND VPWR VPWR sky130_fd_sc_hd__decap_3
XFILLER_120_54 VGND VGND VPWR VPWR sky130_fd_sc_hd__decap_3
XFILLER_13_30 VGND VGND VPWR VPWR sky130_fd_sc_hd__decap_3
XTAP_TAPCELL_ROW_20_450 VGND VPWR sky130_fd_sc_hd__tapvpwrvgnd_1
XFILLER_89_12 VGND VGND VPWR VPWR sky130_fd_sc_hd__decap_3
XFILLER_135_162 VGND VGND VPWR VPWR sky130_fd_sc_hd__decap_3
XFILLER_129_96 VGND VGND VPWR VPWR sky130_fd_sc_hd__fill_1
XFILLER_89_78 VGND VGND VPWR VPWR sky130_fd_sc_hd__decap_3
XFILLER_145_51 VGND VGND VPWR VPWR sky130_fd_sc_hd__decap_3
XFILLER_1_131 VGND VGND VPWR VPWR sky130_fd_sc_hd__decap_3
XFILLER_145_95 VGND VGND VPWR VPWR sky130_fd_sc_hd__fill_2
XFILLER_49_113 VGND VGND VPWR VPWR sky130_fd_sc_hd__decap_3
XTAP_TAPCELL_ROW_182_1105 VGND VPWR sky130_fd_sc_hd__tapvpwrvgnd_1
XTAP_TAPCELL_ROW_119_849 VGND VPWR sky130_fd_sc_hd__tapvpwrvgnd_1
XFILLER_49_146 VGND VGND VPWR VPWR sky130_fd_sc_hd__decap_3
XFILLER_64_127 VGND VGND VPWR VPWR sky130_fd_sc_hd__decap_3
XFILLER_57_190 VGND VGND VPWR VPWR sky130_fd_sc_hd__decap_3
XFILLER_72_171 VGND VGND VPWR VPWR sky130_fd_sc_hd__fill_2
XTAP_TAPCELL_ROW_43_542 VGND VPWR sky130_fd_sc_hd__tapvpwrvgnd_1
X_0941_ net141 net276 VGND VGND VPWR VPWR Tile_X0Y0_OpenRAM_top.Inst_OpenRAM_top_ConfigMem.Inst_frame7_bit5.Q
+ sky130_fd_sc_hd__dlxtp_1
XFILLER_9_220 VGND VGND VPWR VPWR sky130_fd_sc_hd__decap_3
XFILLER_173_202 VGND VGND VPWR VPWR sky130_fd_sc_hd__decap_3
X_0872_ net115 net293 VGND VGND VPWR VPWR Tile_X0Y0_OpenRAM_top.Inst_OpenRAM_top_ConfigMem.Inst_frame5_bit10.Q
+ sky130_fd_sc_hd__dlxtp_1
XFILLER_118_129 VGND VGND VPWR VPWR sky130_fd_sc_hd__decap_3
XFILLER_126_195 VGND VGND VPWR VPWR sky130_fd_sc_hd__fill_1
X_1424_ net245 VGND VGND VPWR VPWR net577 sky130_fd_sc_hd__buf_6
X_1355_ Tile_X0Y0_OpenRAM_top.Inst_OpenRAM_top_switch_matrix.W2BEG5 VGND VGND VPWR
+ VPWR net515 sky130_fd_sc_hd__buf_1
X_0306_ net339 Tile_X0Y1_OpenRAM_bot.Inst_OpenRAM_bot_ConfigMem.Inst_frame0_bit28.Q
+ Tile_X0Y1_OpenRAM_bot.Inst_OpenRAM_bot_ConfigMem.Inst_frame0_bit29.Q VGND VGND VPWR
+ VPWR _0071_ sky130_fd_sc_hd__o21ba_1
XFILLER_55_116 VGND VGND VPWR VPWR sky130_fd_sc_hd__fill_2
X_1286_ net135 VGND VGND VPWR VPWR net438 sky130_fd_sc_hd__buf_1
XTAP_TAPCELL_ROW_66_634 VGND VPWR sky130_fd_sc_hd__tapvpwrvgnd_1
X_0237_ Tile_X0Y0_OpenRAM_top.Inst_OpenRAM_top_ConfigMem.Inst_frame1_bit2.Q VGND VGND
+ VPWR VPWR _0010_ sky130_fd_sc_hd__inv_2
XFILLER_63_160 VGND VGND VPWR VPWR sky130_fd_sc_hd__decap_3
XFILLER_34_29 VGND VGND VPWR VPWR sky130_fd_sc_hd__fill_2
XFILLER_63_193 VGND VGND VPWR VPWR sky130_fd_sc_hd__decap_3
XFILLER_149_221 VGND VGND VPWR VPWR sky130_fd_sc_hd__decap_3
XFILLER_164_224 VGND VGND VPWR VPWR sky130_fd_sc_hd__decap_3
XFILLER_109_107 VGND VGND VPWR VPWR sky130_fd_sc_hd__decap_3
XFILLER_117_140 VGND VGND VPWR VPWR sky130_fd_sc_hd__decap_3
XTAP_TAPCELL_ROW_170_1053 VGND VPWR sky130_fd_sc_hd__tapvpwrvgnd_1
XFILLER_117_184 VGND VGND VPWR VPWR sky130_fd_sc_hd__decap_3
Xoutput550 net633 VGND VGND VPWR VPWR Tile_X0Y1_W2BEG[7] sky130_fd_sc_hd__buf_2
Xoutput572 net655 VGND VGND VPWR VPWR Tile_X0Y1_WW4BEG[10] sky130_fd_sc_hd__buf_2
Xoutput561 net644 VGND VGND VPWR VPWR Tile_X0Y1_W6BEG[11] sky130_fd_sc_hd__buf_2
XFILLER_59_37 VGND VGND VPWR VPWR sky130_fd_sc_hd__decap_3
XFILLER_132_165 VGND VGND VPWR VPWR sky130_fd_sc_hd__decap_3
Xoutput583 net666 VGND VGND VPWR VPWR Tile_X0Y1_WW4BEG[6] sky130_fd_sc_hd__buf_2
XTAP_TAPCELL_ROW_89_726 VGND VPWR sky130_fd_sc_hd__tapvpwrvgnd_1
XFILLER_115_54 VGND VGND VPWR VPWR sky130_fd_sc_hd__fill_2
Xfanout265 net267 VGND VGND VPWR VPWR net265 sky130_fd_sc_hd__clkbuf_2
Xfanout276 net277 VGND VGND VPWR VPWR net276 sky130_fd_sc_hd__clkbuf_2
XFILLER_115_87 VGND VGND VPWR VPWR sky130_fd_sc_hd__decap_3
Xfanout287 net290 VGND VGND VPWR VPWR net287 sky130_fd_sc_hd__clkbuf_2
Xfanout298 net299 VGND VGND VPWR VPWR net298 sky130_fd_sc_hd__clkbuf_2
XTAP_TAPCELL_ROW_57_601 VGND VPWR sky130_fd_sc_hd__tapvpwrvgnd_1
XFILLER_46_138 VGND VGND VPWR VPWR sky130_fd_sc_hd__fill_2
XFILLER_131_75 VGND VGND VPWR VPWR sky130_fd_sc_hd__decap_3
XFILLER_54_171 VGND VGND VPWR VPWR sky130_fd_sc_hd__decap_3
XFILLER_61_119 VGND VGND VPWR VPWR sky130_fd_sc_hd__decap_3
XTAP_TAPCELL_ROW_72_659 VGND VPWR sky130_fd_sc_hd__tapvpwrvgnd_1
XTAP_TAPCELL_ROW_80_692 VGND VPWR sky130_fd_sc_hd__tapvpwrvgnd_1
XFILLER_155_202 VGND VGND VPWR VPWR sky130_fd_sc_hd__decap_3
XFILLER_10_230 VGND VGND VPWR VPWR sky130_fd_sc_hd__fill_1
XFILLER_24_95 VGND VGND VPWR VPWR sky130_fd_sc_hd__fill_1
XFILLER_6_212 VGND VGND VPWR VPWR sky130_fd_sc_hd__fill_2
XFILLER_40_72 VGND VGND VPWR VPWR sky130_fd_sc_hd__decap_3
XFILLER_170_227 VGND VGND VPWR VPWR sky130_fd_sc_hd__decap_3
XFILLER_156_50 VGND VGND VPWR VPWR sky130_fd_sc_hd__decap_3
XFILLER_108_195 VGND VGND VPWR VPWR sky130_fd_sc_hd__fill_1
XFILLER_156_94 VGND VGND VPWR VPWR sky130_fd_sc_hd__decap_3
XFILLER_123_143 VGND VGND VPWR VPWR sky130_fd_sc_hd__decap_3
XFILLER_49_81 VGND VGND VPWR VPWR sky130_fd_sc_hd__decap_3
XFILLER_172_71 VGND VGND VPWR VPWR sky130_fd_sc_hd__decap_3
X_1140_ net231 net288 VGND VGND VPWR VPWR Tile_X0Y1_OpenRAM_bot.Inst_OpenRAM_bot_ConfigMem.Inst_frame5_bit18.Q
+ sky130_fd_sc_hd__dlxtp_1
XFILLER_37_105 VGND VGND VPWR VPWR sky130_fd_sc_hd__decap_3
XFILLER_92_200 VGND VGND VPWR VPWR sky130_fd_sc_hd__decap_3
XTAP_TAPCELL_ROW_115_830 VGND VPWR sky130_fd_sc_hd__tapvpwrvgnd_1
X_1071_ net237 net304 VGND VGND VPWR VPWR Tile_X0Y1_OpenRAM_bot.Inst_OpenRAM_bot_ConfigMem.Inst_frame3_bit23.Q
+ sky130_fd_sc_hd__dlxtp_1
XFILLER_60_141 VGND VGND VPWR VPWR sky130_fd_sc_hd__decap_3
X_0924_ net128 net274 VGND VGND VPWR VPWR Tile_X0Y0_OpenRAM_top.Inst_OpenRAM_top_ConfigMem.Inst_frame7_bit22.Q
+ sky130_fd_sc_hd__dlxtp_1
X_0855_ net133 net292 VGND VGND VPWR VPWR Tile_X0Y0_OpenRAM_top.Inst_OpenRAM_top_ConfigMem.Inst_frame5_bit27.Q
+ sky130_fd_sc_hd__dlxtp_1
X_0786_ net114 net317 VGND VGND VPWR VPWR Tile_X0Y0_OpenRAM_top.Inst_OpenRAM_top_ConfigMem.Inst_frame2_bit0.Q
+ sky130_fd_sc_hd__dlxtp_1
XFILLER_114_121 VGND VGND VPWR VPWR sky130_fd_sc_hd__decap_3
XFILLER_114_165 VGND VGND VPWR VPWR sky130_fd_sc_hd__fill_2
XTAP_TAPCELL_ROW_138_922 VGND VPWR sky130_fd_sc_hd__tapvpwrvgnd_1
X_1407_ net226 VGND VGND VPWR VPWR net558 sky130_fd_sc_hd__clkbuf_2
X_1338_ Tile_X0Y0_OpenRAM_top.N4BEG_outbuf_9.A VGND VGND VPWR VPWR net504 sky130_fd_sc_hd__buf_4
X_1269_ net117 VGND VGND VPWR VPWR net420 sky130_fd_sc_hd__clkbuf_2
XFILLER_45_17 VGND VGND VPWR VPWR sky130_fd_sc_hd__decap_3
XFILLER_36_171 VGND VGND VPWR VPWR sky130_fd_sc_hd__decap_3
XFILLER_43_108 VGND VGND VPWR VPWR sky130_fd_sc_hd__decap_3
XFILLER_43_119 VGND VGND VPWR VPWR sky130_fd_sc_hd__decap_3
XFILLER_101_34 VGND VGND VPWR VPWR sky130_fd_sc_hd__decap_3
XTAP_TAPCELL_ROW_121_855 VGND VPWR sky130_fd_sc_hd__tapvpwrvgnd_1
XFILLER_51_141 VGND VGND VPWR VPWR sky130_fd_sc_hd__fill_2
XFILLER_101_78 VGND VGND VPWR VPWR sky130_fd_sc_hd__decap_3
XFILLER_177_27 VGND VGND VPWR VPWR sky130_fd_sc_hd__decap_3
XPHY_EDGE_ROW_18_Left_201 VGND VGND VPWR VPWR sky130_fd_sc_hd__decap_3
XFILLER_105_132 VGND VGND VPWR VPWR sky130_fd_sc_hd__decap_3
XFILLER_10_53 VGND VGND VPWR VPWR sky130_fd_sc_hd__decap_3
Xoutput380 net463 VGND VGND VPWR VPWR Tile_X0Y0_FrameStrobe_O[4] sky130_fd_sc_hd__buf_2
XFILLER_126_64 VGND VGND VPWR VPWR sky130_fd_sc_hd__decap_3
XFILLER_105_187 VGND VGND VPWR VPWR sky130_fd_sc_hd__decap_3
XFILLER_10_97 VGND VGND VPWR VPWR sky130_fd_sc_hd__decap_3
Xoutput391 net474 VGND VGND VPWR VPWR Tile_X0Y0_N2BEG[1] sky130_fd_sc_hd__buf_2
XFILLER_120_113 VGND VGND VPWR VPWR sky130_fd_sc_hd__decap_3
XFILLER_86_24 VGND VGND VPWR VPWR sky130_fd_sc_hd__decap_3
XFILLER_74_200 VGND VGND VPWR VPWR sky130_fd_sc_hd__decap_3
XTAP_TAPCELL_ROW_144_947 VGND VPWR sky130_fd_sc_hd__tapvpwrvgnd_1
XFILLER_142_85 VGND VGND VPWR VPWR sky130_fd_sc_hd__decap_3
XPHY_EDGE_ROW_27_Left_210 VGND VGND VPWR VPWR sky130_fd_sc_hd__decap_3
XFILLER_27_160 VGND VGND VPWR VPWR sky130_fd_sc_hd__decap_3
XFILLER_34_108 VGND VGND VPWR VPWR sky130_fd_sc_hd__decap_3
XTAP_TAPCELL_ROW_152_980 VGND VPWR sky130_fd_sc_hd__tapvpwrvgnd_1
XFILLER_42_141 VGND VGND VPWR VPWR sky130_fd_sc_hd__decap_3
XFILLER_42_185 VGND VGND VPWR VPWR sky130_fd_sc_hd__decap_3
XFILLER_89_9 VGND VGND VPWR VPWR sky130_fd_sc_hd__decap_3
XFILLER_128_224 VGND VGND VPWR VPWR sky130_fd_sc_hd__decap_3
XFILLER_51_93 VGND VGND VPWR VPWR sky130_fd_sc_hd__decap_3
X_0640_ _0150_ _0146_ Tile_X0Y1_OpenRAM_bot.Inst_OpenRAM_bot_ConfigMem.Inst_frame8_bit30.Q
+ VGND VGND VPWR VPWR _0183_ sky130_fd_sc_hd__mux2_1
XPHY_EDGE_ROW_164_Right_164 VGND VGND VPWR VPWR sky130_fd_sc_hd__decap_3
X_0571_ net8 net40 _0155_ net262 Tile_X0Y1_OpenRAM_bot.Inst_OpenRAM_bot_ConfigMem.Inst_frame4_bit12.Q
+ Tile_X0Y1_OpenRAM_bot.Inst_OpenRAM_bot_ConfigMem.Inst_frame4_bit13.Q VGND VGND VPWR
+ VPWR Tile_X0Y1_OpenRAM_bot.Inst_OpenRAM_bot_switch_matrix.WW4BEG14 sky130_fd_sc_hd__mux4_1
X_1123_ net247 net298 VGND VGND VPWR VPWR Tile_X0Y1_OpenRAM_bot.Inst_OpenRAM_bot_ConfigMem.Inst_frame4_bit3.Q
+ sky130_fd_sc_hd__dlxtp_1
XFILLER_25_119 VGND VGND VPWR VPWR sky130_fd_sc_hd__fill_1
X_1054_ net252 net313 VGND VGND VPWR VPWR Tile_X0Y1_OpenRAM_bot.Inst_OpenRAM_bot_ConfigMem.Inst_frame2_bit8.Q
+ sky130_fd_sc_hd__dlxtp_1
XFILLER_80_203 VGND VGND VPWR VPWR sky130_fd_sc_hd__decap_3
XFILLER_178_124 VGND VGND VPWR VPWR sky130_fd_sc_hd__decap_3
XFILLER_33_163 VGND VGND VPWR VPWR sky130_fd_sc_hd__decap_3
XFILLER_178_168 VGND VGND VPWR VPWR sky130_fd_sc_hd__decap_3
X_0907_ net143 net284 VGND VGND VPWR VPWR Tile_X0Y0_OpenRAM_top.Inst_OpenRAM_top_ConfigMem.Inst_frame6_bit7.Q
+ sky130_fd_sc_hd__dlxtp_1
XFILLER_119_213 VGND VGND VPWR VPWR sky130_fd_sc_hd__decap_3
XFILLER_147_19 VGND VGND VPWR VPWR sky130_fd_sc_hd__decap_3
XFILLER_134_227 VGND VGND VPWR VPWR sky130_fd_sc_hd__decap_3
X_0838_ net117 net301 VGND VGND VPWR VPWR Tile_X0Y0_OpenRAM_top.Inst_OpenRAM_top_ConfigMem.Inst_frame4_bit12.Q
+ sky130_fd_sc_hd__dlxtp_1
XPHY_EDGE_ROW_131_Right_131 VGND VGND VPWR VPWR sky130_fd_sc_hd__decap_3
X_0769_ net122 net317 VGND VGND VPWR VPWR Tile_X0Y0_OpenRAM_top.Inst_OpenRAM_top_ConfigMem.Inst_frame2_bit17.Q
+ sky130_fd_sc_hd__dlxtp_1
XFILLER_0_218 VGND VGND VPWR VPWR sky130_fd_sc_hd__decap_3
Xinput108 Tile_X0Y0_EE4END[4] VGND VGND VPWR VPWR net108 sky130_fd_sc_hd__dlymetal6s2s_1
XFILLER_102_135 VGND VGND VPWR VPWR sky130_fd_sc_hd__decap_3
XFILLER_102_113 VGND VGND VPWR VPWR sky130_fd_sc_hd__decap_3
Xinput119 Tile_X0Y0_FrameData[14] VGND VGND VPWR VPWR net119 sky130_fd_sc_hd__buf_4
XFILLER_102_168 VGND VGND VPWR VPWR sky130_fd_sc_hd__decap_3
XFILLER_56_27 VGND VGND VPWR VPWR sky130_fd_sc_hd__fill_1
XFILLER_56_38 VGND VGND VPWR VPWR sky130_fd_sc_hd__fill_2
XFILLER_56_211 VGND VGND VPWR VPWR sky130_fd_sc_hd__decap_3
XFILLER_112_44 VGND VGND VPWR VPWR sky130_fd_sc_hd__decap_3
XFILLER_72_15 VGND VGND VPWR VPWR sky130_fd_sc_hd__decap_3
XFILLER_169_113 VGND VGND VPWR VPWR sky130_fd_sc_hd__decap_3
XFILLER_169_102 VGND VGND VPWR VPWR sky130_fd_sc_hd__decap_3
XFILLER_112_88 VGND VGND VPWR VPWR sky130_fd_sc_hd__decap_3
XFILLER_24_141 VGND VGND VPWR VPWR sky130_fd_sc_hd__decap_3
XFILLER_72_59 VGND VGND VPWR VPWR sky130_fd_sc_hd__decap_3
XFILLER_24_185 VGND VGND VPWR VPWR sky130_fd_sc_hd__decap_3
XFILLER_177_190 VGND VGND VPWR VPWR sky130_fd_sc_hd__decap_3
XFILLER_21_63 VGND VGND VPWR VPWR sky130_fd_sc_hd__decap_3
XFILLER_21_96 VGND VGND VPWR VPWR sky130_fd_sc_hd__decap_3
XFILLER_137_85 VGND VGND VPWR VPWR sky130_fd_sc_hd__fill_1
XFILLER_47_222 VGND VGND VPWR VPWR sky130_fd_sc_hd__fill_2
XFILLER_101_190 VGND VGND VPWR VPWR sky130_fd_sc_hd__fill_1
XFILLER_62_203 VGND VGND VPWR VPWR sky130_fd_sc_hd__decap_3
XFILLER_15_152 VGND VGND VPWR VPWR sky130_fd_sc_hd__decap_3
XFILLER_175_116 VGND VGND VPWR VPWR sky130_fd_sc_hd__decap_3
XFILLER_175_105 VGND VGND VPWR VPWR sky130_fd_sc_hd__decap_3
XFILLER_30_144 VGND VGND VPWR VPWR sky130_fd_sc_hd__decap_3
XFILLER_87_6 VGND VGND VPWR VPWR sky130_fd_sc_hd__decap_3
XFILLER_175_149 VGND VGND VPWR VPWR sky130_fd_sc_hd__decap_3
XFILLER_7_21 VGND VGND VPWR VPWR sky130_fd_sc_hd__decap_3
XFILLER_30_177 VGND VGND VPWR VPWR sky130_fd_sc_hd__decap_3
XFILLER_7_54 VGND VGND VPWR VPWR sky130_fd_sc_hd__fill_2
XFILLER_116_227 VGND VGND VPWR VPWR sky130_fd_sc_hd__decap_3
XFILLER_7_87 VGND VGND VPWR VPWR sky130_fd_sc_hd__decap_3
X_0623_ net180 _0028_ _0169_ VGND VGND VPWR VPWR _0170_ sky130_fd_sc_hd__o21a_1
XFILLER_97_100 VGND VGND VPWR VPWR sky130_fd_sc_hd__decap_3
X_0554_ net255 net358 _0063_ net171 Tile_X0Y1_OpenRAM_bot.Inst_OpenRAM_bot_ConfigMem.Inst_frame1_bit26.Q
+ Tile_X0Y1_OpenRAM_bot.Inst_OpenRAM_bot_ConfigMem.Inst_frame1_bit27.Q VGND VGND VPWR
+ VPWR _0147_ sky130_fd_sc_hd__mux4_2
X_0485_ _0126_ _0125_ _0123_ _0124_ Tile_X0Y0_OpenRAM_top.Inst_OpenRAM_top_ConfigMem.Inst_frame7_bit10.Q
+ Tile_X0Y0_OpenRAM_top.Inst_OpenRAM_top_ConfigMem.Inst_frame7_bit11.Q VGND VGND VPWR
+ VPWR Tile_X0Y0_OpenRAM_top.Inst_OpenRAM_top_switch_matrix.N4BEG2 sky130_fd_sc_hd__mux4_1
XFILLER_97_188 VGND VGND VPWR VPWR sky130_fd_sc_hd__decap_3
XFILLER_38_222 VGND VGND VPWR VPWR sky130_fd_sc_hd__decap_3
X_1106_ net234 net299 VGND VGND VPWR VPWR Tile_X0Y1_OpenRAM_bot.Inst_OpenRAM_bot_ConfigMem.Inst_frame4_bit20.Q
+ sky130_fd_sc_hd__dlxtp_1
X_1037_ net239 net313 VGND VGND VPWR VPWR Tile_X0Y1_OpenRAM_bot.Inst_OpenRAM_bot_ConfigMem.Inst_frame2_bit25.Q
+ sky130_fd_sc_hd__dlxtp_1
XFILLER_21_111 VGND VGND VPWR VPWR sky130_fd_sc_hd__fill_1
XFILLER_166_116 VGND VGND VPWR VPWR sky130_fd_sc_hd__decap_3
XFILLER_21_122 VGND VGND VPWR VPWR sky130_fd_sc_hd__decap_3
XFILLER_42_18 VGND VGND VPWR VPWR sky130_fd_sc_hd__decap_3
XFILLER_42_29 VGND VGND VPWR VPWR sky130_fd_sc_hd__decap_3
XFILLER_158_29 VGND VGND VPWR VPWR sky130_fd_sc_hd__decap_3
XFILLER_21_155 VGND VGND VPWR VPWR sky130_fd_sc_hd__decap_3
XFILLER_174_171 VGND VGND VPWR VPWR sky130_fd_sc_hd__decap_3
Xinput90 Tile_X0Y0_E6END[2] VGND VGND VPWR VPWR net90 sky130_fd_sc_hd__dlymetal6s2s_1
XFILLER_122_219 VGND VGND VPWR VPWR sky130_fd_sc_hd__decap_3
XFILLER_88_100 VGND VGND VPWR VPWR sky130_fd_sc_hd__decap_3
XFILLER_107_55 VGND VGND VPWR VPWR sky130_fd_sc_hd__fill_1
XFILLER_107_99 VGND VGND VPWR VPWR sky130_fd_sc_hd__fill_1
XFILLER_67_48 VGND VGND VPWR VPWR sky130_fd_sc_hd__decap_3
XFILLER_88_144 VGND VGND VPWR VPWR sky130_fd_sc_hd__decap_3
XFILLER_29_200 VGND VGND VPWR VPWR sky130_fd_sc_hd__decap_3
XFILLER_88_188 VGND VGND VPWR VPWR sky130_fd_sc_hd__decap_3
XFILLER_123_21 VGND VGND VPWR VPWR sky130_fd_sc_hd__decap_3
XFILLER_123_54 VGND VGND VPWR VPWR sky130_fd_sc_hd__fill_2
XTAP_TAPCELL_ROW_4_387 VGND VPWR sky130_fd_sc_hd__tapvpwrvgnd_1
XFILLER_44_203 VGND VGND VPWR VPWR sky130_fd_sc_hd__decap_3
XFILLER_123_87 VGND VGND VPWR VPWR sky130_fd_sc_hd__decap_3
XFILLER_83_36 VGND VGND VPWR VPWR sky130_fd_sc_hd__decap_3
XFILLER_83_69 VGND VGND VPWR VPWR sky130_fd_sc_hd__decap_3
XFILLER_16_85 VGND VGND VPWR VPWR sky130_fd_sc_hd__decap_3
XFILLER_16_74 VGND VGND VPWR VPWR sky130_fd_sc_hd__decap_3
XFILLER_12_100 VGND VGND VPWR VPWR sky130_fd_sc_hd__decap_3
XPHY_EDGE_ROW_11_Right_11 VGND VGND VPWR VPWR sky130_fd_sc_hd__decap_3
XTAP_TAPCELL_ROW_27_478 VGND VPWR sky130_fd_sc_hd__tapvpwrvgnd_1
XFILLER_12_122 VGND VGND VPWR VPWR sky130_fd_sc_hd__decap_3
XFILLER_157_116 VGND VGND VPWR VPWR sky130_fd_sc_hd__fill_1
XFILLER_8_115 VGND VGND VPWR VPWR sky130_fd_sc_hd__decap_3
XFILLER_8_159 VGND VGND VPWR VPWR sky130_fd_sc_hd__decap_3
XFILLER_148_73 VGND VGND VPWR VPWR sky130_fd_sc_hd__decap_3
XFILLER_180_141 VGND VGND VPWR VPWR sky130_fd_sc_hd__fill_2
XFILLER_180_130 VGND VGND VPWR VPWR sky130_fd_sc_hd__decap_3
XFILLER_180_163 VGND VGND VPWR VPWR sky130_fd_sc_hd__decap_3
XFILLER_113_208 VGND VGND VPWR VPWR sky130_fd_sc_hd__decap_3
XPHY_EDGE_ROW_20_Right_20 VGND VGND VPWR VPWR sky130_fd_sc_hd__decap_3
XFILLER_79_166 VGND VGND VPWR VPWR sky130_fd_sc_hd__fill_2
XFILLER_79_199 VGND VGND VPWR VPWR sky130_fd_sc_hd__decap_3
X_0270_ Tile_X0Y1_OpenRAM_bot.Inst_OpenRAM_bot_ConfigMem.Inst_frame3_bit9.Q Tile_X0Y1_OpenRAM_bot.Inst_OpenRAM_bot_ConfigMem.Inst_frame3_bit10.Q
+ _0039_ VGND VGND VPWR VPWR _0040_ sky130_fd_sc_hd__or3b_1
XFILLER_94_103 VGND VGND VPWR VPWR sky130_fd_sc_hd__decap_3
XFILLER_94_136 VGND VGND VPWR VPWR sky130_fd_sc_hd__decap_3
XFILLER_57_81 VGND VGND VPWR VPWR sky130_fd_sc_hd__decap_3
XTAP_TAPCELL_ROW_18_445 VGND VPWR sky130_fd_sc_hd__tapvpwrvgnd_1
XFILLER_148_127 VGND VGND VPWR VPWR sky130_fd_sc_hd__decap_3
XFILLER_85_3 VGND VGND VPWR VPWR sky130_fd_sc_hd__decap_3
XFILLER_163_119 VGND VGND VPWR VPWR sky130_fd_sc_hd__decap_3
XFILLER_156_193 VGND VGND VPWR VPWR sky130_fd_sc_hd__decap_3
XFILLER_7_181 VGND VGND VPWR VPWR sky130_fd_sc_hd__decap_3
XFILLER_171_152 VGND VGND VPWR VPWR sky130_fd_sc_hd__decap_3
XFILLER_171_196 VGND VGND VPWR VPWR sky130_fd_sc_hd__decap_3
X_0606_ net218 net211 net202 _0150_ Tile_X0Y1_OpenRAM_bot.Inst_OpenRAM_bot_ConfigMem.Inst_frame2_bit8.Q
+ Tile_X0Y1_OpenRAM_bot.Inst_OpenRAM_bot_ConfigMem.Inst_frame2_bit9.Q VGND VGND VPWR
+ VPWR net413 sky130_fd_sc_hd__mux4_2
X_0537_ net31 net63 net263 _0087_ Tile_X0Y1_OpenRAM_bot.Inst_OpenRAM_bot_ConfigMem.Inst_frame6_bit30.Q
+ Tile_X0Y1_OpenRAM_bot.Inst_OpenRAM_bot_ConfigMem.Inst_frame6_bit31.Q VGND VGND VPWR
+ VPWR Tile_X0Y1_OpenRAM_bot.Inst_OpenRAM_bot_switch_matrix.W2BEG7 sky130_fd_sc_hd__mux4_1
X_0468_ _0112_ Tile_X0Y0_OpenRAM_top.Inst_OpenRAM_top_ConfigMem.Inst_frame1_bit7.Q
+ _0012_ _0111_ VGND VGND VPWR VPWR net380 sky130_fd_sc_hd__a2bb2o_2
XFILLER_37_18 VGND VGND VPWR VPWR sky130_fd_sc_hd__decap_3
XFILLER_85_158 VGND VGND VPWR VPWR sky130_fd_sc_hd__decap_3
X_0399_ Tile_X0Y0_OpenRAM_top.Inst_OpenRAM_top_switch_matrix.N1END3 net364 net149
+ net169 Tile_X0Y0_OpenRAM_top.Inst_OpenRAM_top_ConfigMem.Inst_frame1_bit22.Q Tile_X0Y0_OpenRAM_top.Inst_OpenRAM_top_ConfigMem.Inst_frame1_bit23.Q
+ VGND VGND VPWR VPWR Tile_X0Y0_OpenRAM_top.Inst_OpenRAM_top_switch_matrix.J_NS4_BEG7
+ sky130_fd_sc_hd__mux4_2
XFILLER_26_203 VGND VGND VPWR VPWR sky130_fd_sc_hd__fill_1
XFILLER_85_169 VGND VGND VPWR VPWR sky130_fd_sc_hd__decap_3
XFILLER_26_225 VGND VGND VPWR VPWR sky130_fd_sc_hd__decap_3
XFILLER_41_217 VGND VGND VPWR VPWR sky130_fd_sc_hd__decap_3
XFILLER_53_39 VGND VGND VPWR VPWR sky130_fd_sc_hd__fill_2
XFILLER_169_39 VGND VGND VPWR VPWR sky130_fd_sc_hd__decap_3
XFILLER_139_116 VGND VGND VPWR VPWR sky130_fd_sc_hd__decap_3
XFILLER_154_119 VGND VGND VPWR VPWR sky130_fd_sc_hd__decap_3
XTAP_TAPCELL_ROW_173_1062 VGND VPWR sky130_fd_sc_hd__tapvpwrvgnd_1
XFILLER_147_193 VGND VGND VPWR VPWR sky130_fd_sc_hd__decap_3
XFILLER_118_32 VGND VGND VPWR VPWR sky130_fd_sc_hd__decap_3
XFILLER_162_141 VGND VGND VPWR VPWR sky130_fd_sc_hd__fill_2
XFILLER_78_47 VGND VGND VPWR VPWR sky130_fd_sc_hd__decap_3
XFILLER_76_103 VGND VGND VPWR VPWR sky130_fd_sc_hd__decap_3
XFILLER_94_35 VGND VGND VPWR VPWR sky130_fd_sc_hd__decap_3
XFILLER_17_225 VGND VGND VPWR VPWR sky130_fd_sc_hd__decap_3
XFILLER_84_180 VGND VGND VPWR VPWR sky130_fd_sc_hd__decap_3
XFILLER_91_128 VGND VGND VPWR VPWR sky130_fd_sc_hd__fill_2
XFILLER_94_79 VGND VGND VPWR VPWR sky130_fd_sc_hd__decap_3
XFILLER_150_41 VGND VGND VPWR VPWR sky130_fd_sc_hd__decap_3
XFILLER_27_84 VGND VGND VPWR VPWR sky130_fd_sc_hd__decap_3
XFILLER_43_72 VGND VGND VPWR VPWR sky130_fd_sc_hd__decap_3
XFILLER_175_60 VGND VGND VPWR VPWR sky130_fd_sc_hd__decap_3
XFILLER_153_163 VGND VGND VPWR VPWR sky130_fd_sc_hd__decap_3
XFILLER_175_93 VGND VGND VPWR VPWR sky130_fd_sc_hd__decap_3
XFILLER_99_228 VGND VGND VPWR VPWR sky130_fd_sc_hd__fill_2
XFILLER_4_162 VGND VGND VPWR VPWR sky130_fd_sc_hd__decap_3
X_1440_ Tile_X0Y0_OpenRAM_top.Inst_OpenRAM_top_switch_matrix.S2BEG2 VGND VGND VPWR
+ VPWR net600 sky130_fd_sc_hd__buf_2
X_1371_ Tile_X0Y0_OpenRAM_top.Inst_OpenRAM_top_switch_matrix.W6BEG5 VGND VGND VPWR
+ VPWR net533 sky130_fd_sc_hd__clkbuf_1
XFILLER_4_44 VGND VGND VPWR VPWR sky130_fd_sc_hd__decap_3
XFILLER_4_77 VGND VGND VPWR VPWR sky130_fd_sc_hd__decap_3
XFILLER_4_195 VGND VGND VPWR VPWR sky130_fd_sc_hd__fill_1
X_0322_ net85 net77 net95 net259 Tile_X0Y0_OpenRAM_top.Inst_OpenRAM_top_ConfigMem.Inst_frame8_bit20.Q
+ Tile_X0Y0_OpenRAM_top.Inst_OpenRAM_top_ConfigMem.Inst_frame8_bit21.Q VGND VGND VPWR
+ VPWR Tile_X0Y0_OpenRAM_top.Inst_OpenRAM_top_switch_matrix.N2BEG0 sky130_fd_sc_hd__mux4_1
XFILLER_4_88 VGND VGND VPWR VPWR sky130_fd_sc_hd__decap_3
XFILLER_68_80 VGND VGND VPWR VPWR sky130_fd_sc_hd__decap_3
XFILLER_68_91 VGND VGND VPWR VPWR sky130_fd_sc_hd__fill_2
Xinput280 Tile_X0Y1_N4END[6] VGND VGND VPWR VPWR net363 sky130_fd_sc_hd__clkbuf_4
XFILLER_67_169 VGND VGND VPWR VPWR sky130_fd_sc_hd__decap_3
X_0253_ Tile_X0Y1_OpenRAM_bot.Inst_OpenRAM_bot_ConfigMem.Inst_frame1_bit0.Q VGND VGND
+ VPWR VPWR _0026_ sky130_fd_sc_hd__inv_2
XFILLER_82_128 VGND VGND VPWR VPWR sky130_fd_sc_hd__decap_3
XFILLER_90_172 VGND VGND VPWR VPWR sky130_fd_sc_hd__decap_3
XFILLER_176_200 VGND VGND VPWR VPWR sky130_fd_sc_hd__decap_3
XFILLER_136_119 VGND VGND VPWR VPWR sky130_fd_sc_hd__decap_3
XFILLER_144_141 VGND VGND VPWR VPWR sky130_fd_sc_hd__decap_3
XFILLER_144_174 VGND VGND VPWR VPWR sky130_fd_sc_hd__decap_3
XFILLER_171_18 VGND VGND VPWR VPWR sky130_fd_sc_hd__decap_3
XFILLER_100_200 VGND VGND VPWR VPWR sky130_fd_sc_hd__decap_3
XFILLER_58_147 VGND VGND VPWR VPWR sky130_fd_sc_hd__decap_3
XTAP_TAPCELL_ROW_164_1028 VGND VPWR sky130_fd_sc_hd__tapvpwrvgnd_1
XFILLER_104_12 VGND VGND VPWR VPWR sky130_fd_sc_hd__decap_3
XFILLER_104_56 VGND VGND VPWR VPWR sky130_fd_sc_hd__decap_3
XFILLER_64_27 VGND VGND VPWR VPWR sky130_fd_sc_hd__fill_1
XFILLER_73_128 VGND VGND VPWR VPWR sky130_fd_sc_hd__decap_3
XFILLER_120_11 VGND VGND VPWR VPWR sky130_fd_sc_hd__decap_3
XFILLER_14_206 VGND VGND VPWR VPWR sky130_fd_sc_hd__decap_3
XFILLER_167_211 VGND VGND VPWR VPWR sky130_fd_sc_hd__decap_3
XTAP_TAPCELL_ROW_12_418 VGND VPWR sky130_fd_sc_hd__tapvpwrvgnd_1
XFILLER_80_26 VGND VGND VPWR VPWR sky130_fd_sc_hd__fill_2
XFILLER_13_42 VGND VGND VPWR VPWR sky130_fd_sc_hd__decap_3
XFILLER_182_225 VGND VGND VPWR VPWR sky130_fd_sc_hd__fill_1
XFILLER_127_119 VGND VGND VPWR VPWR sky130_fd_sc_hd__decap_3
XFILLER_127_108 VGND VGND VPWR VPWR sky130_fd_sc_hd__decap_3
XFILLER_129_75 VGND VGND VPWR VPWR sky130_fd_sc_hd__decap_3
XTAP_TAPCELL_ROW_20_451 VGND VPWR sky130_fd_sc_hd__tapvpwrvgnd_1
XFILLER_89_57 VGND VGND VPWR VPWR sky130_fd_sc_hd__decap_3
XFILLER_135_196 VGND VGND VPWR VPWR sky130_fd_sc_hd__fill_1
XFILLER_96_209 VGND VGND VPWR VPWR sky130_fd_sc_hd__fill_1
XFILLER_150_177 VGND VGND VPWR VPWR sky130_fd_sc_hd__decap_3
XFILLER_145_85 VGND VGND VPWR VPWR sky130_fd_sc_hd__decap_3
XFILLER_1_187 VGND VGND VPWR VPWR sky130_fd_sc_hd__decap_3
XFILLER_49_125 VGND VGND VPWR VPWR sky130_fd_sc_hd__decap_3
XFILLER_161_40 VGND VGND VPWR VPWR sky130_fd_sc_hd__decap_3
XFILLER_49_158 VGND VGND VPWR VPWR sky130_fd_sc_hd__decap_3
XFILLER_49_169 VGND VGND VPWR VPWR sky130_fd_sc_hd__decap_3
XFILLER_64_106 VGND VGND VPWR VPWR sky130_fd_sc_hd__decap_3
XFILLER_161_73 VGND VGND VPWR VPWR sky130_fd_sc_hd__decap_3
XFILLER_38_94 VGND VGND VPWR VPWR sky130_fd_sc_hd__decap_3
XFILLER_64_139 VGND VGND VPWR VPWR sky130_fd_sc_hd__fill_1
XTAP_TAPCELL_ROW_43_543 VGND VPWR sky130_fd_sc_hd__tapvpwrvgnd_1
XFILLER_54_71 VGND VGND VPWR VPWR sky130_fd_sc_hd__fill_1
XFILLER_72_194 VGND VGND VPWR VPWR sky130_fd_sc_hd__fill_2
X_0940_ net142 net276 VGND VGND VPWR VPWR Tile_X0Y0_OpenRAM_top.Inst_OpenRAM_top_ConfigMem.Inst_frame7_bit6.Q
+ sky130_fd_sc_hd__dlxtp_1
XFILLER_158_200 VGND VGND VPWR VPWR sky130_fd_sc_hd__decap_3
XFILLER_20_209 VGND VGND VPWR VPWR sky130_fd_sc_hd__decap_3
XFILLER_173_214 VGND VGND VPWR VPWR sky130_fd_sc_hd__decap_3
X_0871_ net116 net293 VGND VGND VPWR VPWR Tile_X0Y0_OpenRAM_top.Inst_OpenRAM_top_ConfigMem.Inst_frame5_bit11.Q
+ sky130_fd_sc_hd__dlxtp_1
XFILLER_118_108 VGND VGND VPWR VPWR sky130_fd_sc_hd__decap_3
XFILLER_173_225 VGND VGND VPWR VPWR sky130_fd_sc_hd__decap_3
XFILLER_141_111 VGND VGND VPWR VPWR sky130_fd_sc_hd__fill_1
XFILLER_126_174 VGND VGND VPWR VPWR sky130_fd_sc_hd__decap_3
XFILLER_141_122 VGND VGND VPWR VPWR sky130_fd_sc_hd__fill_2
X_1423_ net243 VGND VGND VPWR VPWR net575 sky130_fd_sc_hd__buf_6
X_1354_ Tile_X0Y0_OpenRAM_top.Inst_OpenRAM_top_switch_matrix.W2BEG4 VGND VGND VPWR
+ VPWR net514 sky130_fd_sc_hd__clkbuf_2
X_0305_ net68 net87 Tile_X0Y0_OpenRAM_top.Inst_OpenRAM_top_switch_matrix.J_NS4_BEG14
+ _0069_ Tile_X0Y0_OpenRAM_top.Inst_OpenRAM_top_ConfigMem.Inst_frame7_bit20.Q Tile_X0Y0_OpenRAM_top.Inst_OpenRAM_top_ConfigMem.Inst_frame7_bit21.Q
+ VGND VGND VPWR VPWR _0070_ sky130_fd_sc_hd__mux4_2
X_1285_ net134 VGND VGND VPWR VPWR net437 sky130_fd_sc_hd__clkbuf_2
XFILLER_55_106 VGND VGND VPWR VPWR sky130_fd_sc_hd__decap_3
X_0236_ Tile_X0Y0_OpenRAM_top.Inst_OpenRAM_top_ConfigMem.Inst_frame1_bit0.Q VGND VGND
+ VPWR VPWR _0009_ sky130_fd_sc_hd__inv_2
XFILLER_48_180 VGND VGND VPWR VPWR sky130_fd_sc_hd__decap_3
XFILLER_55_139 VGND VGND VPWR VPWR sky130_fd_sc_hd__decap_3
XTAP_TAPCELL_ROW_66_635 VGND VPWR sky130_fd_sc_hd__tapvpwrvgnd_1
XFILLER_63_172 VGND VGND VPWR VPWR sky130_fd_sc_hd__decap_3
XFILLER_70_109 VGND VGND VPWR VPWR sky130_fd_sc_hd__decap_3
XPHY_EDGE_ROW_178_Right_178 VGND VGND VPWR VPWR sky130_fd_sc_hd__decap_3
XFILLER_109_119 VGND VGND VPWR VPWR sky130_fd_sc_hd__decap_3
XFILLER_50_29 VGND VGND VPWR VPWR sky130_fd_sc_hd__decap_3
XFILLER_166_29 VGND VGND VPWR VPWR sky130_fd_sc_hd__decap_3
XFILLER_166_18 VGND VGND VPWR VPWR sky130_fd_sc_hd__decap_3
XFILLER_117_152 VGND VGND VPWR VPWR sky130_fd_sc_hd__decap_3
XFILLER_132_122 VGND VGND VPWR VPWR sky130_fd_sc_hd__decap_3
XFILLER_117_196 VGND VGND VPWR VPWR sky130_fd_sc_hd__decap_3
Xoutput551 net634 VGND VGND VPWR VPWR Tile_X0Y1_W2BEGb[0] sky130_fd_sc_hd__buf_2
Xoutput540 net623 VGND VGND VPWR VPWR Tile_X0Y1_W1BEG[1] sky130_fd_sc_hd__buf_2
XFILLER_1_9 VGND VGND VPWR VPWR sky130_fd_sc_hd__decap_3
Xoutput562 net645 VGND VGND VPWR VPWR Tile_X0Y1_W6BEG[1] sky130_fd_sc_hd__buf_2
XFILLER_59_49 VGND VGND VPWR VPWR sky130_fd_sc_hd__decap_3
XFILLER_78_209 VGND VGND VPWR VPWR sky130_fd_sc_hd__decap_3
XFILLER_132_177 VGND VGND VPWR VPWR sky130_fd_sc_hd__decap_3
Xoutput584 net667 VGND VGND VPWR VPWR Tile_X0Y1_WW4BEG[7] sky130_fd_sc_hd__buf_2
Xoutput573 net656 VGND VGND VPWR VPWR Tile_X0Y1_WW4BEG[11] sky130_fd_sc_hd__buf_2
XTAP_TAPCELL_ROW_89_727 VGND VPWR sky130_fd_sc_hd__tapvpwrvgnd_1
XFILLER_115_22 VGND VGND VPWR VPWR sky130_fd_sc_hd__fill_2
XFILLER_115_66 VGND VGND VPWR VPWR sky130_fd_sc_hd__decap_3
XTAP_TAPCELL_ROW_97_760 VGND VPWR sky130_fd_sc_hd__tapvpwrvgnd_1
Xfanout288 net290 VGND VGND VPWR VPWR net288 sky130_fd_sc_hd__clkbuf_2
Xfanout277 Tile_X0Y1_FrameStrobe[7] VGND VGND VPWR VPWR net277 sky130_fd_sc_hd__clkbuf_4
XFILLER_75_15 VGND VGND VPWR VPWR sky130_fd_sc_hd__decap_3
XFILLER_75_37 VGND VGND VPWR VPWR sky130_fd_sc_hd__decap_3
Xfanout266 net267 VGND VGND VPWR VPWR net266 sky130_fd_sc_hd__buf_2
Xfanout299 Tile_X0Y1_FrameStrobe[4] VGND VGND VPWR VPWR net299 sky130_fd_sc_hd__buf_2
XFILLER_115_99 VGND VGND VPWR VPWR sky130_fd_sc_hd__fill_1
XFILLER_131_21 VGND VGND VPWR VPWR sky130_fd_sc_hd__decap_3
XFILLER_131_54 VGND VGND VPWR VPWR sky130_fd_sc_hd__fill_2
XFILLER_54_150 VGND VGND VPWR VPWR sky130_fd_sc_hd__decap_3
XFILLER_131_87 VGND VGND VPWR VPWR sky130_fd_sc_hd__decap_3
XFILLER_54_183 VGND VGND VPWR VPWR sky130_fd_sc_hd__decap_3
XFILLER_91_36 VGND VGND VPWR VPWR sky130_fd_sc_hd__decap_3
XFILLER_24_41 VGND VGND VPWR VPWR sky130_fd_sc_hd__decap_3
XPHY_EDGE_ROW_145_Right_145 VGND VGND VPWR VPWR sky130_fd_sc_hd__decap_3
XFILLER_24_85 VGND VGND VPWR VPWR sky130_fd_sc_hd__decap_3
XTAP_TAPCELL_ROW_80_693 VGND VPWR sky130_fd_sc_hd__tapvpwrvgnd_1
XFILLER_155_225 VGND VGND VPWR VPWR sky130_fd_sc_hd__decap_3
XFILLER_170_206 VGND VGND VPWR VPWR sky130_fd_sc_hd__decap_3
XFILLER_108_130 VGND VGND VPWR VPWR sky130_fd_sc_hd__decap_3
XFILLER_156_62 VGND VGND VPWR VPWR sky130_fd_sc_hd__decap_3
XFILLER_123_111 VGND VGND VPWR VPWR sky130_fd_sc_hd__fill_1
XFILLER_108_174 VGND VGND VPWR VPWR sky130_fd_sc_hd__decap_3
XFILLER_123_155 VGND VGND VPWR VPWR sky130_fd_sc_hd__decap_3
XFILLER_172_50 VGND VGND VPWR VPWR sky130_fd_sc_hd__decap_3
XFILLER_123_199 VGND VGND VPWR VPWR sky130_fd_sc_hd__decap_3
XFILLER_49_60 VGND VGND VPWR VPWR sky130_fd_sc_hd__decap_3
XFILLER_77_231 VGND VGND VPWR VPWR sky130_fd_sc_hd__decap_3
XFILLER_172_83 VGND VGND VPWR VPWR sky130_fd_sc_hd__fill_1
XFILLER_1_12 VGND VGND VPWR VPWR sky130_fd_sc_hd__decap_3
XFILLER_49_93 VGND VGND VPWR VPWR sky130_fd_sc_hd__decap_3
XFILLER_172_94 VGND VGND VPWR VPWR sky130_fd_sc_hd__decap_3
XFILLER_37_117 VGND VGND VPWR VPWR sky130_fd_sc_hd__decap_3
XFILLER_92_212 VGND VGND VPWR VPWR sky130_fd_sc_hd__decap_3
X_1070_ net238 net304 VGND VGND VPWR VPWR Tile_X0Y1_OpenRAM_bot.Inst_OpenRAM_bot_ConfigMem.Inst_frame3_bit24.Q
+ sky130_fd_sc_hd__dlxtp_1
XTAP_TAPCELL_ROW_115_831 VGND VPWR sky130_fd_sc_hd__tapvpwrvgnd_1
XFILLER_45_172 VGND VGND VPWR VPWR sky130_fd_sc_hd__decap_3
XFILLER_65_81 VGND VGND VPWR VPWR sky130_fd_sc_hd__decap_3
XFILLER_60_153 VGND VGND VPWR VPWR sky130_fd_sc_hd__decap_3
XFILLER_81_80 VGND VGND VPWR VPWR sky130_fd_sc_hd__decap_3
X_0923_ net129 net274 VGND VGND VPWR VPWR Tile_X0Y0_OpenRAM_top.Inst_OpenRAM_top_ConfigMem.Inst_frame7_bit23.Q
+ sky130_fd_sc_hd__dlxtp_1
XPHY_EDGE_ROW_112_Right_112 VGND VGND VPWR VPWR sky130_fd_sc_hd__decap_3
X_0854_ net134 net291 VGND VGND VPWR VPWR Tile_X0Y0_OpenRAM_top.Inst_OpenRAM_top_ConfigMem.Inst_frame5_bit28.Q
+ sky130_fd_sc_hd__dlxtp_1
XFILLER_161_228 VGND VGND VPWR VPWR sky130_fd_sc_hd__fill_2
X_0785_ net125 net317 VGND VGND VPWR VPWR Tile_X0Y0_OpenRAM_top.Inst_OpenRAM_top_ConfigMem.Inst_frame2_bit1.Q
+ sky130_fd_sc_hd__dlxtp_1
XFILLER_114_100 VGND VGND VPWR VPWR sky130_fd_sc_hd__decap_3
XPHY_EDGE_ROW_49_Right_49 VGND VGND VPWR VPWR sky130_fd_sc_hd__decap_3
XFILLER_114_133 VGND VGND VPWR VPWR sky130_fd_sc_hd__decap_3
XTAP_TAPCELL_ROW_138_923 VGND VPWR sky130_fd_sc_hd__tapvpwrvgnd_1
XFILLER_114_188 VGND VGND VPWR VPWR sky130_fd_sc_hd__decap_3
X_1406_ net225 VGND VGND VPWR VPWR net557 sky130_fd_sc_hd__clkbuf_2
X_1337_ Tile_X0Y0_OpenRAM_top.N4BEG_outbuf_8.A VGND VGND VPWR VPWR net503 sky130_fd_sc_hd__buf_4
XFILLER_28_106 VGND VGND VPWR VPWR sky130_fd_sc_hd__decap_3
X_1268_ net116 VGND VGND VPWR VPWR net419 sky130_fd_sc_hd__buf_1
XFILLER_45_29 VGND VGND VPWR VPWR sky130_fd_sc_hd__decap_3
XPHY_EDGE_ROW_58_Right_58 VGND VGND VPWR VPWR sky130_fd_sc_hd__decap_3
XFILLER_36_150 VGND VGND VPWR VPWR sky130_fd_sc_hd__decap_3
X_1199_ net237 net271 VGND VGND VPWR VPWR Tile_X0Y1_OpenRAM_bot.Inst_OpenRAM_bot_ConfigMem.Inst_frame7_bit23.Q
+ sky130_fd_sc_hd__dlxtp_1
XFILLER_36_183 VGND VGND VPWR VPWR sky130_fd_sc_hd__decap_3
XTAP_TAPCELL_ROW_121_856 VGND VPWR sky130_fd_sc_hd__tapvpwrvgnd_1
XFILLER_51_164 VGND VGND VPWR VPWR sky130_fd_sc_hd__decap_3
XFILLER_177_39 VGND VGND VPWR VPWR sky130_fd_sc_hd__decap_3
XPHY_EDGE_ROW_67_Right_67 VGND VGND VPWR VPWR sky130_fd_sc_hd__decap_3
XFILLER_10_21 VGND VGND VPWR VPWR sky130_fd_sc_hd__decap_3
XFILLER_3_205 VGND VGND VPWR VPWR sky130_fd_sc_hd__decap_3
XFILLER_10_32 VGND VGND VPWR VPWR sky130_fd_sc_hd__decap_3
Xoutput370 net453 VGND VGND VPWR VPWR Tile_X0Y0_FrameStrobe_O[13] sky130_fd_sc_hd__buf_2
XFILLER_126_32 VGND VGND VPWR VPWR sky130_fd_sc_hd__decap_3
XFILLER_120_103 VGND VGND VPWR VPWR sky130_fd_sc_hd__decap_3
XFILLER_105_155 VGND VGND VPWR VPWR sky130_fd_sc_hd__decap_3
XFILLER_10_65 VGND VGND VPWR VPWR sky130_fd_sc_hd__decap_3
Xoutput381 net464 VGND VGND VPWR VPWR Tile_X0Y0_FrameStrobe_O[5] sky130_fd_sc_hd__buf_2
Xoutput392 net475 VGND VGND VPWR VPWR Tile_X0Y0_N2BEG[2] sky130_fd_sc_hd__buf_2
XFILLER_105_199 VGND VGND VPWR VPWR sky130_fd_sc_hd__decap_3
XFILLER_120_169 VGND VGND VPWR VPWR sky130_fd_sc_hd__decap_3
XFILLER_19_52 VGND VGND VPWR VPWR sky130_fd_sc_hd__decap_3
XFILLER_74_212 VGND VGND VPWR VPWR sky130_fd_sc_hd__decap_3
XPHY_EDGE_ROW_76_Right_76 VGND VGND VPWR VPWR sky130_fd_sc_hd__decap_3
XTAP_TAPCELL_ROW_144_948 VGND VPWR sky130_fd_sc_hd__tapvpwrvgnd_1
XFILLER_142_53 VGND VGND VPWR VPWR sky130_fd_sc_hd__decap_3
XFILLER_142_97 VGND VGND VPWR VPWR sky130_fd_sc_hd__fill_2
XTAP_TAPCELL_ROW_152_981 VGND VPWR sky130_fd_sc_hd__tapvpwrvgnd_1
XFILLER_27_194 VGND VGND VPWR VPWR sky130_fd_sc_hd__decap_3
XFILLER_35_51 VGND VGND VPWR VPWR sky130_fd_sc_hd__decap_3
XFILLER_42_131 VGND VGND VPWR VPWR sky130_fd_sc_hd__decap_3
XFILLER_42_153 VGND VGND VPWR VPWR sky130_fd_sc_hd__fill_2
XFILLER_42_197 VGND VGND VPWR VPWR sky130_fd_sc_hd__decap_3
XFILLER_128_203 VGND VGND VPWR VPWR sky130_fd_sc_hd__decap_3
XPHY_EDGE_ROW_85_Right_85 VGND VGND VPWR VPWR sky130_fd_sc_hd__decap_3
XFILLER_167_72 VGND VGND VPWR VPWR sky130_fd_sc_hd__decap_3
XFILLER_167_94 VGND VGND VPWR VPWR sky130_fd_sc_hd__decap_3
XFILLER_143_206 VGND VGND VPWR VPWR sky130_fd_sc_hd__decap_3
X_0570_ net255 net358 _0063_ net171 Tile_X0Y1_OpenRAM_bot.Inst_OpenRAM_bot_ConfigMem.Inst_frame1_bit10.Q
+ Tile_X0Y1_OpenRAM_bot.Inst_OpenRAM_bot_ConfigMem.Inst_frame1_bit11.Q VGND VGND VPWR
+ VPWR _0155_ sky130_fd_sc_hd__mux4_2
XFILLER_111_136 VGND VGND VPWR VPWR sky130_fd_sc_hd__decap_3
XPHY_EDGE_ROW_94_Right_94 VGND VGND VPWR VPWR sky130_fd_sc_hd__decap_3
XFILLER_65_223 VGND VGND VPWR VPWR sky130_fd_sc_hd__fill_1
X_1122_ net248 net299 VGND VGND VPWR VPWR Tile_X0Y1_OpenRAM_bot.Inst_OpenRAM_bot_ConfigMem.Inst_frame4_bit4.Q
+ sky130_fd_sc_hd__dlxtp_1
XFILLER_76_80 VGND VGND VPWR VPWR sky130_fd_sc_hd__decap_3
XFILLER_76_91 VGND VGND VPWR VPWR sky130_fd_sc_hd__decap_3
X_1053_ net253 net313 VGND VGND VPWR VPWR Tile_X0Y1_OpenRAM_bot.Inst_OpenRAM_bot_ConfigMem.Inst_frame2_bit9.Q
+ sky130_fd_sc_hd__dlxtp_1
XFILLER_178_103 VGND VGND VPWR VPWR sky130_fd_sc_hd__decap_3
XFILLER_33_131 VGND VGND VPWR VPWR sky130_fd_sc_hd__decap_3
XFILLER_178_147 VGND VGND VPWR VPWR sky130_fd_sc_hd__decap_3
XFILLER_178_136 VGND VGND VPWR VPWR sky130_fd_sc_hd__decap_3
XPHY_EDGE_ROW_1_Left_184 VGND VGND VPWR VPWR sky130_fd_sc_hd__decap_3
X_0906_ net144 net284 VGND VGND VPWR VPWR Tile_X0Y0_OpenRAM_top.Inst_OpenRAM_top_ConfigMem.Inst_frame6_bit8.Q
+ sky130_fd_sc_hd__dlxtp_1
XFILLER_119_225 VGND VGND VPWR VPWR sky130_fd_sc_hd__fill_1
XFILLER_134_206 VGND VGND VPWR VPWR sky130_fd_sc_hd__decap_3
X_0837_ net118 net301 VGND VGND VPWR VPWR Tile_X0Y0_OpenRAM_top.Inst_OpenRAM_top_ConfigMem.Inst_frame4_bit13.Q
+ sky130_fd_sc_hd__dlxtp_1
X_0768_ net123 net317 VGND VGND VPWR VPWR Tile_X0Y0_OpenRAM_top.Inst_OpenRAM_top_ConfigMem.Inst_frame2_bit18.Q
+ sky130_fd_sc_hd__dlxtp_1
XFILLER_163_19 VGND VGND VPWR VPWR sky130_fd_sc_hd__fill_2
Xinput109 Tile_X0Y0_EE4END[5] VGND VGND VPWR VPWR net109 sky130_fd_sc_hd__buf_1
X_0699_ net129 net334 VGND VGND VPWR VPWR Tile_X0Y0_OpenRAM_top.Inst_OpenRAM_top_ConfigMem.Inst_frame0_bit23.Q
+ sky130_fd_sc_hd__dlxtp_1
XFILLER_102_147 VGND VGND VPWR VPWR sky130_fd_sc_hd__decap_3
XFILLER_56_223 VGND VGND VPWR VPWR sky130_fd_sc_hd__decap_3
XFILLER_16_109 VGND VGND VPWR VPWR sky130_fd_sc_hd__decap_3
XTAP_TAPCELL_ROW_82_700 VGND VPWR sky130_fd_sc_hd__tapvpwrvgnd_1
XFILLER_112_56 VGND VGND VPWR VPWR sky130_fd_sc_hd__decap_3
XFILLER_24_153 VGND VGND VPWR VPWR sky130_fd_sc_hd__decap_3
XFILLER_72_27 VGND VGND VPWR VPWR sky130_fd_sc_hd__fill_1
XFILLER_72_38 VGND VGND VPWR VPWR sky130_fd_sc_hd__decap_3
XFILLER_169_125 VGND VGND VPWR VPWR sky130_fd_sc_hd__decap_3
XFILLER_169_169 VGND VGND VPWR VPWR sky130_fd_sc_hd__decap_3
XFILLER_24_197 VGND VGND VPWR VPWR sky130_fd_sc_hd__decap_3
XFILLER_21_42 VGND VGND VPWR VPWR sky130_fd_sc_hd__decap_3
XFILLER_21_75 VGND VGND VPWR VPWR sky130_fd_sc_hd__decap_3
XFILLER_140_209 VGND VGND VPWR VPWR sky130_fd_sc_hd__decap_3
XFILLER_97_24 VGND VGND VPWR VPWR sky130_fd_sc_hd__decap_3
XFILLER_97_57 VGND VGND VPWR VPWR sky130_fd_sc_hd__decap_3
XFILLER_153_41 VGND VGND VPWR VPWR sky130_fd_sc_hd__decap_3
XFILLER_46_72 VGND VGND VPWR VPWR sky130_fd_sc_hd__decap_3
XFILLER_15_131 VGND VGND VPWR VPWR sky130_fd_sc_hd__decap_3
XFILLER_15_186 VGND VGND VPWR VPWR sky130_fd_sc_hd__decap_3
XFILLER_15_164 VGND VGND VPWR VPWR sky130_fd_sc_hd__decap_3
XFILLER_178_71 VGND VGND VPWR VPWR sky130_fd_sc_hd__decap_3
XFILLER_175_128 VGND VGND VPWR VPWR sky130_fd_sc_hd__decap_3
XFILLER_30_156 VGND VGND VPWR VPWR sky130_fd_sc_hd__decap_3
XFILLER_168_191 VGND VGND VPWR VPWR sky130_fd_sc_hd__decap_3
XFILLER_7_33 VGND VGND VPWR VPWR sky130_fd_sc_hd__decap_3
XFILLER_30_189 VGND VGND VPWR VPWR sky130_fd_sc_hd__decap_3
XFILLER_7_66 VGND VGND VPWR VPWR sky130_fd_sc_hd__decap_3
XFILLER_7_99 VGND VGND VPWR VPWR sky130_fd_sc_hd__decap_3
X_0622_ net188 Tile_X0Y1_OpenRAM_bot.Inst_OpenRAM_bot_ConfigMem.Inst_frame1_bit4.Q
+ Tile_X0Y1_OpenRAM_bot.Inst_OpenRAM_bot_ConfigMem.Inst_frame1_bit5.Q VGND VGND VPWR
+ VPWR _0169_ sky130_fd_sc_hd__o21ba_1
XFILLER_131_209 VGND VGND VPWR VPWR sky130_fd_sc_hd__decap_3
X_0553_ net29 net61 _0146_ net261 Tile_X0Y1_OpenRAM_bot.Inst_OpenRAM_bot_ConfigMem.Inst_frame5_bit26.Q
+ Tile_X0Y1_OpenRAM_bot.Inst_OpenRAM_bot_ConfigMem.Inst_frame5_bit27.Q VGND VGND VPWR
+ VPWR Tile_X0Y1_OpenRAM_bot.Inst_OpenRAM_bot_switch_matrix.WW4BEG5 sky130_fd_sc_hd__mux4_1
XFILLER_97_134 VGND VGND VPWR VPWR sky130_fd_sc_hd__decap_3
X_0484_ net68 Tile_X0Y0_OpenRAM_top.Inst_OpenRAM_top_switch_matrix.J_NS4_BEG6 Tile_X0Y0_OpenRAM_top.Inst_OpenRAM_top_ConfigMem.Inst_frame7_bit12.Q
+ VGND VGND VPWR VPWR _0126_ sky130_fd_sc_hd__mux2_1
XFILLER_97_156 VGND VGND VPWR VPWR sky130_fd_sc_hd__decap_3
XFILLER_38_201 VGND VGND VPWR VPWR sky130_fd_sc_hd__decap_3
X_1105_ net235 net299 VGND VGND VPWR VPWR Tile_X0Y1_OpenRAM_bot.Inst_OpenRAM_bot_ConfigMem.Inst_frame4_bit21.Q
+ sky130_fd_sc_hd__dlxtp_1
X_1036_ net240 net312 VGND VGND VPWR VPWR Tile_X0Y1_OpenRAM_bot.Inst_OpenRAM_bot_ConfigMem.Inst_frame2_bit26.Q
+ sky130_fd_sc_hd__dlxtp_1
XPHY_EDGE_ROW_46_Left_229 VGND VGND VPWR VPWR sky130_fd_sc_hd__decap_3
XFILLER_166_128 VGND VGND VPWR VPWR sky130_fd_sc_hd__decap_3
XFILLER_158_19 VGND VGND VPWR VPWR sky130_fd_sc_hd__decap_3
XFILLER_21_167 VGND VGND VPWR VPWR sky130_fd_sc_hd__fill_1
XFILLER_174_150 VGND VGND VPWR VPWR sky130_fd_sc_hd__decap_3
XFILLER_107_206 VGND VGND VPWR VPWR sky130_fd_sc_hd__fill_2
XFILLER_174_183 VGND VGND VPWR VPWR sky130_fd_sc_hd__decap_3
XFILLER_174_29 VGND VGND VPWR VPWR sky130_fd_sc_hd__decap_3
XFILLER_174_18 VGND VGND VPWR VPWR sky130_fd_sc_hd__decap_3
Xinput91 Tile_X0Y0_E6END[3] VGND VGND VPWR VPWR net91 sky130_fd_sc_hd__dlymetal6s2s_1
Xinput80 Tile_X0Y0_E2MID[2] VGND VGND VPWR VPWR net80 sky130_fd_sc_hd__dlymetal6s2s_1
XFILLER_101_9 VGND VGND VPWR VPWR sky130_fd_sc_hd__fill_1
XPHY_EDGE_ROW_55_Left_238 VGND VGND VPWR VPWR sky130_fd_sc_hd__decap_3
XFILLER_88_112 VGND VGND VPWR VPWR sky130_fd_sc_hd__fill_2
XFILLER_88_123 VGND VGND VPWR VPWR sky130_fd_sc_hd__decap_3
XFILLER_107_78 VGND VGND VPWR VPWR sky130_fd_sc_hd__decap_3
XFILLER_88_156 VGND VGND VPWR VPWR sky130_fd_sc_hd__decap_3
XFILLER_123_33 VGND VGND VPWR VPWR sky130_fd_sc_hd__decap_3
XFILLER_123_66 VGND VGND VPWR VPWR sky130_fd_sc_hd__decap_3
XTAP_TAPCELL_ROW_4_388 VGND VPWR sky130_fd_sc_hd__tapvpwrvgnd_1
XFILLER_83_15 VGND VGND VPWR VPWR sky130_fd_sc_hd__decap_3
XFILLER_123_99 VGND VGND VPWR VPWR sky130_fd_sc_hd__decap_3
XFILLER_83_48 VGND VGND VPWR VPWR sky130_fd_sc_hd__fill_2
XFILLER_16_53 VGND VGND VPWR VPWR sky130_fd_sc_hd__decap_3
XPHY_EDGE_ROW_64_Left_247 VGND VGND VPWR VPWR sky130_fd_sc_hd__decap_3
XTAP_TAPCELL_ROW_27_479 VGND VPWR sky130_fd_sc_hd__tapvpwrvgnd_1
XFILLER_16_97 VGND VGND VPWR VPWR sky130_fd_sc_hd__decap_3
XFILLER_8_127 VGND VGND VPWR VPWR sky130_fd_sc_hd__decap_3
XFILLER_148_41 VGND VGND VPWR VPWR sky130_fd_sc_hd__decap_3
XFILLER_32_41 VGND VGND VPWR VPWR sky130_fd_sc_hd__decap_3
XFILLER_172_109 VGND VGND VPWR VPWR sky130_fd_sc_hd__decap_3
XFILLER_165_172 VGND VGND VPWR VPWR sky130_fd_sc_hd__decap_3
XFILLER_165_161 VGND VGND VPWR VPWR sky130_fd_sc_hd__decap_3
XFILLER_32_85 VGND VGND VPWR VPWR sky130_fd_sc_hd__decap_3
XPHY_EDGE_ROW_73_Left_256 VGND VGND VPWR VPWR sky130_fd_sc_hd__decap_3
XFILLER_180_175 VGND VGND VPWR VPWR sky130_fd_sc_hd__decap_3
XFILLER_121_220 VGND VGND VPWR VPWR sky130_fd_sc_hd__fill_1
XFILLER_79_156 VGND VGND VPWR VPWR sky130_fd_sc_hd__decap_3
XFILLER_79_178 VGND VGND VPWR VPWR sky130_fd_sc_hd__decap_3
XFILLER_94_115 VGND VGND VPWR VPWR sky130_fd_sc_hd__decap_3
XFILLER_57_60 VGND VGND VPWR VPWR sky130_fd_sc_hd__fill_1
XFILLER_94_159 VGND VGND VPWR VPWR sky130_fd_sc_hd__decap_3
XFILLER_180_61 VGND VGND VPWR VPWR sky130_fd_sc_hd__decap_3
XFILLER_57_93 VGND VGND VPWR VPWR sky130_fd_sc_hd__decap_3
XFILLER_180_83 VGND VGND VPWR VPWR sky130_fd_sc_hd__fill_1
XPHY_EDGE_ROW_82_Left_265 VGND VGND VPWR VPWR sky130_fd_sc_hd__decap_3
XFILLER_148_106 VGND VGND VPWR VPWR sky130_fd_sc_hd__decap_3
XFILLER_148_139 VGND VGND VPWR VPWR sky130_fd_sc_hd__fill_1
XFILLER_78_3 VGND VGND VPWR VPWR sky130_fd_sc_hd__decap_3
XFILLER_163_109 VGND VGND VPWR VPWR sky130_fd_sc_hd__decap_3
XFILLER_156_150 VGND VGND VPWR VPWR sky130_fd_sc_hd__decap_3
XFILLER_171_131 VGND VGND VPWR VPWR sky130_fd_sc_hd__decap_3
XFILLER_7_193 VGND VGND VPWR VPWR sky130_fd_sc_hd__decap_3
XPHY_EDGE_ROW_91_Left_274 VGND VGND VPWR VPWR sky130_fd_sc_hd__decap_3
XFILLER_171_164 VGND VGND VPWR VPWR sky130_fd_sc_hd__decap_3
XFILLER_104_209 VGND VGND VPWR VPWR sky130_fd_sc_hd__decap_3
XFILLER_171_175 VGND VGND VPWR VPWR sky130_fd_sc_hd__decap_3
X_0605_ net217 net210 net201 _0151_ Tile_X0Y1_OpenRAM_bot.Inst_OpenRAM_bot_ConfigMem.Inst_frame2_bit6.Q
+ Tile_X0Y1_OpenRAM_bot.Inst_OpenRAM_bot_ConfigMem.Inst_frame2_bit7.Q VGND VGND VPWR
+ VPWR net412 sky130_fd_sc_hd__mux4_1
X_0536_ net30 net62 net262 _0086_ Tile_X0Y1_OpenRAM_bot.Inst_OpenRAM_bot_ConfigMem.Inst_frame6_bit28.Q
+ Tile_X0Y1_OpenRAM_bot.Inst_OpenRAM_bot_ConfigMem.Inst_frame6_bit29.Q VGND VGND VPWR
+ VPWR Tile_X0Y1_OpenRAM_bot.Inst_OpenRAM_bot_switch_matrix.W2BEG6 sky130_fd_sc_hd__mux4_1
X_0467_ net73 Tile_X0Y0_OpenRAM_top.Inst_OpenRAM_top_ConfigMem.Inst_frame1_bit6.Q
+ VGND VGND VPWR VPWR _0112_ sky130_fd_sc_hd__nand2_1
X_0398_ net18 net50 Tile_X0Y0_OpenRAM_top.Inst_OpenRAM_top_switch_matrix.J_NS4_BEG8
+ Tile_X0Y0_OpenRAM_top.Inst_OpenRAM_top_switch_matrix.J_NS2_BEG0 Tile_X0Y0_OpenRAM_top.Inst_OpenRAM_top_ConfigMem.Inst_frame4_bit10.Q
+ Tile_X0Y0_OpenRAM_top.Inst_OpenRAM_top_ConfigMem.Inst_frame4_bit11.Q VGND VGND VPWR
+ VPWR Tile_X0Y0_OpenRAM_top.Inst_OpenRAM_top_switch_matrix.WW4BEG7 sky130_fd_sc_hd__mux4_1
XFILLER_53_18 VGND VGND VPWR VPWR sky130_fd_sc_hd__decap_3
XFILLER_169_18 VGND VGND VPWR VPWR sky130_fd_sc_hd__decap_3
X_1019_ net224 net324 VGND VGND VPWR VPWR Tile_X0Y1_OpenRAM_bot.Inst_OpenRAM_bot_ConfigMem.Inst_frame1_bit11.Q
+ sky130_fd_sc_hd__dlxtp_1
XFILLER_139_106 VGND VGND VPWR VPWR sky130_fd_sc_hd__decap_3
XFILLER_147_161 VGND VGND VPWR VPWR sky130_fd_sc_hd__decap_3
XFILLER_5_119 VGND VGND VPWR VPWR sky130_fd_sc_hd__decap_3
XFILLER_5_108 VGND VGND VPWR VPWR sky130_fd_sc_hd__decap_3
XTAP_TAPCELL_ROW_173_1063 VGND VPWR sky130_fd_sc_hd__tapvpwrvgnd_1
XFILLER_118_11 VGND VGND VPWR VPWR sky130_fd_sc_hd__decap_3
XFILLER_118_44 VGND VGND VPWR VPWR sky130_fd_sc_hd__decap_3
XFILLER_78_15 VGND VGND VPWR VPWR sky130_fd_sc_hd__decap_3
XFILLER_162_197 VGND VGND VPWR VPWR sky130_fd_sc_hd__decap_3
XFILLER_118_99 VGND VGND VPWR VPWR sky130_fd_sc_hd__fill_2
XFILLER_103_220 VGND VGND VPWR VPWR sky130_fd_sc_hd__decap_3
XFILLER_78_59 VGND VGND VPWR VPWR sky130_fd_sc_hd__decap_3
XFILLER_134_32 VGND VGND VPWR VPWR sky130_fd_sc_hd__decap_3
XFILLER_76_115 VGND VGND VPWR VPWR sky130_fd_sc_hd__decap_3
XFILLER_76_137 VGND VGND VPWR VPWR sky130_fd_sc_hd__decap_3
XFILLER_182_3 VGND VGND VPWR VPWR sky130_fd_sc_hd__decap_3
XFILLER_134_98 VGND VGND VPWR VPWR sky130_fd_sc_hd__decap_3
XFILLER_27_30 VGND VGND VPWR VPWR sky130_fd_sc_hd__fill_1
XFILLER_27_52 VGND VGND VPWR VPWR sky130_fd_sc_hd__decap_3
XFILLER_27_63 VGND VGND VPWR VPWR sky130_fd_sc_hd__decap_3
XFILLER_150_53 VGND VGND VPWR VPWR sky130_fd_sc_hd__decap_3
XFILLER_27_96 VGND VGND VPWR VPWR sky130_fd_sc_hd__decap_3
XFILLER_84_192 VGND VGND VPWR VPWR sky130_fd_sc_hd__decap_3
XFILLER_32_218 VGND VGND VPWR VPWR sky130_fd_sc_hd__decap_3
XFILLER_43_40 VGND VGND VPWR VPWR sky130_fd_sc_hd__decap_3
XFILLER_43_84 VGND VGND VPWR VPWR sky130_fd_sc_hd__decap_3
XFILLER_145_109 VGND VGND VPWR VPWR sky130_fd_sc_hd__decap_3
XFILLER_138_150 VGND VGND VPWR VPWR sky130_fd_sc_hd__decap_3
XFILLER_138_183 VGND VGND VPWR VPWR sky130_fd_sc_hd__decap_3
XFILLER_153_142 VGND VGND VPWR VPWR sky130_fd_sc_hd__decap_3
XFILLER_99_207 VGND VGND VPWR VPWR sky130_fd_sc_hd__decap_3
XFILLER_4_130 VGND VGND VPWR VPWR sky130_fd_sc_hd__decap_3
XFILLER_4_141 VGND VGND VPWR VPWR sky130_fd_sc_hd__decap_3
XFILLER_175_72 VGND VGND VPWR VPWR sky130_fd_sc_hd__decap_3
XFILLER_153_175 VGND VGND VPWR VPWR sky130_fd_sc_hd__decap_3
XFILLER_4_12 VGND VGND VPWR VPWR sky130_fd_sc_hd__decap_3
XFILLER_4_174 VGND VGND VPWR VPWR sky130_fd_sc_hd__decap_3
X_1370_ Tile_X0Y0_OpenRAM_top.Inst_OpenRAM_top_switch_matrix.W6BEG4 VGND VGND VPWR
+ VPWR net532 sky130_fd_sc_hd__buf_1
XFILLER_4_56 VGND VGND VPWR VPWR sky130_fd_sc_hd__decap_3
X_0321_ net69 net95 Tile_X0Y0_OpenRAM_top.Inst_OpenRAM_top_switch_matrix.J_NS4_BEG15
+ _0076_ Tile_X0Y0_OpenRAM_top.Inst_OpenRAM_top_ConfigMem.Inst_frame8_bit18.Q Tile_X0Y0_OpenRAM_top.Inst_OpenRAM_top_ConfigMem.Inst_frame8_bit19.Q
+ VGND VGND VPWR VPWR Tile_X0Y0_OpenRAM_top.Inst_OpenRAM_top_switch_matrix.N1BEG3
+ sky130_fd_sc_hd__mux4_1
XFILLER_67_137 VGND VGND VPWR VPWR sky130_fd_sc_hd__decap_3
Xinput281 Tile_X0Y1_N4END[7] VGND VGND VPWR VPWR net364 sky130_fd_sc_hd__clkbuf_4
Xinput270 Tile_X0Y1_N2MID[4] VGND VGND VPWR VPWR net353 sky130_fd_sc_hd__clkbuf_2
X_0252_ Tile_X0Y1_OpenRAM_bot.Inst_OpenRAM_bot_ConfigMem.Inst_frame3_bit26.Q VGND
+ VGND VPWR VPWR _0025_ sky130_fd_sc_hd__inv_2
XFILLER_82_107 VGND VGND VPWR VPWR sky130_fd_sc_hd__decap_3
XFILLER_75_181 VGND VGND VPWR VPWR sky130_fd_sc_hd__decap_3
XPHY_EDGE_ROW_159_Right_159 VGND VGND VPWR VPWR sky130_fd_sc_hd__decap_3
XFILLER_84_91 VGND VGND VPWR VPWR sky130_fd_sc_hd__decap_3
XFILLER_23_218 VGND VGND VPWR VPWR sky130_fd_sc_hd__decap_3
XFILLER_90_151 VGND VGND VPWR VPWR sky130_fd_sc_hd__decap_3
XFILLER_90_184 VGND VGND VPWR VPWR sky130_fd_sc_hd__decap_3
XFILLER_90_195 VGND VGND VPWR VPWR sky130_fd_sc_hd__fill_1
XFILLER_176_212 VGND VGND VPWR VPWR sky130_fd_sc_hd__decap_3
XFILLER_129_161 VGND VGND VPWR VPWR sky130_fd_sc_hd__decap_3
XFILLER_144_153 VGND VGND VPWR VPWR sky130_fd_sc_hd__decap_3
XFILLER_144_197 VGND VGND VPWR VPWR sky130_fd_sc_hd__decap_3
XFILLER_144_186 VGND VGND VPWR VPWR sky130_fd_sc_hd__decap_3
XPHY_EDGE_ROW_129_Left_312 VGND VGND VPWR VPWR sky130_fd_sc_hd__decap_3
XFILLER_48_18 VGND VGND VPWR VPWR sky130_fd_sc_hd__decap_3
XFILLER_48_29 VGND VGND VPWR VPWR sky130_fd_sc_hd__decap_3
X_1499_ Tile_X0Y1_OpenRAM_bot.Inst_OpenRAM_bot_switch_matrix.WW4BEG5 VGND VGND VPWR
+ VPWR net665 sky130_fd_sc_hd__buf_1
XFILLER_58_137 VGND VGND VPWR VPWR sky130_fd_sc_hd__decap_3
X_0519_ net192 net184 net205 _0081_ Tile_X0Y1_OpenRAM_bot.Inst_OpenRAM_bot_ConfigMem.Inst_frame7_bit14.Q
+ Tile_X0Y1_OpenRAM_bot.Inst_OpenRAM_bot_ConfigMem.Inst_frame7_bit15.Q VGND VGND VPWR
+ VPWR Tile_X0Y1_OpenRAM_bot.Inst_OpenRAM_bot_switch_matrix.S2BEG1 sky130_fd_sc_hd__mux4_1
XTAP_TAPCELL_ROW_164_1029 VGND VPWR sky130_fd_sc_hd__tapvpwrvgnd_1
XFILLER_104_35 VGND VGND VPWR VPWR sky130_fd_sc_hd__decap_3
XFILLER_104_24 VGND VGND VPWR VPWR sky130_fd_sc_hd__decap_3
XFILLER_58_159 VGND VGND VPWR VPWR sky130_fd_sc_hd__decap_3
XFILLER_73_107 VGND VGND VPWR VPWR sky130_fd_sc_hd__decap_3
XFILLER_104_68 VGND VGND VPWR VPWR sky130_fd_sc_hd__decap_3
XPHY_EDGE_ROW_126_Right_126 VGND VGND VPWR VPWR sky130_fd_sc_hd__decap_3
XFILLER_81_140 VGND VGND VPWR VPWR sky130_fd_sc_hd__decap_3
XFILLER_14_218 VGND VGND VPWR VPWR sky130_fd_sc_hd__decap_3
XFILLER_81_162 VGND VGND VPWR VPWR sky130_fd_sc_hd__decap_3
XFILLER_167_223 VGND VGND VPWR VPWR sky130_fd_sc_hd__fill_1
XPHY_EDGE_ROW_138_Left_321 VGND VGND VPWR VPWR sky130_fd_sc_hd__decap_3
XFILLER_120_78 VGND VGND VPWR VPWR sky130_fd_sc_hd__decap_3
XFILLER_13_21 VGND VGND VPWR VPWR sky130_fd_sc_hd__decap_3
XTAP_TAPCELL_ROW_12_419 VGND VPWR sky130_fd_sc_hd__tapvpwrvgnd_1
XFILLER_129_21 VGND VGND VPWR VPWR sky130_fd_sc_hd__decap_3
XFILLER_13_54 VGND VGND VPWR VPWR sky130_fd_sc_hd__fill_2
XFILLER_129_54 VGND VGND VPWR VPWR sky130_fd_sc_hd__fill_2
XTAP_TAPCELL_ROW_20_452 VGND VPWR sky130_fd_sc_hd__tapvpwrvgnd_1
XFILLER_135_153 VGND VGND VPWR VPWR sky130_fd_sc_hd__decap_3
XFILLER_135_131 VGND VGND VPWR VPWR sky130_fd_sc_hd__decap_3
XFILLER_129_87 VGND VGND VPWR VPWR sky130_fd_sc_hd__decap_3
XFILLER_150_156 VGND VGND VPWR VPWR sky130_fd_sc_hd__decap_3
XFILLER_150_134 VGND VGND VPWR VPWR sky130_fd_sc_hd__decap_3
XPHY_EDGE_ROW_147_Left_330 VGND VGND VPWR VPWR sky130_fd_sc_hd__decap_3
XFILLER_145_42 VGND VGND VPWR VPWR sky130_fd_sc_hd__decap_3
XFILLER_8_3 VGND VGND VPWR VPWR sky130_fd_sc_hd__decap_3
XFILLER_1_111 VGND VGND VPWR VPWR sky130_fd_sc_hd__fill_1
XFILLER_150_189 VGND VGND VPWR VPWR sky130_fd_sc_hd__decap_3
XFILLER_1_166 VGND VGND VPWR VPWR sky130_fd_sc_hd__fill_2
XFILLER_1_199 VGND VGND VPWR VPWR sky130_fd_sc_hd__decap_3
XFILLER_49_137 VGND VGND VPWR VPWR sky130_fd_sc_hd__decap_3
XFILLER_161_63 VGND VGND VPWR VPWR sky130_fd_sc_hd__decap_3
XFILLER_161_52 VGND VGND VPWR VPWR sky130_fd_sc_hd__decap_3
XFILLER_64_118 VGND VGND VPWR VPWR sky130_fd_sc_hd__decap_3
XFILLER_161_96 VGND VGND VPWR VPWR sky130_fd_sc_hd__fill_2
XFILLER_57_181 VGND VGND VPWR VPWR sky130_fd_sc_hd__decap_3
XFILLER_54_50 VGND VGND VPWR VPWR sky130_fd_sc_hd__decap_3
XFILLER_72_162 VGND VGND VPWR VPWR sky130_fd_sc_hd__decap_3
XFILLER_158_212 VGND VGND VPWR VPWR sky130_fd_sc_hd__fill_1
XTAP_TAPCELL_ROW_43_544 VGND VPWR sky130_fd_sc_hd__tapvpwrvgnd_1
XFILLER_9_211 VGND VGND VPWR VPWR sky130_fd_sc_hd__decap_3
X_0870_ net117 net295 VGND VGND VPWR VPWR Tile_X0Y0_OpenRAM_top.Inst_OpenRAM_top_ConfigMem.Inst_frame5_bit12.Q
+ sky130_fd_sc_hd__dlxtp_1
XFILLER_70_82 VGND VGND VPWR VPWR sky130_fd_sc_hd__fill_2
XFILLER_126_186 VGND VGND VPWR VPWR sky130_fd_sc_hd__decap_3
XFILLER_141_145 VGND VGND VPWR VPWR sky130_fd_sc_hd__fill_2
XFILLER_126_197 VGND VGND VPWR VPWR sky130_fd_sc_hd__decap_3
X_1422_ net242 VGND VGND VPWR VPWR net574 sky130_fd_sc_hd__buf_6
X_1353_ Tile_X0Y0_OpenRAM_top.Inst_OpenRAM_top_switch_matrix.W2BEG3 VGND VGND VPWR
+ VPWR net513 sky130_fd_sc_hd__buf_1
X_1284_ net133 VGND VGND VPWR VPWR net436 sky130_fd_sc_hd__clkbuf_1
X_0304_ Tile_X0Y0_OpenRAM_top.Inst_OpenRAM_top_ConfigMem.Inst_frame0_bit28.Q _0068_
+ _0003_ _0067_ VGND VGND VPWR VPWR _0069_ sky130_fd_sc_hd__a2bb2o_1
X_0235_ Tile_X0Y0_OpenRAM_top.Inst_OpenRAM_top_ConfigMem.Inst_frame2_bit30.Q VGND
+ VGND VPWR VPWR _0008_ sky130_fd_sc_hd__inv_2
XTAP_TAPCELL_ROW_66_636 VGND VPWR sky130_fd_sc_hd__tapvpwrvgnd_1
XFILLER_48_192 VGND VGND VPWR VPWR sky130_fd_sc_hd__decap_3
XFILLER_63_151 VGND VGND VPWR VPWR sky130_fd_sc_hd__decap_3
XFILLER_63_184 VGND VGND VPWR VPWR sky130_fd_sc_hd__decap_3
XFILLER_164_215 VGND VGND VPWR VPWR sky130_fd_sc_hd__decap_3
X_0999_ net246 net322 VGND VGND VPWR VPWR Tile_X0Y1_OpenRAM_bot.Inst_OpenRAM_bot_ConfigMem.Inst_frame1_bit31.Q
+ sky130_fd_sc_hd__dlxtp_1
XFILLER_117_131 VGND VGND VPWR VPWR sky130_fd_sc_hd__decap_3
XFILLER_117_175 VGND VGND VPWR VPWR sky130_fd_sc_hd__decap_3
XFILLER_117_164 VGND VGND VPWR VPWR sky130_fd_sc_hd__decap_3
XFILLER_132_134 VGND VGND VPWR VPWR sky130_fd_sc_hd__decap_3
Xoutput552 net635 VGND VGND VPWR VPWR Tile_X0Y1_W2BEGb[1] sky130_fd_sc_hd__buf_2
Xoutput541 net624 VGND VGND VPWR VPWR Tile_X0Y1_W1BEG[2] sky130_fd_sc_hd__buf_2
Xoutput530 net613 VGND VGND VPWR VPWR Tile_X0Y1_S4BEG[1] sky130_fd_sc_hd__buf_2
Xoutput563 net646 VGND VGND VPWR VPWR Tile_X0Y1_W6BEG[2] sky130_fd_sc_hd__buf_2
XFILLER_182_29 VGND VGND VPWR VPWR sky130_fd_sc_hd__decap_3
XFILLER_132_156 VGND VGND VPWR VPWR sky130_fd_sc_hd__decap_3
Xoutput585 net668 VGND VGND VPWR VPWR Tile_X0Y1_WW4BEG[8] sky130_fd_sc_hd__buf_2
Xoutput574 net657 VGND VGND VPWR VPWR Tile_X0Y1_WW4BEG[12] sky130_fd_sc_hd__buf_2
XTAP_TAPCELL_ROW_89_728 VGND VPWR sky130_fd_sc_hd__tapvpwrvgnd_1
XFILLER_132_189 VGND VGND VPWR VPWR sky130_fd_sc_hd__decap_3
XFILLER_115_45 VGND VGND VPWR VPWR sky130_fd_sc_hd__decap_3
Xfanout256 Tile_X0Y0_OpenRAM_top.Inst_OpenRAM_top_switch_matrix.J_NS2_BEG3 VGND VGND
+ VPWR VPWR net256 sky130_fd_sc_hd__clkbuf_4
XFILLER_86_221 VGND VGND VPWR VPWR sky130_fd_sc_hd__decap_3
XFILLER_115_78 VGND VGND VPWR VPWR sky130_fd_sc_hd__decap_3
XTAP_TAPCELL_ROW_97_761 VGND VPWR sky130_fd_sc_hd__tapvpwrvgnd_1
Xfanout278 net280 VGND VGND VPWR VPWR net278 sky130_fd_sc_hd__clkbuf_2
Xfanout289 net290 VGND VGND VPWR VPWR net289 sky130_fd_sc_hd__clkbuf_2
Xfanout267 Tile_X0Y1_FrameStrobe[8] VGND VGND VPWR VPWR net267 sky130_fd_sc_hd__clkbuf_2
XFILLER_131_33 VGND VGND VPWR VPWR sky130_fd_sc_hd__decap_3
XFILLER_39_181 VGND VGND VPWR VPWR sky130_fd_sc_hd__fill_1
XFILLER_131_66 VGND VGND VPWR VPWR sky130_fd_sc_hd__decap_3
XFILLER_54_162 VGND VGND VPWR VPWR sky130_fd_sc_hd__decap_3
XFILLER_91_15 VGND VGND VPWR VPWR sky130_fd_sc_hd__decap_3
XFILLER_131_99 VGND VGND VPWR VPWR sky130_fd_sc_hd__decap_3
XFILLER_54_195 VGND VGND VPWR VPWR sky130_fd_sc_hd__fill_1
XFILLER_10_221 VGND VGND VPWR VPWR sky130_fd_sc_hd__decap_3
XFILLER_6_203 VGND VGND VPWR VPWR sky130_fd_sc_hd__decap_3
XFILLER_40_63 VGND VGND VPWR VPWR sky130_fd_sc_hd__decap_3
XFILLER_170_218 VGND VGND VPWR VPWR sky130_fd_sc_hd__decap_3
XFILLER_156_41 VGND VGND VPWR VPWR sky130_fd_sc_hd__decap_3
XFILLER_108_186 VGND VGND VPWR VPWR sky130_fd_sc_hd__decap_3
XFILLER_156_85 VGND VGND VPWR VPWR sky130_fd_sc_hd__decap_3
XFILLER_123_134 VGND VGND VPWR VPWR sky130_fd_sc_hd__decap_3
XFILLER_123_167 VGND VGND VPWR VPWR sky130_fd_sc_hd__fill_1
XFILLER_49_72 VGND VGND VPWR VPWR sky130_fd_sc_hd__decap_3
XFILLER_172_62 VGND VGND VPWR VPWR sky130_fd_sc_hd__decap_3
XFILLER_37_129 VGND VGND VPWR VPWR sky130_fd_sc_hd__decap_3
XFILLER_92_224 VGND VGND VPWR VPWR sky130_fd_sc_hd__decap_3
XTAP_TAPCELL_ROW_155_990 VGND VPWR sky130_fd_sc_hd__tapvpwrvgnd_1
XFILLER_1_57 VGND VGND VPWR VPWR sky130_fd_sc_hd__fill_2
XFILLER_65_60 VGND VGND VPWR VPWR sky130_fd_sc_hd__decap_3
XTAP_TAPCELL_ROW_115_832 VGND VPWR sky130_fd_sc_hd__tapvpwrvgnd_1
XFILLER_45_162 VGND VGND VPWR VPWR sky130_fd_sc_hd__decap_3
XFILLER_65_93 VGND VGND VPWR VPWR sky130_fd_sc_hd__decap_3
XFILLER_60_121 VGND VGND VPWR VPWR sky130_fd_sc_hd__decap_3
X_0922_ net130 net274 VGND VGND VPWR VPWR Tile_X0Y0_OpenRAM_top.Inst_OpenRAM_top_ConfigMem.Inst_frame7_bit24.Q
+ sky130_fd_sc_hd__dlxtp_1
X_0853_ net135 net291 VGND VGND VPWR VPWR Tile_X0Y0_OpenRAM_top.Inst_OpenRAM_top_ConfigMem.Inst_frame5_bit29.Q
+ sky130_fd_sc_hd__dlxtp_1
X_0784_ net136 net317 VGND VGND VPWR VPWR Tile_X0Y0_OpenRAM_top.Inst_OpenRAM_top_ConfigMem.Inst_frame2_bit2.Q
+ sky130_fd_sc_hd__dlxtp_1
X_1405_ net224 VGND VGND VPWR VPWR net556 sky130_fd_sc_hd__buf_6
XFILLER_68_221 VGND VGND VPWR VPWR sky130_fd_sc_hd__decap_3
XTAP_TAPCELL_ROW_138_924 VGND VPWR sky130_fd_sc_hd__tapvpwrvgnd_1
X_1336_ Tile_X0Y1_N4END[15] VGND VGND VPWR VPWR net502 sky130_fd_sc_hd__buf_6
XFILLER_28_118 VGND VGND VPWR VPWR sky130_fd_sc_hd__decap_3
Xinput1 CONFIGURED_top VGND VGND VPWR VPWR net1 sky130_fd_sc_hd__dlymetal6s2s_1
X_1267_ net115 VGND VGND VPWR VPWR net418 sky130_fd_sc_hd__clkbuf_2
XFILLER_36_162 VGND VGND VPWR VPWR sky130_fd_sc_hd__decap_3
X_1198_ net238 net271 VGND VGND VPWR VPWR Tile_X0Y1_OpenRAM_bot.Inst_OpenRAM_bot_ConfigMem.Inst_frame7_bit24.Q
+ sky130_fd_sc_hd__dlxtp_1
XFILLER_101_25 VGND VGND VPWR VPWR sky130_fd_sc_hd__decap_3
XFILLER_36_195 VGND VGND VPWR VPWR sky130_fd_sc_hd__fill_1
XTAP_TAPCELL_ROW_121_857 VGND VPWR sky130_fd_sc_hd__tapvpwrvgnd_1
XFILLER_177_18 VGND VGND VPWR VPWR sky130_fd_sc_hd__decap_3
XFILLER_152_229 VGND VGND VPWR VPWR sky130_fd_sc_hd__fill_1
XFILLER_3_217 VGND VGND VPWR VPWR sky130_fd_sc_hd__decap_3
XFILLER_10_44 VGND VGND VPWR VPWR sky130_fd_sc_hd__decap_3
XFILLER_3_228 VGND VGND VPWR VPWR sky130_fd_sc_hd__decap_3
Xoutput371 net454 VGND VGND VPWR VPWR Tile_X0Y0_FrameStrobe_O[14] sky130_fd_sc_hd__buf_2
Xoutput360 net443 VGND VGND VPWR VPWR Tile_X0Y0_FrameData_O[4] sky130_fd_sc_hd__buf_2
XFILLER_126_44 VGND VGND VPWR VPWR sky130_fd_sc_hd__decap_3
XFILLER_105_167 VGND VGND VPWR VPWR sky130_fd_sc_hd__fill_1
XFILLER_10_88 VGND VGND VPWR VPWR sky130_fd_sc_hd__decap_3
XFILLER_10_77 VGND VGND VPWR VPWR sky130_fd_sc_hd__decap_3
Xoutput382 net465 VGND VGND VPWR VPWR Tile_X0Y0_FrameStrobe_O[6] sky130_fd_sc_hd__buf_2
Xoutput393 net476 VGND VGND VPWR VPWR Tile_X0Y0_N2BEG[3] sky130_fd_sc_hd__buf_2
XFILLER_59_221 VGND VGND VPWR VPWR sky130_fd_sc_hd__decap_3
XFILLER_86_15 VGND VGND VPWR VPWR sky130_fd_sc_hd__decap_3
XFILLER_19_20 VGND VGND VPWR VPWR sky130_fd_sc_hd__decap_3
XTAP_TAPCELL_ROW_144_949 VGND VPWR sky130_fd_sc_hd__tapvpwrvgnd_1
XFILLER_74_224 VGND VGND VPWR VPWR sky130_fd_sc_hd__decap_3
XFILLER_27_140 VGND VGND VPWR VPWR sky130_fd_sc_hd__decap_3
XFILLER_35_30 VGND VGND VPWR VPWR sky130_fd_sc_hd__decap_3
XFILLER_35_63 VGND VGND VPWR VPWR sky130_fd_sc_hd__decap_3
XFILLER_42_176 VGND VGND VPWR VPWR sky130_fd_sc_hd__decap_3
XFILLER_128_215 VGND VGND VPWR VPWR sky130_fd_sc_hd__decap_3
XFILLER_167_51 VGND VGND VPWR VPWR sky130_fd_sc_hd__decap_3
XFILLER_167_84 VGND VGND VPWR VPWR sky130_fd_sc_hd__fill_1
XFILLER_111_148 VGND VGND VPWR VPWR sky130_fd_sc_hd__decap_3
X_1121_ net249 net299 VGND VGND VPWR VPWR Tile_X0Y1_OpenRAM_bot.Inst_OpenRAM_bot_ConfigMem.Inst_frame4_bit5.Q
+ sky130_fd_sc_hd__dlxtp_1
XTAP_TAPCELL_ROW_160_1010 VGND VPWR sky130_fd_sc_hd__tapvpwrvgnd_1
X_1052_ net223 net312 VGND VGND VPWR VPWR Tile_X0Y1_OpenRAM_bot.Inst_OpenRAM_bot_ConfigMem.Inst_frame2_bit10.Q
+ sky130_fd_sc_hd__dlxtp_1
XFILLER_18_195 VGND VGND VPWR VPWR sky130_fd_sc_hd__fill_1
XTAP_TAPCELL_ROW_91_734 VGND VPWR sky130_fd_sc_hd__tapvpwrvgnd_1
XFILLER_178_115 VGND VGND VPWR VPWR sky130_fd_sc_hd__decap_3
XFILLER_178_159 VGND VGND VPWR VPWR sky130_fd_sc_hd__decap_3
X_0905_ net145 net285 VGND VGND VPWR VPWR Tile_X0Y0_OpenRAM_top.Inst_OpenRAM_top_ConfigMem.Inst_frame6_bit9.Q
+ sky130_fd_sc_hd__dlxtp_1
XFILLER_119_204 VGND VGND VPWR VPWR sky130_fd_sc_hd__decap_3
X_0836_ net119 net300 VGND VGND VPWR VPWR Tile_X0Y0_OpenRAM_top.Inst_OpenRAM_top_ConfigMem.Inst_frame4_bit14.Q
+ sky130_fd_sc_hd__dlxtp_1
X_0767_ net124 net317 VGND VGND VPWR VPWR Tile_X0Y0_OpenRAM_top.Inst_OpenRAM_top_ConfigMem.Inst_frame2_bit19.Q
+ sky130_fd_sc_hd__dlxtp_1
XFILLER_0_209 VGND VGND VPWR VPWR sky130_fd_sc_hd__decap_3
X_0698_ net130 net335 VGND VGND VPWR VPWR Tile_X0Y0_OpenRAM_top.Inst_OpenRAM_top_ConfigMem.Inst_frame0_bit24.Q
+ sky130_fd_sc_hd__dlxtp_1
XFILLER_102_159 VGND VGND VPWR VPWR sky130_fd_sc_hd__decap_3
XPHY_EDGE_ROW_102_Left_285 VGND VGND VPWR VPWR sky130_fd_sc_hd__decap_3
XFILLER_56_18 VGND VGND VPWR VPWR sky130_fd_sc_hd__decap_3
XFILLER_56_29 VGND VGND VPWR VPWR sky130_fd_sc_hd__decap_3
X_1319_ Tile_X0Y0_OpenRAM_top.Inst_OpenRAM_top_switch_matrix.N2BEG6 VGND VGND VPWR
+ VPWR net479 sky130_fd_sc_hd__clkbuf_2
XFILLER_179_9 VGND VGND VPWR VPWR sky130_fd_sc_hd__decap_3
XFILLER_112_24 VGND VGND VPWR VPWR sky130_fd_sc_hd__decap_3
XTAP_TAPCELL_ROW_82_701 VGND VPWR sky130_fd_sc_hd__tapvpwrvgnd_1
XFILLER_112_68 VGND VGND VPWR VPWR sky130_fd_sc_hd__decap_3
XFILLER_112_35 VGND VGND VPWR VPWR sky130_fd_sc_hd__decap_3
XFILLER_24_176 VGND VGND VPWR VPWR sky130_fd_sc_hd__decap_3
XFILLER_169_159 VGND VGND VPWR VPWR sky130_fd_sc_hd__decap_3
XPHY_EDGE_ROW_111_Left_294 VGND VGND VPWR VPWR sky130_fd_sc_hd__decap_3
XFILLER_177_181 VGND VGND VPWR VPWR sky130_fd_sc_hd__decap_3
XFILLER_137_10 VGND VGND VPWR VPWR sky130_fd_sc_hd__fill_2
XFILLER_125_207 VGND VGND VPWR VPWR sky130_fd_sc_hd__fill_1
XFILLER_21_54 VGND VGND VPWR VPWR sky130_fd_sc_hd__fill_2
XFILLER_137_54 VGND VGND VPWR VPWR sky130_fd_sc_hd__fill_2
XFILLER_21_87 VGND VGND VPWR VPWR sky130_fd_sc_hd__decap_3
XFILLER_137_76 VGND VGND VPWR VPWR sky130_fd_sc_hd__fill_2
XFILLER_97_69 VGND VGND VPWR VPWR sky130_fd_sc_hd__decap_3
XFILLER_153_53 VGND VGND VPWR VPWR sky130_fd_sc_hd__decap_3
XFILLER_47_202 VGND VGND VPWR VPWR sky130_fd_sc_hd__fill_2
XFILLER_153_86 VGND VGND VPWR VPWR sky130_fd_sc_hd__fill_2
XFILLER_46_51 VGND VGND VPWR VPWR sky130_fd_sc_hd__decap_3
XTAP_TAPCELL_ROW_140_930 VGND VPWR sky130_fd_sc_hd__tapvpwrvgnd_1
XFILLER_15_143 VGND VGND VPWR VPWR sky130_fd_sc_hd__decap_3
XFILLER_94_9 VGND VGND VPWR VPWR sky130_fd_sc_hd__decap_3
XFILLER_15_198 VGND VGND VPWR VPWR sky130_fd_sc_hd__decap_3
XFILLER_62_50 VGND VGND VPWR VPWR sky130_fd_sc_hd__decap_3
XFILLER_178_50 VGND VGND VPWR VPWR sky130_fd_sc_hd__decap_3
XFILLER_168_170 VGND VGND VPWR VPWR sky130_fd_sc_hd__decap_3
XFILLER_7_12 VGND VGND VPWR VPWR sky130_fd_sc_hd__decap_3
XFILLER_30_168 VGND VGND VPWR VPWR sky130_fd_sc_hd__decap_3
XFILLER_62_94 VGND VGND VPWR VPWR sky130_fd_sc_hd__decap_3
XFILLER_178_94 VGND VGND VPWR VPWR sky130_fd_sc_hd__decap_3
XFILLER_178_83 VGND VGND VPWR VPWR sky130_fd_sc_hd__fill_1
XFILLER_7_45 VGND VGND VPWR VPWR sky130_fd_sc_hd__decap_3
XFILLER_116_218 VGND VGND VPWR VPWR sky130_fd_sc_hd__decap_3
XFILLER_7_78 VGND VGND VPWR VPWR sky130_fd_sc_hd__decap_3
X_0621_ _0027_ Tile_X0Y1_OpenRAM_bot.Inst_OpenRAM_bot_ConfigMem.Inst_frame1_bit3.Q
+ net262 _0168_ VGND VGND VPWR VPWR net374 sky130_fd_sc_hd__a31o_1
X_0552_ net339 net359 _0070_ net172 Tile_X0Y1_OpenRAM_bot.Inst_OpenRAM_bot_ConfigMem.Inst_frame1_bit28.Q
+ Tile_X0Y1_OpenRAM_bot.Inst_OpenRAM_bot_ConfigMem.Inst_frame1_bit29.Q VGND VGND VPWR
+ VPWR _0146_ sky130_fd_sc_hd__mux4_2
X_0483_ net106 Tile_X0Y0_OpenRAM_top.Inst_OpenRAM_top_switch_matrix.J_NS4_BEG10 Tile_X0Y0_OpenRAM_top.Inst_OpenRAM_top_ConfigMem.Inst_frame7_bit12.Q
+ VGND VGND VPWR VPWR _0125_ sky130_fd_sc_hd__mux2_1
XFILLER_23_3 VGND VGND VPWR VPWR sky130_fd_sc_hd__decap_3
XFILLER_38_213 VGND VGND VPWR VPWR sky130_fd_sc_hd__decap_3
X_1104_ net236 net296 VGND VGND VPWR VPWR Tile_X0Y1_OpenRAM_bot.Inst_OpenRAM_bot_ConfigMem.Inst_frame4_bit22.Q
+ sky130_fd_sc_hd__dlxtp_1
XFILLER_53_216 VGND VGND VPWR VPWR sky130_fd_sc_hd__decap_3
X_1035_ net241 net312 VGND VGND VPWR VPWR Tile_X0Y1_OpenRAM_bot.Inst_OpenRAM_bot_ConfigMem.Inst_frame2_bit27.Q
+ sky130_fd_sc_hd__dlxtp_1
XFILLER_21_102 VGND VGND VPWR VPWR sky130_fd_sc_hd__decap_3
XFILLER_21_113 VGND VGND VPWR VPWR sky130_fd_sc_hd__decap_3
XFILLER_21_146 VGND VGND VPWR VPWR sky130_fd_sc_hd__decap_3
XFILLER_174_162 VGND VGND VPWR VPWR sky130_fd_sc_hd__decap_3
XFILLER_174_195 VGND VGND VPWR VPWR sky130_fd_sc_hd__fill_1
Xinput70 Tile_X0Y0_E2END[0] VGND VGND VPWR VPWR net70 sky130_fd_sc_hd__dlymetal6s2s_1
X_0819_ net138 net302 VGND VGND VPWR VPWR Tile_X0Y0_OpenRAM_top.Inst_OpenRAM_top_ConfigMem.Inst_frame4_bit31.Q
+ sky130_fd_sc_hd__dlxtp_1
Xinput81 Tile_X0Y0_E2MID[3] VGND VGND VPWR VPWR net81 sky130_fd_sc_hd__dlymetal6s2s_1
Xinput92 Tile_X0Y0_E6END[4] VGND VGND VPWR VPWR net92 sky130_fd_sc_hd__dlymetal6s2s_1
XFILLER_67_39 VGND VGND VPWR VPWR sky130_fd_sc_hd__decap_3
XTAP_TAPCELL_ROW_167_1038 VGND VPWR sky130_fd_sc_hd__tapvpwrvgnd_1
XFILLER_88_179 VGND VGND VPWR VPWR sky130_fd_sc_hd__decap_3
XFILLER_96_190 VGND VGND VPWR VPWR sky130_fd_sc_hd__decap_3
XTAP_TAPCELL_ROW_4_389 VGND VPWR sky130_fd_sc_hd__tapvpwrvgnd_1
XFILLER_177_6 VGND VGND VPWR VPWR sky130_fd_sc_hd__decap_3
XFILLER_123_78 VGND VGND VPWR VPWR sky130_fd_sc_hd__decap_3
XFILLER_83_27 VGND VGND VPWR VPWR sky130_fd_sc_hd__decap_3
XFILLER_16_65 VGND VGND VPWR VPWR sky130_fd_sc_hd__decap_3
XFILLER_12_168 VGND VGND VPWR VPWR sky130_fd_sc_hd__fill_1
XFILLER_8_106 VGND VGND VPWR VPWR sky130_fd_sc_hd__decap_3
XFILLER_8_139 VGND VGND VPWR VPWR sky130_fd_sc_hd__fill_1
XFILLER_165_140 VGND VGND VPWR VPWR sky130_fd_sc_hd__decap_3
XFILLER_148_53 VGND VGND VPWR VPWR sky130_fd_sc_hd__fill_1
XFILLER_32_97 VGND VGND VPWR VPWR sky130_fd_sc_hd__decap_3
XFILLER_165_184 VGND VGND VPWR VPWR sky130_fd_sc_hd__decap_3
XFILLER_148_97 VGND VGND VPWR VPWR sky130_fd_sc_hd__decap_3
XFILLER_180_154 VGND VGND VPWR VPWR sky130_fd_sc_hd__decap_3
XFILLER_79_113 VGND VGND VPWR VPWR sky130_fd_sc_hd__decap_3
XFILLER_164_85 VGND VGND VPWR VPWR sky130_fd_sc_hd__decap_3
XFILLER_87_190 VGND VGND VPWR VPWR sky130_fd_sc_hd__decap_3
XFILLER_94_127 VGND VGND VPWR VPWR sky130_fd_sc_hd__decap_3
XFILLER_92_6 VGND VGND VPWR VPWR sky130_fd_sc_hd__decap_3
XFILLER_148_118 VGND VGND VPWR VPWR sky130_fd_sc_hd__decap_3
XFILLER_156_184 VGND VGND VPWR VPWR sky130_fd_sc_hd__decap_3
XFILLER_7_172 VGND VGND VPWR VPWR sky130_fd_sc_hd__decap_3
XFILLER_7_161 VGND VGND VPWR VPWR sky130_fd_sc_hd__decap_3
XFILLER_171_143 VGND VGND VPWR VPWR sky130_fd_sc_hd__decap_3
XPHY_EDGE_ROW_9_Right_9 VGND VGND VPWR VPWR sky130_fd_sc_hd__decap_3
X_0604_ net216 net209 net200 _0152_ Tile_X0Y1_OpenRAM_bot.Inst_OpenRAM_bot_ConfigMem.Inst_frame2_bit4.Q
+ Tile_X0Y1_OpenRAM_bot.Inst_OpenRAM_bot_ConfigMem.Inst_frame2_bit5.Q VGND VGND VPWR
+ VPWR net411 sky130_fd_sc_hd__mux4_2
XFILLER_171_187 VGND VGND VPWR VPWR sky130_fd_sc_hd__decap_3
X_0535_ net29 net61 net261 _0085_ Tile_X0Y1_OpenRAM_bot.Inst_OpenRAM_bot_ConfigMem.Inst_frame6_bit26.Q
+ Tile_X0Y1_OpenRAM_bot.Inst_OpenRAM_bot_ConfigMem.Inst_frame6_bit27.Q VGND VGND VPWR
+ VPWR Tile_X0Y1_OpenRAM_bot.Inst_OpenRAM_bot_switch_matrix.W2BEG5 sky130_fd_sc_hd__mux4_1
X_0466_ net81 net256 Tile_X0Y0_OpenRAM_top.Inst_OpenRAM_top_ConfigMem.Inst_frame1_bit7.Q
+ VGND VGND VPWR VPWR _0111_ sky130_fd_sc_hd__mux2_1
XPHY_EDGE_ROW_107_Right_107 VGND VGND VPWR VPWR sky130_fd_sc_hd__decap_3
XFILLER_85_149 VGND VGND VPWR VPWR sky130_fd_sc_hd__decap_3
X_0397_ Tile_X0Y0_OpenRAM_top.Inst_OpenRAM_top_switch_matrix.N1END0 net361 net146
+ net166 Tile_X0Y0_OpenRAM_top.Inst_OpenRAM_top_ConfigMem.Inst_frame1_bit24.Q Tile_X0Y0_OpenRAM_top.Inst_OpenRAM_top_ConfigMem.Inst_frame1_bit25.Q
+ VGND VGND VPWR VPWR Tile_X0Y0_OpenRAM_top.Inst_OpenRAM_top_switch_matrix.J_NS4_BEG8
+ sky130_fd_sc_hd__mux4_2
XFILLER_26_216 VGND VGND VPWR VPWR sky130_fd_sc_hd__decap_3
XFILLER_93_193 VGND VGND VPWR VPWR sky130_fd_sc_hd__decap_3
XFILLER_179_221 VGND VGND VPWR VPWR sky130_fd_sc_hd__decap_3
X_1018_ net225 net322 VGND VGND VPWR VPWR Tile_X0Y1_OpenRAM_bot.Inst_OpenRAM_bot_ConfigMem.Inst_frame1_bit12.Q
+ sky130_fd_sc_hd__dlxtp_1
XFILLER_41_208 VGND VGND VPWR VPWR sky130_fd_sc_hd__decap_3
XTAP_TAPCELL_ROW_173_1064 VGND VPWR sky130_fd_sc_hd__tapvpwrvgnd_1
XFILLER_162_121 VGND VGND VPWR VPWR sky130_fd_sc_hd__decap_3
XFILLER_162_176 VGND VGND VPWR VPWR sky130_fd_sc_hd__fill_1
XFILLER_78_27 VGND VGND VPWR VPWR sky130_fd_sc_hd__fill_1
XFILLER_78_38 VGND VGND VPWR VPWR sky130_fd_sc_hd__decap_3
XFILLER_134_77 VGND VGND VPWR VPWR sky130_fd_sc_hd__decap_3
XFILLER_94_26 VGND VGND VPWR VPWR sky130_fd_sc_hd__fill_2
XFILLER_69_190 VGND VGND VPWR VPWR sky130_fd_sc_hd__decap_3
XFILLER_91_108 VGND VGND VPWR VPWR sky130_fd_sc_hd__decap_3
XFILLER_175_3 VGND VGND VPWR VPWR sky130_fd_sc_hd__decap_3
XFILLER_84_171 VGND VGND VPWR VPWR sky130_fd_sc_hd__decap_3
XFILLER_91_119 VGND VGND VPWR VPWR sky130_fd_sc_hd__decap_3
XFILLER_150_65 VGND VGND VPWR VPWR sky130_fd_sc_hd__decap_3
XFILLER_27_75 VGND VGND VPWR VPWR sky130_fd_sc_hd__decap_3
XTAP_TAPCELL_ROW_0_370 VGND VPWR sky130_fd_sc_hd__tapvpwrvgnd_1
XFILLER_159_63 VGND VGND VPWR VPWR sky130_fd_sc_hd__decap_3
XFILLER_43_96 VGND VGND VPWR VPWR sky130_fd_sc_hd__decap_3
XFILLER_138_195 VGND VGND VPWR VPWR sky130_fd_sc_hd__fill_1
XFILLER_175_51 VGND VGND VPWR VPWR sky130_fd_sc_hd__decap_3
XFILLER_153_154 VGND VGND VPWR VPWR sky130_fd_sc_hd__decap_3
XFILLER_175_84 VGND VGND VPWR VPWR sky130_fd_sc_hd__decap_3
XFILLER_99_219 VGND VGND VPWR VPWR sky130_fd_sc_hd__decap_3
XFILLER_4_24 VGND VGND VPWR VPWR sky130_fd_sc_hd__decap_3
XFILLER_4_153 VGND VGND VPWR VPWR sky130_fd_sc_hd__decap_3
XFILLER_153_198 VGND VGND VPWR VPWR sky130_fd_sc_hd__decap_3
XFILLER_4_35 VGND VGND VPWR VPWR sky130_fd_sc_hd__decap_3
XFILLER_4_68 VGND VGND VPWR VPWR sky130_fd_sc_hd__decap_3
XFILLER_4_186 VGND VGND VPWR VPWR sky130_fd_sc_hd__decap_3
XFILLER_4_197 VGND VGND VPWR VPWR sky130_fd_sc_hd__decap_3
X_0320_ Tile_X0Y0_OpenRAM_top.Inst_OpenRAM_top_switch_matrix.N1END3 net364 net149
+ net169 Tile_X0Y0_OpenRAM_top.Inst_OpenRAM_top_ConfigMem.Inst_frame0_bit6.Q Tile_X0Y0_OpenRAM_top.Inst_OpenRAM_top_ConfigMem.Inst_frame0_bit7.Q
+ VGND VGND VPWR VPWR Tile_X0Y0_OpenRAM_top.Inst_OpenRAM_top_switch_matrix.J_NS4_BEG15
+ sky130_fd_sc_hd__mux4_2
XFILLER_68_71 VGND VGND VPWR VPWR sky130_fd_sc_hd__decap_3
XFILLER_67_116 VGND VGND VPWR VPWR sky130_fd_sc_hd__decap_3
Xinput260 Tile_X0Y1_N2END[2] VGND VGND VPWR VPWR net343 sky130_fd_sc_hd__buf_2
Xinput271 Tile_X0Y1_N2MID[5] VGND VGND VPWR VPWR net354 sky130_fd_sc_hd__buf_2
X_0251_ Tile_X0Y1_OpenRAM_bot.Inst_OpenRAM_bot_ConfigMem.Inst_frame3_bit24.Q VGND
+ VGND VPWR VPWR _0024_ sky130_fd_sc_hd__inv_2
XFILLER_82_119 VGND VGND VPWR VPWR sky130_fd_sc_hd__decap_3
XFILLER_75_193 VGND VGND VPWR VPWR sky130_fd_sc_hd__decap_3
XFILLER_90_163 VGND VGND VPWR VPWR sky130_fd_sc_hd__decap_3
XFILLER_90_3 VGND VGND VPWR VPWR sky130_fd_sc_hd__decap_3
XFILLER_176_224 VGND VGND VPWR VPWR sky130_fd_sc_hd__decap_3
XFILLER_129_140 VGND VGND VPWR VPWR sky130_fd_sc_hd__decap_3
XFILLER_144_110 VGND VGND VPWR VPWR sky130_fd_sc_hd__decap_3
XFILLER_144_132 VGND VGND VPWR VPWR sky130_fd_sc_hd__decap_3
XFILLER_144_165 VGND VGND VPWR VPWR sky130_fd_sc_hd__decap_3
X_0518_ net193 net185 net204 net263 Tile_X0Y1_OpenRAM_bot.Inst_OpenRAM_bot_ConfigMem.Inst_frame7_bit12.Q
+ Tile_X0Y1_OpenRAM_bot.Inst_OpenRAM_bot_ConfigMem.Inst_frame7_bit13.Q VGND VGND VPWR
+ VPWR Tile_X0Y1_OpenRAM_bot.Inst_OpenRAM_bot_switch_matrix.S2BEG0 sky130_fd_sc_hd__mux4_1
X_1498_ Tile_X0Y1_OpenRAM_bot.Inst_OpenRAM_bot_switch_matrix.WW4BEG4 VGND VGND VPWR
+ VPWR net664 sky130_fd_sc_hd__clkbuf_1
X_0449_ net71 Tile_X0Y0_OpenRAM_top.Inst_OpenRAM_top_ConfigMem.Inst_frame2_bit26.Q
+ VGND VGND VPWR VPWR _0100_ sky130_fd_sc_hd__nand2_1
XFILLER_104_47 VGND VGND VPWR VPWR sky130_fd_sc_hd__decap_3
XFILLER_73_119 VGND VGND VPWR VPWR sky130_fd_sc_hd__decap_3
XTAP_TAPCELL_ROW_37_520 VGND VPWR sky130_fd_sc_hd__tapvpwrvgnd_1
XFILLER_64_29 VGND VGND VPWR VPWR sky130_fd_sc_hd__decap_3
XFILLER_66_193 VGND VGND VPWR VPWR sky130_fd_sc_hd__decap_3
XFILLER_120_57 VGND VGND VPWR VPWR sky130_fd_sc_hd__decap_3
XFILLER_167_202 VGND VGND VPWR VPWR sky130_fd_sc_hd__decap_3
XFILLER_13_33 VGND VGND VPWR VPWR sky130_fd_sc_hd__decap_3
XTAP_TAPCELL_ROW_52_578 VGND VPWR sky130_fd_sc_hd__tapvpwrvgnd_1
XFILLER_135_110 VGND VGND VPWR VPWR sky130_fd_sc_hd__fill_2
XFILLER_129_66 VGND VGND VPWR VPWR sky130_fd_sc_hd__decap_3
XTAP_TAPCELL_ROW_20_453 VGND VPWR sky130_fd_sc_hd__tapvpwrvgnd_1
XFILLER_89_15 VGND VGND VPWR VPWR sky130_fd_sc_hd__decap_3
XFILLER_135_165 VGND VGND VPWR VPWR sky130_fd_sc_hd__decap_3
XFILLER_145_54 VGND VGND VPWR VPWR sky130_fd_sc_hd__fill_2
XFILLER_1_134 VGND VGND VPWR VPWR sky130_fd_sc_hd__decap_3
XFILLER_145_76 VGND VGND VPWR VPWR sky130_fd_sc_hd__decap_3
XFILLER_49_116 VGND VGND VPWR VPWR sky130_fd_sc_hd__decap_3
XFILLER_161_31 VGND VGND VPWR VPWR sky130_fd_sc_hd__decap_3
XFILLER_38_41 VGND VGND VPWR VPWR sky130_fd_sc_hd__decap_3
XFILLER_49_149 VGND VGND VPWR VPWR sky130_fd_sc_hd__decap_3
XFILLER_38_85 VGND VGND VPWR VPWR sky130_fd_sc_hd__decap_3
XFILLER_57_193 VGND VGND VPWR VPWR sky130_fd_sc_hd__decap_3
XFILLER_72_141 VGND VGND VPWR VPWR sky130_fd_sc_hd__decap_3
XFILLER_54_62 VGND VGND VPWR VPWR sky130_fd_sc_hd__decap_3
XFILLER_72_185 VGND VGND VPWR VPWR sky130_fd_sc_hd__decap_3
XTAP_TAPCELL_ROW_43_545 VGND VPWR sky130_fd_sc_hd__tapvpwrvgnd_1
XFILLER_9_223 VGND VGND VPWR VPWR sky130_fd_sc_hd__fill_1
XFILLER_173_205 VGND VGND VPWR VPWR sky130_fd_sc_hd__decap_3
XFILLER_126_110 VGND VGND VPWR VPWR sky130_fd_sc_hd__decap_3
XFILLER_70_94 VGND VGND VPWR VPWR sky130_fd_sc_hd__decap_3
XFILLER_141_113 VGND VGND VPWR VPWR sky130_fd_sc_hd__decap_3
X_1421_ net241 VGND VGND VPWR VPWR net573 sky130_fd_sc_hd__buf_6
XFILLER_79_81 VGND VGND VPWR VPWR sky130_fd_sc_hd__fill_1
X_1352_ Tile_X0Y0_OpenRAM_top.Inst_OpenRAM_top_switch_matrix.W2BEG2 VGND VGND VPWR
+ VPWR net512 sky130_fd_sc_hd__clkbuf_1
XFILLER_95_200 VGND VGND VPWR VPWR sky130_fd_sc_hd__decap_3
XFILLER_95_233 VGND VGND VPWR VPWR sky130_fd_sc_hd__fill_1
X_1283_ net132 VGND VGND VPWR VPWR net435 sky130_fd_sc_hd__buf_1
X_0303_ net148 Tile_X0Y0_OpenRAM_top.Inst_OpenRAM_top_ConfigMem.Inst_frame0_bit29.Q
+ VGND VGND VPWR VPWR _0068_ sky130_fd_sc_hd__nand2_1
X_0234_ Tile_X0Y0_OpenRAM_top.Inst_OpenRAM_top_ConfigMem.Inst_frame2_bit28.Q VGND
+ VGND VPWR VPWR _0007_ sky130_fd_sc_hd__inv_2
XFILLER_48_171 VGND VGND VPWR VPWR sky130_fd_sc_hd__decap_3
XFILLER_95_80 VGND VGND VPWR VPWR sky130_fd_sc_hd__decap_3
XFILLER_63_130 VGND VGND VPWR VPWR sky130_fd_sc_hd__decap_3
XTAP_TAPCELL_ROW_66_637 VGND VPWR sky130_fd_sc_hd__tapvpwrvgnd_1
XFILLER_63_163 VGND VGND VPWR VPWR sky130_fd_sc_hd__decap_3
XFILLER_63_196 VGND VGND VPWR VPWR sky130_fd_sc_hd__decap_3
XTAP_TAPCELL_ROW_101_774 VGND VPWR sky130_fd_sc_hd__tapvpwrvgnd_1
XFILLER_164_227 VGND VGND VPWR VPWR sky130_fd_sc_hd__decap_3
XFILLER_117_110 VGND VGND VPWR VPWR sky130_fd_sc_hd__fill_2
X_0998_ net222 net331 VGND VGND VPWR VPWR Tile_X0Y1_OpenRAM_bot.Inst_OpenRAM_bot_ConfigMem.Inst_frame0_bit0.Q
+ sky130_fd_sc_hd__dlxtp_1
XFILLER_117_143 VGND VGND VPWR VPWR sky130_fd_sc_hd__decap_3
XFILLER_132_102 VGND VGND VPWR VPWR sky130_fd_sc_hd__fill_1
Xoutput520 net603 VGND VGND VPWR VPWR Tile_X0Y1_S2BEGb[5] sky130_fd_sc_hd__buf_2
XFILLER_117_187 VGND VGND VPWR VPWR sky130_fd_sc_hd__decap_3
Xoutput553 net636 VGND VGND VPWR VPWR Tile_X0Y1_W2BEGb[2] sky130_fd_sc_hd__buf_2
Xoutput542 net625 VGND VGND VPWR VPWR Tile_X0Y1_W1BEG[3] sky130_fd_sc_hd__buf_2
Xoutput531 net614 VGND VGND VPWR VPWR Tile_X0Y1_S4BEG[2] sky130_fd_sc_hd__buf_2
XFILLER_132_168 VGND VGND VPWR VPWR sky130_fd_sc_hd__decap_3
Xoutput586 net669 VGND VGND VPWR VPWR Tile_X0Y1_WW4BEG[9] sky130_fd_sc_hd__buf_2
Xoutput575 net658 VGND VGND VPWR VPWR Tile_X0Y1_WW4BEG[13] sky130_fd_sc_hd__buf_2
Xoutput564 net647 VGND VGND VPWR VPWR Tile_X0Y1_W6BEG[3] sky130_fd_sc_hd__buf_2
XTAP_TAPCELL_ROW_89_729 VGND VPWR sky130_fd_sc_hd__tapvpwrvgnd_1
XFILLER_140_190 VGND VGND VPWR VPWR sky130_fd_sc_hd__decap_3
Xfanout268 Tile_X0Y1_FrameStrobe[8] VGND VGND VPWR VPWR net268 sky130_fd_sc_hd__buf_2
Xfanout257 Tile_X0Y0_OpenRAM_top.Inst_OpenRAM_top_switch_matrix.J_NS2_BEG2 VGND VGND
+ VPWR VPWR net257 sky130_fd_sc_hd__clkbuf_4
Xfanout279 net280 VGND VGND VPWR VPWR net279 sky130_fd_sc_hd__buf_1
XFILLER_54_130 VGND VGND VPWR VPWR sky130_fd_sc_hd__decap_3
XFILLER_54_141 VGND VGND VPWR VPWR sky130_fd_sc_hd__decap_3
XFILLER_131_78 VGND VGND VPWR VPWR sky130_fd_sc_hd__decap_3
XTAP_TAPCELL_ROW_124_866 VGND VPWR sky130_fd_sc_hd__tapvpwrvgnd_1
XFILLER_54_174 VGND VGND VPWR VPWR sky130_fd_sc_hd__decap_3
XFILLER_24_21 VGND VGND VPWR VPWR sky130_fd_sc_hd__decap_3
XFILLER_24_32 VGND VGND VPWR VPWR sky130_fd_sc_hd__decap_3
XFILLER_10_200 VGND VGND VPWR VPWR sky130_fd_sc_hd__decap_3
XFILLER_155_205 VGND VGND VPWR VPWR sky130_fd_sc_hd__fill_1
XFILLER_108_121 VGND VGND VPWR VPWR sky130_fd_sc_hd__decap_3
XFILLER_156_53 VGND VGND VPWR VPWR sky130_fd_sc_hd__decap_3
XFILLER_123_102 VGND VGND VPWR VPWR sky130_fd_sc_hd__decap_3
XFILLER_108_165 VGND VGND VPWR VPWR sky130_fd_sc_hd__decap_3
XFILLER_40_75 VGND VGND VPWR VPWR sky130_fd_sc_hd__decap_3
XFILLER_156_97 VGND VGND VPWR VPWR sky130_fd_sc_hd__decap_3
XFILLER_123_146 VGND VGND VPWR VPWR sky130_fd_sc_hd__decap_3
XFILLER_172_41 VGND VGND VPWR VPWR sky130_fd_sc_hd__decap_3
XFILLER_49_51 VGND VGND VPWR VPWR sky130_fd_sc_hd__decap_3
XFILLER_172_74 VGND VGND VPWR VPWR sky130_fd_sc_hd__decap_3
XFILLER_49_84 VGND VGND VPWR VPWR sky130_fd_sc_hd__decap_3
XFILLER_172_85 VGND VGND VPWR VPWR sky130_fd_sc_hd__decap_3
XTAP_TAPCELL_ROW_147_958 VGND VPWR sky130_fd_sc_hd__tapvpwrvgnd_1
XFILLER_37_108 VGND VGND VPWR VPWR sky130_fd_sc_hd__decap_3
XFILLER_92_203 VGND VGND VPWR VPWR sky130_fd_sc_hd__decap_3
XTAP_TAPCELL_ROW_155_991 VGND VPWR sky130_fd_sc_hd__tapvpwrvgnd_1
XTAP_TAPCELL_ROW_115_833 VGND VPWR sky130_fd_sc_hd__tapvpwrvgnd_1
XFILLER_45_141 VGND VGND VPWR VPWR sky130_fd_sc_hd__decap_3
XFILLER_65_72 VGND VGND VPWR VPWR sky130_fd_sc_hd__decap_3
XFILLER_60_144 VGND VGND VPWR VPWR sky130_fd_sc_hd__decap_3
X_0921_ net131 net274 VGND VGND VPWR VPWR Tile_X0Y0_OpenRAM_top.Inst_OpenRAM_top_ConfigMem.Inst_frame7_bit25.Q
+ sky130_fd_sc_hd__dlxtp_1
XFILLER_60_177 VGND VGND VPWR VPWR sky130_fd_sc_hd__decap_3
XFILLER_81_60 VGND VGND VPWR VPWR sky130_fd_sc_hd__decap_3
X_0852_ net137 net291 VGND VGND VPWR VPWR Tile_X0Y0_OpenRAM_top.Inst_OpenRAM_top_ConfigMem.Inst_frame5_bit30.Q
+ sky130_fd_sc_hd__dlxtp_1
X_0783_ net139 net317 VGND VGND VPWR VPWR Tile_X0Y0_OpenRAM_top.Inst_OpenRAM_top_ConfigMem.Inst_frame2_bit3.Q
+ sky130_fd_sc_hd__dlxtp_1
XFILLER_114_124 VGND VGND VPWR VPWR sky130_fd_sc_hd__decap_3
XFILLER_114_179 VGND VGND VPWR VPWR sky130_fd_sc_hd__decap_3
X_1404_ net223 VGND VGND VPWR VPWR net555 sky130_fd_sc_hd__buf_6
XFILLER_68_200 VGND VGND VPWR VPWR sky130_fd_sc_hd__decap_3
XTAP_TAPCELL_ROW_138_925 VGND VPWR sky130_fd_sc_hd__tapvpwrvgnd_1
XFILLER_122_190 VGND VGND VPWR VPWR sky130_fd_sc_hd__decap_3
X_1335_ Tile_X0Y1_N4END[14] VGND VGND VPWR VPWR net501 sky130_fd_sc_hd__buf_6
Xinput2 DOUT_A_SRAM0 VGND VGND VPWR VPWR net2 sky130_fd_sc_hd__clkbuf_2
XPHY_EDGE_ROW_166_Left_349 VGND VGND VPWR VPWR sky130_fd_sc_hd__decap_3
X_1266_ net145 VGND VGND VPWR VPWR net448 sky130_fd_sc_hd__clkbuf_2
XFILLER_83_225 VGND VGND VPWR VPWR sky130_fd_sc_hd__fill_1
XFILLER_36_130 VGND VGND VPWR VPWR sky130_fd_sc_hd__decap_3
XFILLER_36_141 VGND VGND VPWR VPWR sky130_fd_sc_hd__decap_3
X_1197_ net239 net271 VGND VGND VPWR VPWR Tile_X0Y1_OpenRAM_bot.Inst_OpenRAM_bot_ConfigMem.Inst_frame7_bit25.Q
+ sky130_fd_sc_hd__dlxtp_1
XFILLER_36_174 VGND VGND VPWR VPWR sky130_fd_sc_hd__decap_3
XFILLER_51_111 VGND VGND VPWR VPWR sky130_fd_sc_hd__fill_1
XFILLER_101_37 VGND VGND VPWR VPWR sky130_fd_sc_hd__decap_3
XFILLER_51_122 VGND VGND VPWR VPWR sky130_fd_sc_hd__decap_3
XFILLER_51_199 VGND VGND VPWR VPWR sky130_fd_sc_hd__decap_3
XPHY_EDGE_ROW_175_Left_358 VGND VGND VPWR VPWR sky130_fd_sc_hd__decap_3
XFILLER_10_12 VGND VGND VPWR VPWR sky130_fd_sc_hd__decap_3
XFILLER_105_135 VGND VGND VPWR VPWR sky130_fd_sc_hd__decap_3
XFILLER_105_113 VGND VGND VPWR VPWR sky130_fd_sc_hd__decap_3
Xoutput350 net433 VGND VGND VPWR VPWR Tile_X0Y0_FrameData_O[24] sky130_fd_sc_hd__buf_2
Xoutput361 net444 VGND VGND VPWR VPWR Tile_X0Y0_FrameData_O[5] sky130_fd_sc_hd__buf_2
XFILLER_10_56 VGND VGND VPWR VPWR sky130_fd_sc_hd__decap_3
Xoutput394 net477 VGND VGND VPWR VPWR Tile_X0Y0_N2BEG[4] sky130_fd_sc_hd__buf_2
Xoutput372 net455 VGND VGND VPWR VPWR Tile_X0Y0_FrameStrobe_O[15] sky130_fd_sc_hd__buf_2
Xoutput383 net466 VGND VGND VPWR VPWR Tile_X0Y0_FrameStrobe_O[7] sky130_fd_sc_hd__buf_2
XFILLER_126_67 VGND VGND VPWR VPWR sky130_fd_sc_hd__decap_3
XFILLER_120_116 VGND VGND VPWR VPWR sky130_fd_sc_hd__fill_1
XFILLER_86_27 VGND VGND VPWR VPWR sky130_fd_sc_hd__fill_1
XFILLER_113_190 VGND VGND VPWR VPWR sky130_fd_sc_hd__decap_3
XFILLER_19_108 VGND VGND VPWR VPWR sky130_fd_sc_hd__decap_3
XFILLER_19_32 VGND VGND VPWR VPWR sky130_fd_sc_hd__decap_3
XFILLER_74_203 VGND VGND VPWR VPWR sky130_fd_sc_hd__decap_3
XTAP_TAPCELL_ROW_85_710 VGND VPWR sky130_fd_sc_hd__tapvpwrvgnd_1
XFILLER_142_88 VGND VGND VPWR VPWR sky130_fd_sc_hd__decap_3
XFILLER_27_163 VGND VGND VPWR VPWR sky130_fd_sc_hd__decap_3
XFILLER_27_185 VGND VGND VPWR VPWR sky130_fd_sc_hd__decap_3
XFILLER_35_42 VGND VGND VPWR VPWR sky130_fd_sc_hd__decap_3
XFILLER_42_144 VGND VGND VPWR VPWR sky130_fd_sc_hd__decap_3
XFILLER_42_188 VGND VGND VPWR VPWR sky130_fd_sc_hd__decap_3
XFILLER_167_30 VGND VGND VPWR VPWR sky130_fd_sc_hd__decap_3
XFILLER_128_227 VGND VGND VPWR VPWR sky130_fd_sc_hd__decap_3
XFILLER_51_96 VGND VGND VPWR VPWR sky130_fd_sc_hd__decap_3
X_1120_ net250 net298 VGND VGND VPWR VPWR Tile_X0Y1_OpenRAM_bot.Inst_OpenRAM_bot_ConfigMem.Inst_frame4_bit6.Q
+ sky130_fd_sc_hd__dlxtp_1
XFILLER_76_71 VGND VGND VPWR VPWR sky130_fd_sc_hd__decap_3
XTAP_TAPCELL_ROW_160_1011 VGND VPWR sky130_fd_sc_hd__tapvpwrvgnd_1
XFILLER_18_141 VGND VGND VPWR VPWR sky130_fd_sc_hd__decap_3
X_1051_ net224 net312 VGND VGND VPWR VPWR Tile_X0Y1_OpenRAM_bot.Inst_OpenRAM_bot_ConfigMem.Inst_frame2_bit11.Q
+ sky130_fd_sc_hd__dlxtp_1
XFILLER_80_206 VGND VGND VPWR VPWR sky130_fd_sc_hd__decap_3
XFILLER_33_111 VGND VGND VPWR VPWR sky130_fd_sc_hd__fill_1
XTAP_TAPCELL_ROW_91_735 VGND VPWR sky130_fd_sc_hd__tapvpwrvgnd_1
XFILLER_178_127 VGND VGND VPWR VPWR sky130_fd_sc_hd__decap_3
XFILLER_33_166 VGND VGND VPWR VPWR sky130_fd_sc_hd__fill_2
X_0904_ net115 net285 VGND VGND VPWR VPWR Tile_X0Y0_OpenRAM_top.Inst_OpenRAM_top_ConfigMem.Inst_frame6_bit10.Q
+ sky130_fd_sc_hd__dlxtp_1
XFILLER_119_216 VGND VGND VPWR VPWR sky130_fd_sc_hd__decap_3
X_0835_ net120 net300 VGND VGND VPWR VPWR Tile_X0Y0_OpenRAM_top.Inst_OpenRAM_top_ConfigMem.Inst_frame4_bit15.Q
+ sky130_fd_sc_hd__dlxtp_1
X_0766_ net126 net318 VGND VGND VPWR VPWR Tile_X0Y0_OpenRAM_top.Inst_OpenRAM_top_ConfigMem.Inst_frame2_bit20.Q
+ sky130_fd_sc_hd__dlxtp_1
X_0697_ net131 net335 VGND VGND VPWR VPWR Tile_X0Y0_OpenRAM_top.Inst_OpenRAM_top_ConfigMem.Inst_frame0_bit25.Q
+ sky130_fd_sc_hd__dlxtp_1
XFILLER_102_116 VGND VGND VPWR VPWR sky130_fd_sc_hd__decap_3
XFILLER_102_138 VGND VGND VPWR VPWR sky130_fd_sc_hd__fill_2
X_1318_ Tile_X0Y0_OpenRAM_top.Inst_OpenRAM_top_switch_matrix.N2BEG5 VGND VGND VPWR
+ VPWR net478 sky130_fd_sc_hd__clkbuf_2
XFILLER_56_214 VGND VGND VPWR VPWR sky130_fd_sc_hd__decap_3
X_1249_ net249 net265 VGND VGND VPWR VPWR Tile_X0Y1_OpenRAM_bot.Inst_OpenRAM_bot_ConfigMem.Inst_frame8_bit5.Q
+ sky130_fd_sc_hd__dlxtp_1
XFILLER_112_47 VGND VGND VPWR VPWR sky130_fd_sc_hd__decap_3
XFILLER_169_105 VGND VGND VPWR VPWR sky130_fd_sc_hd__decap_3
XFILLER_24_144 VGND VGND VPWR VPWR sky130_fd_sc_hd__decap_3
XFILLER_72_18 VGND VGND VPWR VPWR sky130_fd_sc_hd__decap_3
XFILLER_72_29 VGND VGND VPWR VPWR sky130_fd_sc_hd__decap_3
XFILLER_169_116 VGND VGND VPWR VPWR sky130_fd_sc_hd__decap_3
XFILLER_24_188 VGND VGND VPWR VPWR sky130_fd_sc_hd__decap_3
XFILLER_177_193 VGND VGND VPWR VPWR sky130_fd_sc_hd__decap_3
XFILLER_21_66 VGND VGND VPWR VPWR sky130_fd_sc_hd__decap_3
XFILLER_21_99 VGND VGND VPWR VPWR sky130_fd_sc_hd__decap_3
XFILLER_153_32 VGND VGND VPWR VPWR sky130_fd_sc_hd__decap_3
XTAP_TAPCELL_ROW_7_398 VGND VPWR sky130_fd_sc_hd__tapvpwrvgnd_1
XFILLER_46_41 VGND VGND VPWR VPWR sky130_fd_sc_hd__decap_3
XFILLER_62_206 VGND VGND VPWR VPWR sky130_fd_sc_hd__decap_3
XFILLER_15_100 VGND VGND VPWR VPWR sky130_fd_sc_hd__decap_3
XFILLER_15_122 VGND VGND VPWR VPWR sky130_fd_sc_hd__decap_3
XTAP_TAPCELL_ROW_140_931 VGND VPWR sky130_fd_sc_hd__tapvpwrvgnd_1
XFILLER_102_91 VGND VGND VPWR VPWR sky130_fd_sc_hd__decap_3
XFILLER_102_80 VGND VGND VPWR VPWR sky130_fd_sc_hd__decap_3
XFILLER_15_155 VGND VGND VPWR VPWR sky130_fd_sc_hd__decap_3
XFILLER_178_62 VGND VGND VPWR VPWR sky130_fd_sc_hd__decap_3
XFILLER_175_119 VGND VGND VPWR VPWR sky130_fd_sc_hd__decap_3
XFILLER_175_108 VGND VGND VPWR VPWR sky130_fd_sc_hd__decap_3
XFILLER_30_147 VGND VGND VPWR VPWR sky130_fd_sc_hd__decap_3
XFILLER_87_9 VGND VGND VPWR VPWR sky130_fd_sc_hd__decap_3
XFILLER_168_182 VGND VGND VPWR VPWR sky130_fd_sc_hd__decap_3
XFILLER_7_24 VGND VGND VPWR VPWR sky130_fd_sc_hd__decap_3
XFILLER_7_57 VGND VGND VPWR VPWR sky130_fd_sc_hd__decap_3
X_0620_ net179 _0027_ _0167_ VGND VGND VPWR VPWR _0168_ sky130_fd_sc_hd__o21a_1
X_0551_ net28 net60 _0145_ net260 Tile_X0Y1_OpenRAM_bot.Inst_OpenRAM_bot_ConfigMem.Inst_frame5_bit24.Q
+ Tile_X0Y1_OpenRAM_bot.Inst_OpenRAM_bot_ConfigMem.Inst_frame5_bit25.Q VGND VGND VPWR
+ VPWR Tile_X0Y1_OpenRAM_bot.Inst_OpenRAM_bot_switch_matrix.WW4BEG4 sky130_fd_sc_hd__mux4_1
XFILLER_97_125 VGND VGND VPWR VPWR sky130_fd_sc_hd__decap_3
XFILLER_97_103 VGND VGND VPWR VPWR sky130_fd_sc_hd__decap_3
X_0482_ _0096_ net257 Tile_X0Y0_OpenRAM_top.Inst_OpenRAM_top_ConfigMem.Inst_frame7_bit12.Q
+ VGND VGND VPWR VPWR _0124_ sky130_fd_sc_hd__mux2_1
XFILLER_97_147 VGND VGND VPWR VPWR sky130_fd_sc_hd__decap_3
XFILLER_38_225 VGND VGND VPWR VPWR sky130_fd_sc_hd__decap_3
X_1103_ net237 net296 VGND VGND VPWR VPWR Tile_X0Y1_OpenRAM_bot.Inst_OpenRAM_bot_ConfigMem.Inst_frame4_bit23.Q
+ sky130_fd_sc_hd__dlxtp_1
X_1034_ net242 net316 VGND VGND VPWR VPWR Tile_X0Y1_OpenRAM_bot.Inst_OpenRAM_bot_ConfigMem.Inst_frame2_bit28.Q
+ sky130_fd_sc_hd__dlxtp_1
XFILLER_21_125 VGND VGND VPWR VPWR sky130_fd_sc_hd__decap_3
XFILLER_166_119 VGND VGND VPWR VPWR sky130_fd_sc_hd__decap_3
XFILLER_21_158 VGND VGND VPWR VPWR sky130_fd_sc_hd__decap_3
XFILLER_21_169 VGND VGND VPWR VPWR sky130_fd_sc_hd__decap_3
XFILLER_174_130 VGND VGND VPWR VPWR sky130_fd_sc_hd__decap_3
XFILLER_174_141 VGND VGND VPWR VPWR sky130_fd_sc_hd__decap_3
XFILLER_174_174 VGND VGND VPWR VPWR sky130_fd_sc_hd__decap_3
Xinput82 Tile_X0Y0_E2MID[4] VGND VGND VPWR VPWR net82 sky130_fd_sc_hd__buf_1
Xinput71 Tile_X0Y0_E2END[1] VGND VGND VPWR VPWR net71 sky130_fd_sc_hd__clkbuf_2
X_0818_ net114 net308 VGND VGND VPWR VPWR Tile_X0Y0_OpenRAM_top.Inst_OpenRAM_top_ConfigMem.Inst_frame3_bit0.Q
+ sky130_fd_sc_hd__dlxtp_1
Xinput60 DOUT_B_SRAM4 VGND VGND VPWR VPWR net60 sky130_fd_sc_hd__dlymetal6s2s_1
Xinput93 Tile_X0Y0_E6END[5] VGND VGND VPWR VPWR net93 sky130_fd_sc_hd__dlymetal6s2s_1
X_0749_ net141 net326 VGND VGND VPWR VPWR Tile_X0Y0_OpenRAM_top.Inst_OpenRAM_top_ConfigMem.Inst_frame1_bit5.Q
+ sky130_fd_sc_hd__dlxtp_1
XFILLER_88_103 VGND VGND VPWR VPWR sky130_fd_sc_hd__decap_3
XFILLER_130_233 VGND VGND VPWR VPWR sky130_fd_sc_hd__fill_1
XFILLER_107_69 VGND VGND VPWR VPWR sky130_fd_sc_hd__decap_3
XFILLER_88_147 VGND VGND VPWR VPWR sky130_fd_sc_hd__decap_3
XTAP_TAPCELL_ROW_167_1039 VGND VPWR sky130_fd_sc_hd__tapvpwrvgnd_1
XFILLER_123_24 VGND VGND VPWR VPWR sky130_fd_sc_hd__decap_3
XFILLER_29_225 VGND VGND VPWR VPWR sky130_fd_sc_hd__fill_1
XFILLER_123_57 VGND VGND VPWR VPWR sky130_fd_sc_hd__decap_3
XFILLER_44_206 VGND VGND VPWR VPWR sky130_fd_sc_hd__decap_3
XFILLER_83_39 VGND VGND VPWR VPWR sky130_fd_sc_hd__decap_3
XFILLER_16_44 VGND VGND VPWR VPWR sky130_fd_sc_hd__decap_3
XFILLER_16_77 VGND VGND VPWR VPWR sky130_fd_sc_hd__decap_3
XFILLER_16_88 VGND VGND VPWR VPWR sky130_fd_sc_hd__decap_3
XFILLER_12_125 VGND VGND VPWR VPWR sky130_fd_sc_hd__fill_2
XFILLER_12_103 VGND VGND VPWR VPWR sky130_fd_sc_hd__decap_3
XFILLER_8_118 VGND VGND VPWR VPWR sky130_fd_sc_hd__decap_3
XFILLER_148_32 VGND VGND VPWR VPWR sky130_fd_sc_hd__decap_3
XFILLER_32_32 VGND VGND VPWR VPWR sky130_fd_sc_hd__decap_3
XFILLER_165_152 VGND VGND VPWR VPWR sky130_fd_sc_hd__decap_3
XFILLER_20_180 VGND VGND VPWR VPWR sky130_fd_sc_hd__decap_3
XFILLER_180_100 VGND VGND VPWR VPWR sky130_fd_sc_hd__decap_3
XFILLER_148_76 VGND VGND VPWR VPWR sky130_fd_sc_hd__decap_3
XFILLER_180_133 VGND VGND VPWR VPWR sky130_fd_sc_hd__decap_3
XFILLER_180_188 VGND VGND VPWR VPWR sky130_fd_sc_hd__decap_3
XFILLER_180_166 VGND VGND VPWR VPWR sky130_fd_sc_hd__decap_3
XFILLER_121_211 VGND VGND VPWR VPWR sky130_fd_sc_hd__decap_3
XFILLER_79_169 VGND VGND VPWR VPWR sky130_fd_sc_hd__decap_3
XFILLER_94_106 VGND VGND VPWR VPWR sky130_fd_sc_hd__decap_3
XFILLER_94_139 VGND VGND VPWR VPWR sky130_fd_sc_hd__fill_1
XFILLER_180_52 VGND VGND VPWR VPWR sky130_fd_sc_hd__decap_3
XFILLER_57_73 VGND VGND VPWR VPWR sky130_fd_sc_hd__fill_2
XFILLER_57_84 VGND VGND VPWR VPWR sky130_fd_sc_hd__decap_3
XFILLER_180_85 VGND VGND VPWR VPWR sky130_fd_sc_hd__decap_3
XFILLER_180_74 VGND VGND VPWR VPWR sky130_fd_sc_hd__decap_3
XFILLER_73_72 VGND VGND VPWR VPWR sky130_fd_sc_hd__decap_3
XFILLER_85_6 VGND VGND VPWR VPWR sky130_fd_sc_hd__decap_3
XFILLER_156_141 VGND VGND VPWR VPWR sky130_fd_sc_hd__decap_3
XFILLER_7_140 VGND VGND VPWR VPWR sky130_fd_sc_hd__decap_3
XFILLER_171_122 VGND VGND VPWR VPWR sky130_fd_sc_hd__decap_3
XFILLER_171_111 VGND VGND VPWR VPWR sky130_fd_sc_hd__fill_1
XFILLER_7_184 VGND VGND VPWR VPWR sky130_fd_sc_hd__decap_3
XFILLER_171_155 VGND VGND VPWR VPWR sky130_fd_sc_hd__decap_3
X_0603_ net215 net208 net199 _0153_ Tile_X0Y1_OpenRAM_bot.Inst_OpenRAM_bot_ConfigMem.Inst_frame2_bit2.Q
+ Tile_X0Y1_OpenRAM_bot.Inst_OpenRAM_bot_ConfigMem.Inst_frame2_bit3.Q VGND VGND VPWR
+ VPWR net408 sky130_fd_sc_hd__mux4_2
XFILLER_112_200 VGND VGND VPWR VPWR sky130_fd_sc_hd__decap_3
XFILLER_171_199 VGND VGND VPWR VPWR sky130_fd_sc_hd__decap_3
X_0534_ net28 net60 net260 _0084_ Tile_X0Y1_OpenRAM_bot.Inst_OpenRAM_bot_ConfigMem.Inst_frame6_bit24.Q
+ Tile_X0Y1_OpenRAM_bot.Inst_OpenRAM_bot_ConfigMem.Inst_frame6_bit25.Q VGND VGND VPWR
+ VPWR Tile_X0Y1_OpenRAM_bot.Inst_OpenRAM_bot_switch_matrix.W2BEG4 sky130_fd_sc_hd__mux4_1
X_0465_ _0110_ Tile_X0Y0_OpenRAM_top.Inst_OpenRAM_top_ConfigMem.Inst_frame1_bit5.Q
+ _0011_ _0109_ VGND VGND VPWR VPWR net379 sky130_fd_sc_hd__a2bb2o_1
XFILLER_78_180 VGND VGND VPWR VPWR sky130_fd_sc_hd__decap_3
X_0396_ net17 net49 Tile_X0Y0_OpenRAM_top.Inst_OpenRAM_top_switch_matrix.J_NS4_BEG9
+ net258 Tile_X0Y0_OpenRAM_top.Inst_OpenRAM_top_ConfigMem.Inst_frame4_bit8.Q Tile_X0Y0_OpenRAM_top.Inst_OpenRAM_top_ConfigMem.Inst_frame4_bit9.Q
+ VGND VGND VPWR VPWR Tile_X0Y0_OpenRAM_top.Inst_OpenRAM_top_switch_matrix.WW4BEG6
+ sky130_fd_sc_hd__mux4_1
XFILLER_26_228 VGND VGND VPWR VPWR sky130_fd_sc_hd__fill_2
XFILLER_179_200 VGND VGND VPWR VPWR sky130_fd_sc_hd__decap_3
X_1017_ net226 net322 VGND VGND VPWR VPWR Tile_X0Y1_OpenRAM_bot.Inst_OpenRAM_bot_ConfigMem.Inst_frame1_bit13.Q
+ sky130_fd_sc_hd__dlxtp_1
XFILLER_139_119 VGND VGND VPWR VPWR sky130_fd_sc_hd__fill_2
XFILLER_147_152 VGND VGND VPWR VPWR sky130_fd_sc_hd__decap_3
XTAP_TAPCELL_ROW_173_1065 VGND VPWR sky130_fd_sc_hd__tapvpwrvgnd_1
XFILLER_147_196 VGND VGND VPWR VPWR sky130_fd_sc_hd__decap_3
XPHY_EDGE_ROW_7_Left_190 VGND VGND VPWR VPWR sky130_fd_sc_hd__decap_3
XFILLER_118_35 VGND VGND VPWR VPWR sky130_fd_sc_hd__decap_3
XFILLER_103_211 VGND VGND VPWR VPWR sky130_fd_sc_hd__decap_3
XFILLER_76_106 VGND VGND VPWR VPWR sky130_fd_sc_hd__decap_3
XFILLER_94_38 VGND VGND VPWR VPWR sky130_fd_sc_hd__decap_3
XFILLER_27_21 VGND VGND VPWR VPWR sky130_fd_sc_hd__decap_3
XFILLER_27_43 VGND VGND VPWR VPWR sky130_fd_sc_hd__decap_3
XFILLER_84_150 VGND VGND VPWR VPWR sky130_fd_sc_hd__decap_3
XFILLER_150_44 VGND VGND VPWR VPWR sky130_fd_sc_hd__decap_3
XFILLER_27_87 VGND VGND VPWR VPWR sky130_fd_sc_hd__decap_3
XFILLER_84_183 VGND VGND VPWR VPWR sky130_fd_sc_hd__decap_3
XTAP_TAPCELL_ROW_0_371 VGND VPWR sky130_fd_sc_hd__tapvpwrvgnd_1
XFILLER_32_209 VGND VGND VPWR VPWR sky130_fd_sc_hd__decap_3
XPHY_EDGE_ROW_173_Right_173 VGND VGND VPWR VPWR sky130_fd_sc_hd__decap_3
XTAP_TAPCELL_ROW_23_462 VGND VPWR sky130_fd_sc_hd__tapvpwrvgnd_1
XFILLER_43_75 VGND VGND VPWR VPWR sky130_fd_sc_hd__decap_3
XFILLER_138_141 VGND VGND VPWR VPWR sky130_fd_sc_hd__decap_3
XFILLER_138_174 VGND VGND VPWR VPWR sky130_fd_sc_hd__decap_3
XFILLER_175_30 VGND VGND VPWR VPWR sky130_fd_sc_hd__decap_3
XFILLER_153_122 VGND VGND VPWR VPWR sky130_fd_sc_hd__decap_3
XFILLER_4_121 VGND VGND VPWR VPWR sky130_fd_sc_hd__decap_3
XFILLER_175_96 VGND VGND VPWR VPWR sky130_fd_sc_hd__decap_3
XFILLER_175_63 VGND VGND VPWR VPWR sky130_fd_sc_hd__decap_3
XFILLER_153_166 VGND VGND VPWR VPWR sky130_fd_sc_hd__fill_2
XFILLER_4_165 VGND VGND VPWR VPWR sky130_fd_sc_hd__decap_3
XFILLER_4_47 VGND VGND VPWR VPWR sky130_fd_sc_hd__decap_3
XFILLER_68_83 VGND VGND VPWR VPWR sky130_fd_sc_hd__fill_1
X_0250_ Tile_X0Y1_OpenRAM_bot.Inst_OpenRAM_bot_ConfigMem.Inst_frame3_bit22.Q VGND
+ VGND VPWR VPWR _0023_ sky130_fd_sc_hd__inv_2
Xinput261 Tile_X0Y1_N2END[3] VGND VGND VPWR VPWR net344 sky130_fd_sc_hd__buf_2
Xinput272 Tile_X0Y1_N2MID[6] VGND VGND VPWR VPWR net355 sky130_fd_sc_hd__buf_2
Xinput250 Tile_X0Y1_FrameData[6] VGND VGND VPWR VPWR net250 sky130_fd_sc_hd__clkbuf_4
XFILLER_75_161 VGND VGND VPWR VPWR sky130_fd_sc_hd__decap_3
XFILLER_84_82 VGND VGND VPWR VPWR sky130_fd_sc_hd__fill_2
XTAP_TAPCELL_ROW_46_554 VGND VPWR sky130_fd_sc_hd__tapvpwrvgnd_1
XFILLER_90_175 VGND VGND VPWR VPWR sky130_fd_sc_hd__decap_3
XFILLER_176_203 VGND VGND VPWR VPWR sky130_fd_sc_hd__decap_3
XFILLER_83_3 VGND VGND VPWR VPWR sky130_fd_sc_hd__decap_3
XPHY_EDGE_ROW_140_Right_140 VGND VGND VPWR VPWR sky130_fd_sc_hd__decap_3
XFILLER_129_152 VGND VGND VPWR VPWR sky130_fd_sc_hd__decap_3
XFILLER_144_144 VGND VGND VPWR VPWR sky130_fd_sc_hd__decap_3
XFILLER_144_177 VGND VGND VPWR VPWR sky130_fd_sc_hd__decap_3
X_0517_ net177 net196 Tile_X0Y1_OpenRAM_bot.Inst_OpenRAM_bot_switch_matrix.J_NS4_BEG15
+ _0080_ Tile_X0Y1_OpenRAM_bot.Inst_OpenRAM_bot_ConfigMem.Inst_frame7_bit10.Q Tile_X0Y1_OpenRAM_bot.Inst_OpenRAM_bot_ConfigMem.Inst_frame7_bit11.Q
+ VGND VGND VPWR VPWR Tile_X0Y1_OpenRAM_bot.Inst_OpenRAM_bot_switch_matrix.S1BEG3
+ sky130_fd_sc_hd__mux4_1
XFILLER_100_203 VGND VGND VPWR VPWR sky130_fd_sc_hd__decap_3
X_1497_ Tile_X0Y1_OpenRAM_bot.Inst_OpenRAM_bot_switch_matrix.WW4BEG3 VGND VGND VPWR
+ VPWR net663 sky130_fd_sc_hd__clkbuf_1
XFILLER_104_15 VGND VGND VPWR VPWR sky130_fd_sc_hd__decap_3
X_0448_ net79 net258 Tile_X0Y0_OpenRAM_top.Inst_OpenRAM_top_ConfigMem.Inst_frame2_bit27.Q
+ VGND VGND VPWR VPWR _0099_ sky130_fd_sc_hd__mux2_1
XTAP_TAPCELL_ROW_69_646 VGND VPWR sky130_fd_sc_hd__tapvpwrvgnd_1
XFILLER_104_59 VGND VGND VPWR VPWR sky130_fd_sc_hd__decap_3
X_0379_ net20 net52 net258 Tile_X0Y0_OpenRAM_top.Inst_OpenRAM_top_switch_matrix.J_NS2_BEG6
+ Tile_X0Y0_OpenRAM_top.Inst_OpenRAM_top_ConfigMem.Inst_frame5_bit14.Q Tile_X0Y0_OpenRAM_top.Inst_OpenRAM_top_ConfigMem.Inst_frame5_bit15.Q
+ VGND VGND VPWR VPWR Tile_X0Y0_OpenRAM_top.Inst_OpenRAM_top_switch_matrix.W2BEGb1
+ sky130_fd_sc_hd__mux4_1
XTAP_TAPCELL_ROW_37_521 VGND VPWR sky130_fd_sc_hd__tapvpwrvgnd_1
XFILLER_81_131 VGND VGND VPWR VPWR sky130_fd_sc_hd__decap_3
XFILLER_14_209 VGND VGND VPWR VPWR sky130_fd_sc_hd__decap_3
XFILLER_120_36 VGND VGND VPWR VPWR sky130_fd_sc_hd__decap_3
XFILLER_167_214 VGND VGND VPWR VPWR sky130_fd_sc_hd__decap_3
XFILLER_80_29 VGND VGND VPWR VPWR sky130_fd_sc_hd__fill_2
XFILLER_167_225 VGND VGND VPWR VPWR sky130_fd_sc_hd__decap_3
XTAP_TAPCELL_ROW_52_579 VGND VPWR sky130_fd_sc_hd__tapvpwrvgnd_1
XFILLER_13_45 VGND VGND VPWR VPWR sky130_fd_sc_hd__decap_3
XFILLER_135_122 VGND VGND VPWR VPWR sky130_fd_sc_hd__decap_3
XFILLER_129_78 VGND VGND VPWR VPWR sky130_fd_sc_hd__decap_3
XFILLER_145_22 VGND VGND VPWR VPWR sky130_fd_sc_hd__decap_3
XFILLER_49_128 VGND VGND VPWR VPWR sky130_fd_sc_hd__decap_3
XFILLER_161_43 VGND VGND VPWR VPWR sky130_fd_sc_hd__decap_3
XFILLER_38_75 VGND VGND VPWR VPWR sky130_fd_sc_hd__decap_3
XFILLER_38_97 VGND VGND VPWR VPWR sky130_fd_sc_hd__decap_3
XFILLER_64_109 VGND VGND VPWR VPWR sky130_fd_sc_hd__decap_3
XFILLER_161_76 VGND VGND VPWR VPWR sky130_fd_sc_hd__decap_3
XFILLER_72_120 VGND VGND VPWR VPWR sky130_fd_sc_hd__decap_3
XFILLER_54_41 VGND VGND VPWR VPWR sky130_fd_sc_hd__decap_3
XFILLER_72_153 VGND VGND VPWR VPWR sky130_fd_sc_hd__decap_3
XFILLER_72_197 VGND VGND VPWR VPWR sky130_fd_sc_hd__decap_3
XFILLER_158_203 VGND VGND VPWR VPWR sky130_fd_sc_hd__decap_3
XFILLER_13_220 VGND VGND VPWR VPWR sky130_fd_sc_hd__decap_3
XFILLER_158_225 VGND VGND VPWR VPWR sky130_fd_sc_hd__fill_1
XFILLER_110_80 VGND VGND VPWR VPWR sky130_fd_sc_hd__decap_3
XFILLER_9_202 VGND VGND VPWR VPWR sky130_fd_sc_hd__decap_3
XFILLER_110_91 VGND VGND VPWR VPWR sky130_fd_sc_hd__decap_3
XFILLER_70_62 VGND VGND VPWR VPWR sky130_fd_sc_hd__decap_3
XFILLER_173_228 VGND VGND VPWR VPWR sky130_fd_sc_hd__fill_2
XFILLER_173_217 VGND VGND VPWR VPWR sky130_fd_sc_hd__decap_3
XFILLER_126_122 VGND VGND VPWR VPWR sky130_fd_sc_hd__decap_3
XFILLER_126_177 VGND VGND VPWR VPWR sky130_fd_sc_hd__decap_3
XFILLER_141_136 VGND VGND VPWR VPWR sky130_fd_sc_hd__decap_3
X_1420_ net240 VGND VGND VPWR VPWR net572 sky130_fd_sc_hd__buf_6
X_1351_ Tile_X0Y0_OpenRAM_top.Inst_OpenRAM_top_switch_matrix.W2BEG1 VGND VGND VPWR
+ VPWR net511 sky130_fd_sc_hd__clkbuf_1
X_0302_ Tile_X0Y0_OpenRAM_top.Inst_OpenRAM_top_switch_matrix.N1END2 net90 Tile_X0Y0_OpenRAM_top.Inst_OpenRAM_top_ConfigMem.Inst_frame0_bit28.Q
+ VGND VGND VPWR VPWR _0067_ sky130_fd_sc_hd__mux2_1
XPHY_EDGE_ROW_79_Left_262 VGND VGND VPWR VPWR sky130_fd_sc_hd__decap_3
X_1282_ net131 VGND VGND VPWR VPWR net434 sky130_fd_sc_hd__buf_1
XTAP_TAPCELL_ROW_118_842 VGND VPWR sky130_fd_sc_hd__tapvpwrvgnd_1
X_0233_ Tile_X0Y0_OpenRAM_top.Inst_OpenRAM_top_ConfigMem.Inst_frame2_bit26.Q VGND
+ VGND VPWR VPWR _0006_ sky130_fd_sc_hd__inv_2
XFILLER_48_150 VGND VGND VPWR VPWR sky130_fd_sc_hd__decap_3
XFILLER_55_109 VGND VGND VPWR VPWR sky130_fd_sc_hd__decap_3
XFILLER_95_92 VGND VGND VPWR VPWR sky130_fd_sc_hd__decap_3
XFILLER_48_183 VGND VGND VPWR VPWR sky130_fd_sc_hd__decap_3
XFILLER_63_175 VGND VGND VPWR VPWR sky130_fd_sc_hd__decap_3
XPHY_EDGE_ROW_88_Left_271 VGND VGND VPWR VPWR sky130_fd_sc_hd__decap_3
XFILLER_149_225 VGND VGND VPWR VPWR sky130_fd_sc_hd__decap_3
XTAP_TAPCELL_ROW_101_775 VGND VPWR sky130_fd_sc_hd__tapvpwrvgnd_1
X_0997_ net233 net331 VGND VGND VPWR VPWR Tile_X0Y1_OpenRAM_bot.Inst_OpenRAM_bot_ConfigMem.Inst_frame0_bit1.Q
+ sky130_fd_sc_hd__dlxtp_1
XFILLER_117_122 VGND VGND VPWR VPWR sky130_fd_sc_hd__decap_3
XFILLER_117_155 VGND VGND VPWR VPWR sky130_fd_sc_hd__decap_3
Xoutput510 net593 VGND VGND VPWR VPWR Tile_X0Y1_S2BEG[3] sky130_fd_sc_hd__buf_2
XFILLER_132_125 VGND VGND VPWR VPWR sky130_fd_sc_hd__decap_3
XFILLER_117_199 VGND VGND VPWR VPWR sky130_fd_sc_hd__decap_3
Xoutput554 net637 VGND VGND VPWR VPWR Tile_X0Y1_W2BEGb[3] sky130_fd_sc_hd__buf_2
Xoutput543 net626 VGND VGND VPWR VPWR Tile_X0Y1_W2BEG[0] sky130_fd_sc_hd__buf_2
Xoutput532 net615 VGND VGND VPWR VPWR Tile_X0Y1_S4BEG[3] sky130_fd_sc_hd__buf_2
Xoutput521 net604 VGND VGND VPWR VPWR Tile_X0Y1_S2BEGb[6] sky130_fd_sc_hd__buf_2
XFILLER_59_19 VGND VGND VPWR VPWR sky130_fd_sc_hd__decap_3
XPHY_EDGE_ROW_97_Left_280 VGND VGND VPWR VPWR sky130_fd_sc_hd__decap_3
XFILLER_5_90 VGND VGND VPWR VPWR sky130_fd_sc_hd__decap_3
Xoutput576 net659 VGND VGND VPWR VPWR Tile_X0Y1_WW4BEG[14] sky130_fd_sc_hd__buf_2
Xoutput565 net648 VGND VGND VPWR VPWR Tile_X0Y1_W6BEG[4] sky130_fd_sc_hd__buf_2
Xoutput587 net670 VGND VGND VPWR VPWR WEB_A_SRAM sky130_fd_sc_hd__buf_2
XFILLER_115_36 VGND VGND VPWR VPWR sky130_fd_sc_hd__decap_3
XFILLER_86_212 VGND VGND VPWR VPWR sky130_fd_sc_hd__decap_3
Xfanout258 Tile_X0Y0_OpenRAM_top.Inst_OpenRAM_top_switch_matrix.J_NS2_BEG1 VGND VGND
+ VPWR VPWR net258 sky130_fd_sc_hd__clkbuf_4
Xfanout269 Tile_X0Y1_FrameStrobe[8] VGND VGND VPWR VPWR net269 sky130_fd_sc_hd__buf_2
XFILLER_115_69 VGND VGND VPWR VPWR sky130_fd_sc_hd__decap_3
XFILLER_75_18 VGND VGND VPWR VPWR sky130_fd_sc_hd__decap_3
XFILLER_131_24 VGND VGND VPWR VPWR sky130_fd_sc_hd__decap_3
XFILLER_39_172 VGND VGND VPWR VPWR sky130_fd_sc_hd__decap_3
XFILLER_54_153 VGND VGND VPWR VPWR sky130_fd_sc_hd__decap_3
XTAP_TAPCELL_ROW_124_867 VGND VPWR sky130_fd_sc_hd__tapvpwrvgnd_1
XFILLER_54_186 VGND VGND VPWR VPWR sky130_fd_sc_hd__decap_3
XFILLER_54_197 VGND VGND VPWR VPWR sky130_fd_sc_hd__decap_3
XFILLER_91_39 VGND VGND VPWR VPWR sky130_fd_sc_hd__decap_3
XFILLER_24_44 VGND VGND VPWR VPWR sky130_fd_sc_hd__decap_3
XFILLER_10_212 VGND VGND VPWR VPWR sky130_fd_sc_hd__decap_3
XFILLER_24_88 VGND VGND VPWR VPWR sky130_fd_sc_hd__fill_1
XFILLER_24_99 VGND VGND VPWR VPWR sky130_fd_sc_hd__decap_3
XFILLER_155_228 VGND VGND VPWR VPWR sky130_fd_sc_hd__fill_2
XFILLER_108_100 VGND VGND VPWR VPWR sky130_fd_sc_hd__decap_3
XFILLER_108_133 VGND VGND VPWR VPWR sky130_fd_sc_hd__decap_3
XFILLER_40_32 VGND VGND VPWR VPWR sky130_fd_sc_hd__decap_3
XFILLER_170_209 VGND VGND VPWR VPWR sky130_fd_sc_hd__decap_3
XFILLER_156_32 VGND VGND VPWR VPWR sky130_fd_sc_hd__decap_3
XFILLER_108_177 VGND VGND VPWR VPWR sky130_fd_sc_hd__decap_3
XFILLER_108_144 VGND VGND VPWR VPWR sky130_fd_sc_hd__decap_3
XFILLER_156_65 VGND VGND VPWR VPWR sky130_fd_sc_hd__decap_3
XFILLER_123_169 VGND VGND VPWR VPWR sky130_fd_sc_hd__decap_3
XFILLER_123_158 VGND VGND VPWR VPWR sky130_fd_sc_hd__decap_3
XFILLER_49_63 VGND VGND VPWR VPWR sky130_fd_sc_hd__decap_3
XFILLER_172_53 VGND VGND VPWR VPWR sky130_fd_sc_hd__decap_3
XFILLER_49_96 VGND VGND VPWR VPWR sky130_fd_sc_hd__decap_3
XFILLER_172_97 VGND VGND VPWR VPWR sky130_fd_sc_hd__decap_3
XTAP_TAPCELL_ROW_147_959 VGND VPWR sky130_fd_sc_hd__tapvpwrvgnd_1
XFILLER_1_15 VGND VGND VPWR VPWR sky130_fd_sc_hd__decap_3
XFILLER_92_215 VGND VGND VPWR VPWR sky130_fd_sc_hd__decap_3
XFILLER_65_51 VGND VGND VPWR VPWR sky130_fd_sc_hd__decap_3
XTAP_TAPCELL_ROW_155_992 VGND VPWR sky130_fd_sc_hd__tapvpwrvgnd_1
XFILLER_65_84 VGND VGND VPWR VPWR sky130_fd_sc_hd__decap_3
XFILLER_45_175 VGND VGND VPWR VPWR sky130_fd_sc_hd__decap_3
XFILLER_60_112 VGND VGND VPWR VPWR sky130_fd_sc_hd__decap_3
X_0920_ net132 net275 VGND VGND VPWR VPWR Tile_X0Y0_OpenRAM_top.Inst_OpenRAM_top_ConfigMem.Inst_frame7_bit26.Q
+ sky130_fd_sc_hd__dlxtp_1
XFILLER_60_156 VGND VGND VPWR VPWR sky130_fd_sc_hd__decap_3
XFILLER_81_72 VGND VGND VPWR VPWR sky130_fd_sc_hd__decap_3
XFILLER_81_83 VGND VGND VPWR VPWR sky130_fd_sc_hd__fill_2
XFILLER_146_206 VGND VGND VPWR VPWR sky130_fd_sc_hd__decap_3
X_0851_ net138 net291 VGND VGND VPWR VPWR Tile_X0Y0_OpenRAM_top.Inst_OpenRAM_top_ConfigMem.Inst_frame5_bit31.Q
+ sky130_fd_sc_hd__dlxtp_1
X_0782_ net140 net319 VGND VGND VPWR VPWR Tile_X0Y0_OpenRAM_top.Inst_OpenRAM_top_ConfigMem.Inst_frame2_bit4.Q
+ sky130_fd_sc_hd__dlxtp_1
XFILLER_114_136 VGND VGND VPWR VPWR sky130_fd_sc_hd__decap_3
XFILLER_114_103 VGND VGND VPWR VPWR sky130_fd_sc_hd__decap_3
XPHY_EDGE_ROW_18_Right_18 VGND VGND VPWR VPWR sky130_fd_sc_hd__decap_3
X_1403_ net253 VGND VGND VPWR VPWR net585 sky130_fd_sc_hd__buf_6
XFILLER_68_212 VGND VGND VPWR VPWR sky130_fd_sc_hd__decap_3
X_1334_ Tile_X0Y1_N4END[13] VGND VGND VPWR VPWR net500 sky130_fd_sc_hd__buf_6
X_1265_ net144 VGND VGND VPWR VPWR net447 sky130_fd_sc_hd__clkbuf_2
XFILLER_28_109 VGND VGND VPWR VPWR sky130_fd_sc_hd__decap_3
XFILLER_83_215 VGND VGND VPWR VPWR sky130_fd_sc_hd__decap_3
Xinput3 DOUT_A_SRAM1 VGND VGND VPWR VPWR net3 sky130_fd_sc_hd__buf_1
XFILLER_36_153 VGND VGND VPWR VPWR sky130_fd_sc_hd__decap_3
X_1196_ net240 net270 VGND VGND VPWR VPWR Tile_X0Y1_OpenRAM_bot.Inst_OpenRAM_bot_ConfigMem.Inst_frame7_bit26.Q
+ sky130_fd_sc_hd__dlxtp_1
XFILLER_36_186 VGND VGND VPWR VPWR sky130_fd_sc_hd__decap_3
XPHY_EDGE_ROW_27_Right_27 VGND VGND VPWR VPWR sky130_fd_sc_hd__decap_3
XFILLER_51_167 VGND VGND VPWR VPWR sky130_fd_sc_hd__fill_1
XFILLER_3_208 VGND VGND VPWR VPWR sky130_fd_sc_hd__decap_3
XFILLER_10_35 VGND VGND VPWR VPWR sky130_fd_sc_hd__decap_3
XFILLER_10_24 VGND VGND VPWR VPWR sky130_fd_sc_hd__decap_3
Xoutput351 net434 VGND VGND VPWR VPWR Tile_X0Y0_FrameData_O[25] sky130_fd_sc_hd__buf_2
Xoutput340 net423 VGND VGND VPWR VPWR Tile_X0Y0_FrameData_O[15] sky130_fd_sc_hd__buf_2
Xoutput362 net445 VGND VGND VPWR VPWR Tile_X0Y0_FrameData_O[6] sky130_fd_sc_hd__buf_2
XFILLER_126_35 VGND VGND VPWR VPWR sky130_fd_sc_hd__decap_3
XFILLER_105_158 VGND VGND VPWR VPWR sky130_fd_sc_hd__decap_3
XFILLER_10_68 VGND VGND VPWR VPWR sky130_fd_sc_hd__decap_3
XPHY_EDGE_ROW_36_Right_36 VGND VGND VPWR VPWR sky130_fd_sc_hd__decap_3
Xoutput384 net467 VGND VGND VPWR VPWR Tile_X0Y0_FrameStrobe_O[8] sky130_fd_sc_hd__buf_2
Xoutput373 net456 VGND VGND VPWR VPWR Tile_X0Y0_FrameStrobe_O[16] sky130_fd_sc_hd__buf_2
Xoutput395 net478 VGND VGND VPWR VPWR Tile_X0Y0_N2BEG[5] sky130_fd_sc_hd__buf_2
XFILLER_120_106 VGND VGND VPWR VPWR sky130_fd_sc_hd__fill_1
XFILLER_59_212 VGND VGND VPWR VPWR sky130_fd_sc_hd__decap_3
XFILLER_19_55 VGND VGND VPWR VPWR sky130_fd_sc_hd__fill_1
XTAP_TAPCELL_ROW_85_711 VGND VPWR sky130_fd_sc_hd__tapvpwrvgnd_1
XFILLER_142_56 VGND VGND VPWR VPWR sky130_fd_sc_hd__decap_3
XFILLER_74_215 VGND VGND VPWR VPWR sky130_fd_sc_hd__decap_3
XFILLER_27_131 VGND VGND VPWR VPWR sky130_fd_sc_hd__decap_3
XFILLER_35_21 VGND VGND VPWR VPWR sky130_fd_sc_hd__decap_3
XPHY_EDGE_ROW_45_Right_45 VGND VGND VPWR VPWR sky130_fd_sc_hd__decap_3
XFILLER_27_197 VGND VGND VPWR VPWR sky130_fd_sc_hd__decap_3
XFILLER_35_54 VGND VGND VPWR VPWR sky130_fd_sc_hd__fill_2
XFILLER_42_134 VGND VGND VPWR VPWR sky130_fd_sc_hd__decap_3
XFILLER_42_167 VGND VGND VPWR VPWR sky130_fd_sc_hd__decap_3
XFILLER_128_206 VGND VGND VPWR VPWR sky130_fd_sc_hd__decap_3
XFILLER_51_53 VGND VGND VPWR VPWR sky130_fd_sc_hd__decap_3
XFILLER_167_42 VGND VGND VPWR VPWR sky130_fd_sc_hd__decap_3
XFILLER_51_75 VGND VGND VPWR VPWR sky130_fd_sc_hd__decap_3
XFILLER_167_97 VGND VGND VPWR VPWR sky130_fd_sc_hd__decap_3
XFILLER_167_75 VGND VGND VPWR VPWR sky130_fd_sc_hd__decap_3
XFILLER_143_209 VGND VGND VPWR VPWR sky130_fd_sc_hd__fill_1
XPHY_EDGE_ROW_54_Right_54 VGND VGND VPWR VPWR sky130_fd_sc_hd__decap_3
XFILLER_111_139 VGND VGND VPWR VPWR sky130_fd_sc_hd__decap_3
XFILLER_76_50 VGND VGND VPWR VPWR sky130_fd_sc_hd__decap_3
XFILLER_76_83 VGND VGND VPWR VPWR sky130_fd_sc_hd__fill_1
XFILLER_76_94 VGND VGND VPWR VPWR sky130_fd_sc_hd__decap_3
XTAP_TAPCELL_ROW_160_1012 VGND VPWR sky130_fd_sc_hd__tapvpwrvgnd_1
X_1050_ net225 net312 VGND VGND VPWR VPWR Tile_X0Y1_OpenRAM_bot.Inst_OpenRAM_bot_ConfigMem.Inst_frame2_bit12.Q
+ sky130_fd_sc_hd__dlxtp_1
XPHY_EDGE_ROW_63_Right_63 VGND VGND VPWR VPWR sky130_fd_sc_hd__decap_3
XTAP_TAPCELL_ROW_91_736 VGND VPWR sky130_fd_sc_hd__tapvpwrvgnd_1
XFILLER_178_106 VGND VGND VPWR VPWR sky130_fd_sc_hd__decap_3
XFILLER_18_197 VGND VGND VPWR VPWR sky130_fd_sc_hd__decap_3
XFILLER_33_134 VGND VGND VPWR VPWR sky130_fd_sc_hd__decap_3
XFILLER_178_139 VGND VGND VPWR VPWR sky130_fd_sc_hd__fill_1
X_0903_ net116 net285 VGND VGND VPWR VPWR Tile_X0Y0_OpenRAM_top.Inst_OpenRAM_top_ConfigMem.Inst_frame6_bit11.Q
+ sky130_fd_sc_hd__dlxtp_1
X_0834_ net121 net301 VGND VGND VPWR VPWR Tile_X0Y0_OpenRAM_top.Inst_OpenRAM_top_ConfigMem.Inst_frame4_bit16.Q
+ sky130_fd_sc_hd__dlxtp_1
XPHY_EDGE_ROW_72_Right_72 VGND VGND VPWR VPWR sky130_fd_sc_hd__decap_3
X_0765_ net127 net318 VGND VGND VPWR VPWR Tile_X0Y0_OpenRAM_top.Inst_OpenRAM_top_ConfigMem.Inst_frame2_bit21.Q
+ sky130_fd_sc_hd__dlxtp_1
X_0696_ net132 net336 VGND VGND VPWR VPWR Tile_X0Y0_OpenRAM_top.Inst_OpenRAM_top_ConfigMem.Inst_frame0_bit26.Q
+ sky130_fd_sc_hd__dlxtp_1
X_1317_ Tile_X0Y0_OpenRAM_top.Inst_OpenRAM_top_switch_matrix.N2BEG4 VGND VGND VPWR
+ VPWR net477 sky130_fd_sc_hd__buf_1
XFILLER_110_172 VGND VGND VPWR VPWR sky130_fd_sc_hd__fill_1
XFILLER_56_226 VGND VGND VPWR VPWR sky130_fd_sc_hd__decap_3
XPHY_EDGE_ROW_81_Right_81 VGND VGND VPWR VPWR sky130_fd_sc_hd__decap_3
XFILLER_110_194 VGND VGND VPWR VPWR sky130_fd_sc_hd__fill_2
XPHY_EDGE_ROW_16_Left_199 VGND VGND VPWR VPWR sky130_fd_sc_hd__decap_3
XFILLER_2_91 VGND VGND VPWR VPWR sky130_fd_sc_hd__decap_3
X_1248_ net250 net265 VGND VGND VPWR VPWR Tile_X0Y1_OpenRAM_bot.Inst_OpenRAM_bot_ConfigMem.Inst_frame8_bit6.Q
+ sky130_fd_sc_hd__dlxtp_1
XFILLER_112_59 VGND VGND VPWR VPWR sky130_fd_sc_hd__decap_3
XFILLER_24_123 VGND VGND VPWR VPWR sky130_fd_sc_hd__decap_3
X_1179_ net224 net279 VGND VGND VPWR VPWR Tile_X0Y1_OpenRAM_bot.Inst_OpenRAM_bot_ConfigMem.Inst_frame6_bit11.Q
+ sky130_fd_sc_hd__dlxtp_1
XFILLER_169_128 VGND VGND VPWR VPWR sky130_fd_sc_hd__decap_3
XFILLER_24_156 VGND VGND VPWR VPWR sky130_fd_sc_hd__decap_3
XFILLER_177_172 VGND VGND VPWR VPWR sky130_fd_sc_hd__decap_3
XFILLER_177_161 VGND VGND VPWR VPWR sky130_fd_sc_hd__decap_3
XTAP_TAPCELL_ROW_176_1074 VGND VPWR sky130_fd_sc_hd__tapvpwrvgnd_1
XPHY_EDGE_ROW_90_Right_90 VGND VGND VPWR VPWR sky130_fd_sc_hd__decap_3
XFILLER_21_45 VGND VGND VPWR VPWR sky130_fd_sc_hd__decap_3
XFILLER_21_78 VGND VGND VPWR VPWR sky130_fd_sc_hd__decap_3
XFILLER_97_27 VGND VGND VPWR VPWR sky130_fd_sc_hd__decap_3
XFILLER_153_66 VGND VGND VPWR VPWR sky130_fd_sc_hd__decap_3
XFILLER_153_44 VGND VGND VPWR VPWR sky130_fd_sc_hd__decap_3
XTAP_TAPCELL_ROW_7_399 VGND VPWR sky130_fd_sc_hd__tapvpwrvgnd_1
XFILLER_15_134 VGND VGND VPWR VPWR sky130_fd_sc_hd__decap_3
XTAP_TAPCELL_ROW_140_932 VGND VPWR sky130_fd_sc_hd__tapvpwrvgnd_1
XFILLER_15_167 VGND VGND VPWR VPWR sky130_fd_sc_hd__fill_1
XFILLER_15_189 VGND VGND VPWR VPWR sky130_fd_sc_hd__decap_3
XFILLER_62_41 VGND VGND VPWR VPWR sky130_fd_sc_hd__decap_3
XFILLER_178_41 VGND VGND VPWR VPWR sky130_fd_sc_hd__decap_3
XFILLER_168_161 VGND VGND VPWR VPWR sky130_fd_sc_hd__decap_3
XFILLER_30_159 VGND VGND VPWR VPWR sky130_fd_sc_hd__decap_3
XFILLER_62_85 VGND VGND VPWR VPWR sky130_fd_sc_hd__decap_3
XFILLER_178_85 VGND VGND VPWR VPWR sky130_fd_sc_hd__decap_3
XFILLER_178_74 VGND VGND VPWR VPWR sky130_fd_sc_hd__decap_3
XFILLER_168_194 VGND VGND VPWR VPWR sky130_fd_sc_hd__fill_2
XFILLER_7_36 VGND VGND VPWR VPWR sky130_fd_sc_hd__decap_3
XFILLER_116_209 VGND VGND VPWR VPWR sky130_fd_sc_hd__decap_3
XFILLER_7_69 VGND VGND VPWR VPWR sky130_fd_sc_hd__decap_3
X_0550_ net340 net360 _0077_ net173 Tile_X0Y1_OpenRAM_bot.Inst_OpenRAM_bot_ConfigMem.Inst_frame1_bit30.Q
+ Tile_X0Y1_OpenRAM_bot.Inst_OpenRAM_bot_ConfigMem.Inst_frame1_bit31.Q VGND VGND VPWR
+ VPWR _0145_ sky130_fd_sc_hd__mux4_2
X_0481_ net87 Tile_X0Y0_OpenRAM_top.Inst_OpenRAM_top_switch_matrix.J_NS4_BEG14 Tile_X0Y0_OpenRAM_top.Inst_OpenRAM_top_ConfigMem.Inst_frame7_bit12.Q
+ VGND VGND VPWR VPWR _0123_ sky130_fd_sc_hd__mux2_1
XFILLER_97_137 VGND VGND VPWR VPWR sky130_fd_sc_hd__decap_3
XFILLER_87_60 VGND VGND VPWR VPWR sky130_fd_sc_hd__decap_3
XFILLER_97_159 VGND VGND VPWR VPWR sky130_fd_sc_hd__decap_3
XFILLER_38_204 VGND VGND VPWR VPWR sky130_fd_sc_hd__decap_3
X_1102_ net238 net296 VGND VGND VPWR VPWR Tile_X0Y1_OpenRAM_bot.Inst_OpenRAM_bot_ConfigMem.Inst_frame4_bit24.Q
+ sky130_fd_sc_hd__dlxtp_1
XFILLER_53_229 VGND VGND VPWR VPWR sky130_fd_sc_hd__fill_1
X_1033_ net243 net316 VGND VGND VPWR VPWR Tile_X0Y1_OpenRAM_bot.Inst_OpenRAM_bot_ConfigMem.Inst_frame2_bit29.Q
+ sky130_fd_sc_hd__dlxtp_1
XFILLER_159_161 VGND VGND VPWR VPWR sky130_fd_sc_hd__decap_3
XFILLER_159_172 VGND VGND VPWR VPWR sky130_fd_sc_hd__decap_3
XFILLER_174_153 VGND VGND VPWR VPWR sky130_fd_sc_hd__decap_3
XFILLER_174_197 VGND VGND VPWR VPWR sky130_fd_sc_hd__decap_3
XFILLER_174_186 VGND VGND VPWR VPWR sky130_fd_sc_hd__decap_3
Xinput72 Tile_X0Y0_E2END[2] VGND VGND VPWR VPWR net72 sky130_fd_sc_hd__clkbuf_2
X_0817_ net125 net308 VGND VGND VPWR VPWR Tile_X0Y0_OpenRAM_top.Inst_OpenRAM_top_ConfigMem.Inst_frame3_bit1.Q
+ sky130_fd_sc_hd__dlxtp_1
Xinput61 DOUT_B_SRAM5 VGND VGND VPWR VPWR net61 sky130_fd_sc_hd__buf_1
Xinput50 DOUT_B_SRAM23 VGND VGND VPWR VPWR net50 sky130_fd_sc_hd__clkbuf_2
X_0748_ net142 net328 VGND VGND VPWR VPWR Tile_X0Y0_OpenRAM_top.Inst_OpenRAM_top_ConfigMem.Inst_frame1_bit6.Q
+ sky130_fd_sc_hd__dlxtp_1
Xinput94 Tile_X0Y0_E6END[6] VGND VGND VPWR VPWR net94 sky130_fd_sc_hd__clkbuf_2
Xinput83 Tile_X0Y0_E2MID[5] VGND VGND VPWR VPWR net83 sky130_fd_sc_hd__buf_1
XFILLER_88_126 VGND VGND VPWR VPWR sky130_fd_sc_hd__decap_3
XFILLER_88_137 VGND VGND VPWR VPWR sky130_fd_sc_hd__decap_3
X_0679_ Tile_X0Y1_OpenRAM_bot.Inst_OpenRAM_bot_ConfigMem.Inst_frame3_bit13.Q _0215_
+ _0213_ Tile_X0Y1_OpenRAM_bot.Inst_OpenRAM_bot_ConfigMem.Inst_frame3_bit12.Q VGND
+ VGND VPWR VPWR _0216_ sky130_fd_sc_hd__o211a_1
XFILLER_88_159 VGND VGND VPWR VPWR sky130_fd_sc_hd__fill_2
XFILLER_96_181 VGND VGND VPWR VPWR sky130_fd_sc_hd__decap_3
XPHY_EDGE_ROW_24_Left_207 VGND VGND VPWR VPWR sky130_fd_sc_hd__decap_3
XFILLER_29_215 VGND VGND VPWR VPWR sky130_fd_sc_hd__decap_3
XFILLER_123_36 VGND VGND VPWR VPWR sky130_fd_sc_hd__decap_3
XFILLER_123_69 VGND VGND VPWR VPWR sky130_fd_sc_hd__decap_3
XFILLER_83_18 VGND VGND VPWR VPWR sky130_fd_sc_hd__decap_3
XPHY_EDGE_ROW_154_Right_154 VGND VGND VPWR VPWR sky130_fd_sc_hd__decap_3
XFILLER_16_56 VGND VGND VPWR VPWR sky130_fd_sc_hd__decap_3
XPHY_EDGE_ROW_0_Right_0 VGND VGND VPWR VPWR sky130_fd_sc_hd__decap_3
XPHY_EDGE_ROW_33_Left_216 VGND VGND VPWR VPWR sky130_fd_sc_hd__decap_3
XFILLER_148_22 VGND VGND VPWR VPWR sky130_fd_sc_hd__fill_1
XFILLER_32_44 VGND VGND VPWR VPWR sky130_fd_sc_hd__fill_2
XFILLER_165_131 VGND VGND VPWR VPWR sky130_fd_sc_hd__decap_3
XFILLER_148_44 VGND VGND VPWR VPWR sky130_fd_sc_hd__decap_3
XFILLER_20_192 VGND VGND VPWR VPWR sky130_fd_sc_hd__decap_3
XFILLER_32_88 VGND VGND VPWR VPWR sky130_fd_sc_hd__decap_3
XFILLER_180_112 VGND VGND VPWR VPWR sky130_fd_sc_hd__decap_3
XFILLER_165_175 VGND VGND VPWR VPWR sky130_fd_sc_hd__decap_3
XFILLER_165_164 VGND VGND VPWR VPWR sky130_fd_sc_hd__decap_3
XFILLER_148_88 VGND VGND VPWR VPWR sky130_fd_sc_hd__decap_3
XFILLER_113_3 VGND VGND VPWR VPWR sky130_fd_sc_hd__fill_2
XFILLER_180_178 VGND VGND VPWR VPWR sky130_fd_sc_hd__decap_3
XFILLER_164_32 VGND VGND VPWR VPWR sky130_fd_sc_hd__decap_3
XFILLER_164_21 VGND VGND VPWR VPWR sky130_fd_sc_hd__decap_3
XPHY_EDGE_ROW_42_Left_225 VGND VGND VPWR VPWR sky130_fd_sc_hd__decap_3
XFILLER_79_159 VGND VGND VPWR VPWR sky130_fd_sc_hd__decap_3
XFILLER_57_52 VGND VGND VPWR VPWR sky130_fd_sc_hd__decap_3
XFILLER_94_118 VGND VGND VPWR VPWR sky130_fd_sc_hd__decap_3
XFILLER_180_64 VGND VGND VPWR VPWR sky130_fd_sc_hd__fill_1
XFILLER_57_96 VGND VGND VPWR VPWR sky130_fd_sc_hd__decap_3
XFILLER_180_97 VGND VGND VPWR VPWR sky130_fd_sc_hd__decap_3
XPHY_EDGE_ROW_121_Right_121 VGND VGND VPWR VPWR sky130_fd_sc_hd__decap_3
XFILLER_73_40 VGND VGND VPWR VPWR sky130_fd_sc_hd__fill_1
XPHY_EDGE_ROW_51_Left_234 VGND VGND VPWR VPWR sky130_fd_sc_hd__decap_3
XFILLER_148_109 VGND VGND VPWR VPWR sky130_fd_sc_hd__decap_3
XFILLER_156_153 VGND VGND VPWR VPWR sky130_fd_sc_hd__decap_3
XFILLER_78_6 VGND VGND VPWR VPWR sky130_fd_sc_hd__decap_3
XFILLER_7_152 VGND VGND VPWR VPWR sky130_fd_sc_hd__decap_3
XFILLER_171_134 VGND VGND VPWR VPWR sky130_fd_sc_hd__decap_3
XFILLER_156_197 VGND VGND VPWR VPWR sky130_fd_sc_hd__decap_3
XFILLER_7_196 VGND VGND VPWR VPWR sky130_fd_sc_hd__decap_3
X_0602_ net214 net207 net198 _0154_ Tile_X0Y1_OpenRAM_bot.Inst_OpenRAM_bot_ConfigMem.Inst_frame2_bit0.Q
+ Tile_X0Y1_OpenRAM_bot.Inst_OpenRAM_bot_ConfigMem.Inst_frame2_bit1.Q VGND VGND VPWR
+ VPWR net397 sky130_fd_sc_hd__mux4_2
XFILLER_171_178 VGND VGND VPWR VPWR sky130_fd_sc_hd__decap_3
XFILLER_171_167 VGND VGND VPWR VPWR sky130_fd_sc_hd__fill_1
XFILLER_98_70 VGND VGND VPWR VPWR sky130_fd_sc_hd__decap_3
X_0533_ net25 net57 net260 _0084_ Tile_X0Y1_OpenRAM_bot.Inst_OpenRAM_bot_ConfigMem.Inst_frame6_bit22.Q
+ Tile_X0Y1_OpenRAM_bot.Inst_OpenRAM_bot_ConfigMem.Inst_frame6_bit23.Q VGND VGND VPWR
+ VPWR Tile_X0Y1_OpenRAM_bot.Inst_OpenRAM_bot_switch_matrix.W2BEG3 sky130_fd_sc_hd__mux4_1
XPHY_EDGE_ROW_60_Left_243 VGND VGND VPWR VPWR sky130_fd_sc_hd__decap_3
X_0464_ net72 Tile_X0Y0_OpenRAM_top.Inst_OpenRAM_top_ConfigMem.Inst_frame1_bit4.Q
+ VGND VGND VPWR VPWR _0110_ sky130_fd_sc_hd__nand2_1
X_0395_ Tile_X0Y0_OpenRAM_top.Inst_OpenRAM_top_switch_matrix.N1END1 net362 net147
+ net167 Tile_X0Y0_OpenRAM_top.Inst_OpenRAM_top_ConfigMem.Inst_frame1_bit26.Q Tile_X0Y0_OpenRAM_top.Inst_OpenRAM_top_ConfigMem.Inst_frame1_bit27.Q
+ VGND VGND VPWR VPWR Tile_X0Y0_OpenRAM_top.Inst_OpenRAM_top_switch_matrix.J_NS4_BEG9
+ sky130_fd_sc_hd__mux4_2
XFILLER_78_192 VGND VGND VPWR VPWR sky130_fd_sc_hd__decap_3
XFILLER_93_140 VGND VGND VPWR VPWR sky130_fd_sc_hd__decap_3
XFILLER_93_162 VGND VGND VPWR VPWR sky130_fd_sc_hd__decap_3
XFILLER_179_212 VGND VGND VPWR VPWR sky130_fd_sc_hd__decap_3
X_1016_ net227 net323 VGND VGND VPWR VPWR Tile_X0Y1_OpenRAM_bot.Inst_OpenRAM_bot_ConfigMem.Inst_frame1_bit14.Q
+ sky130_fd_sc_hd__dlxtp_1
XFILLER_139_109 VGND VGND VPWR VPWR sky130_fd_sc_hd__decap_3
XFILLER_162_101 VGND VGND VPWR VPWR sky130_fd_sc_hd__decap_3
XFILLER_147_164 VGND VGND VPWR VPWR sky130_fd_sc_hd__decap_3
XFILLER_118_47 VGND VGND VPWR VPWR sky130_fd_sc_hd__decap_3
XTAP_TAPCELL_ROW_9_406 VGND VPWR sky130_fd_sc_hd__tapvpwrvgnd_1
XFILLER_78_18 VGND VGND VPWR VPWR sky130_fd_sc_hd__decap_3
XFILLER_78_29 VGND VGND VPWR VPWR sky130_fd_sc_hd__decap_3
XFILLER_103_223 VGND VGND VPWR VPWR sky130_fd_sc_hd__fill_1
XFILLER_134_35 VGND VGND VPWR VPWR sky130_fd_sc_hd__decap_3
XFILLER_76_118 VGND VGND VPWR VPWR sky130_fd_sc_hd__decap_3
XFILLER_182_6 VGND VGND VPWR VPWR sky130_fd_sc_hd__decap_3
XFILLER_69_181 VGND VGND VPWR VPWR sky130_fd_sc_hd__decap_3
XFILLER_84_162 VGND VGND VPWR VPWR sky130_fd_sc_hd__decap_3
XFILLER_150_56 VGND VGND VPWR VPWR sky130_fd_sc_hd__decap_3
XFILLER_150_23 VGND VGND VPWR VPWR sky130_fd_sc_hd__decap_3
XPHY_EDGE_ROW_108_Left_291 VGND VGND VPWR VPWR sky130_fd_sc_hd__decap_3
XFILLER_27_55 VGND VGND VPWR VPWR sky130_fd_sc_hd__fill_1
XFILLER_27_66 VGND VGND VPWR VPWR sky130_fd_sc_hd__decap_3
XFILLER_84_195 VGND VGND VPWR VPWR sky130_fd_sc_hd__fill_1
XTAP_TAPCELL_ROW_0_372 VGND VPWR sky130_fd_sc_hd__tapvpwrvgnd_1
XFILLER_27_99 VGND VGND VPWR VPWR sky130_fd_sc_hd__decap_3
XFILLER_43_43 VGND VGND VPWR VPWR sky130_fd_sc_hd__fill_1
XTAP_TAPCELL_ROW_23_463 VGND VPWR sky130_fd_sc_hd__tapvpwrvgnd_1
XFILLER_43_87 VGND VGND VPWR VPWR sky130_fd_sc_hd__decap_3
XFILLER_138_153 VGND VGND VPWR VPWR sky130_fd_sc_hd__decap_3
XFILLER_138_131 VGND VGND VPWR VPWR sky130_fd_sc_hd__decap_3
XFILLER_138_186 VGND VGND VPWR VPWR sky130_fd_sc_hd__decap_3
XFILLER_175_42 VGND VGND VPWR VPWR sky130_fd_sc_hd__decap_3
XFILLER_153_145 VGND VGND VPWR VPWR sky130_fd_sc_hd__decap_3
XFILLER_138_197 VGND VGND VPWR VPWR sky130_fd_sc_hd__decap_3
XFILLER_4_100 VGND VGND VPWR VPWR sky130_fd_sc_hd__decap_3
XFILLER_4_133 VGND VGND VPWR VPWR sky130_fd_sc_hd__decap_3
XFILLER_175_75 VGND VGND VPWR VPWR sky130_fd_sc_hd__decap_3
XFILLER_153_178 VGND VGND VPWR VPWR sky130_fd_sc_hd__fill_2
XFILLER_4_15 VGND VGND VPWR VPWR sky130_fd_sc_hd__decap_3
XFILLER_4_144 VGND VGND VPWR VPWR sky130_fd_sc_hd__decap_3
XFILLER_4_59 VGND VGND VPWR VPWR sky130_fd_sc_hd__decap_3
XFILLER_4_177 VGND VGND VPWR VPWR sky130_fd_sc_hd__decap_3
XFILLER_108_91 VGND VGND VPWR VPWR sky130_fd_sc_hd__decap_3
Xinput262 Tile_X0Y1_N2END[4] VGND VGND VPWR VPWR net345 sky130_fd_sc_hd__clkbuf_2
Xinput251 Tile_X0Y1_FrameData[7] VGND VGND VPWR VPWR net251 sky130_fd_sc_hd__clkbuf_4
Xinput240 Tile_X0Y1_FrameData[26] VGND VGND VPWR VPWR net240 sky130_fd_sc_hd__buf_4
Xinput273 Tile_X0Y1_N2MID[7] VGND VGND VPWR VPWR net356 sky130_fd_sc_hd__clkbuf_2
XFILLER_75_140 VGND VGND VPWR VPWR sky130_fd_sc_hd__decap_3
XFILLER_75_184 VGND VGND VPWR VPWR sky130_fd_sc_hd__decap_3
XFILLER_90_121 VGND VGND VPWR VPWR sky130_fd_sc_hd__decap_3
XTAP_TAPCELL_ROW_46_555 VGND VPWR sky130_fd_sc_hd__tapvpwrvgnd_1
XFILLER_84_94 VGND VGND VPWR VPWR sky130_fd_sc_hd__decap_3
XFILLER_90_154 VGND VGND VPWR VPWR sky130_fd_sc_hd__decap_3
XFILLER_90_187 VGND VGND VPWR VPWR sky130_fd_sc_hd__decap_3
XFILLER_176_215 VGND VGND VPWR VPWR sky130_fd_sc_hd__decap_3
XFILLER_129_131 VGND VGND VPWR VPWR sky130_fd_sc_hd__decap_3
XFILLER_76_3 VGND VGND VPWR VPWR sky130_fd_sc_hd__decap_3
XFILLER_129_164 VGND VGND VPWR VPWR sky130_fd_sc_hd__decap_3
XFILLER_144_123 VGND VGND VPWR VPWR sky130_fd_sc_hd__decap_3
XFILLER_144_156 VGND VGND VPWR VPWR sky130_fd_sc_hd__decap_3
XFILLER_144_189 VGND VGND VPWR VPWR sky130_fd_sc_hd__decap_3
XFILLER_98_221 VGND VGND VPWR VPWR sky130_fd_sc_hd__decap_3
X_0516_ net176 net195 Tile_X0Y1_OpenRAM_bot.Inst_OpenRAM_bot_switch_matrix.J_NS4_BEG14
+ _0073_ Tile_X0Y1_OpenRAM_bot.Inst_OpenRAM_bot_ConfigMem.Inst_frame7_bit8.Q Tile_X0Y1_OpenRAM_bot.Inst_OpenRAM_bot_ConfigMem.Inst_frame7_bit9.Q
+ VGND VGND VPWR VPWR Tile_X0Y1_OpenRAM_bot.Inst_OpenRAM_bot_switch_matrix.S1BEG2
+ sky130_fd_sc_hd__mux4_1
X_1496_ Tile_X0Y1_OpenRAM_bot.Inst_OpenRAM_bot_switch_matrix.WW4BEG2 VGND VGND VPWR
+ VPWR net662 sky130_fd_sc_hd__clkbuf_2
X_0447_ _0098_ Tile_X0Y0_OpenRAM_top.Inst_OpenRAM_top_ConfigMem.Inst_frame2_bit25.Q
+ _0005_ _0097_ VGND VGND VPWR VPWR net369 sky130_fd_sc_hd__a2bb2o_1
XFILLER_104_27 VGND VGND VPWR VPWR sky130_fd_sc_hd__fill_1
XTAP_TAPCELL_ROW_69_647 VGND VPWR sky130_fd_sc_hd__tapvpwrvgnd_1
XFILLER_104_38 VGND VGND VPWR VPWR sky130_fd_sc_hd__decap_3
X_0378_ net19 net51 net259 Tile_X0Y0_OpenRAM_top.Inst_OpenRAM_top_switch_matrix.J_NS2_BEG7
+ Tile_X0Y0_OpenRAM_top.Inst_OpenRAM_top_ConfigMem.Inst_frame5_bit12.Q Tile_X0Y0_OpenRAM_top.Inst_OpenRAM_top_ConfigMem.Inst_frame5_bit13.Q
+ VGND VGND VPWR VPWR Tile_X0Y0_OpenRAM_top.Inst_OpenRAM_top_switch_matrix.W2BEGb0
+ sky130_fd_sc_hd__mux4_1
XTAP_TAPCELL_ROW_77_680 VGND VPWR sky130_fd_sc_hd__tapvpwrvgnd_1
XFILLER_81_143 VGND VGND VPWR VPWR sky130_fd_sc_hd__decap_3
XFILLER_81_165 VGND VGND VPWR VPWR sky130_fd_sc_hd__decap_3
XFILLER_120_26 VGND VGND VPWR VPWR sky130_fd_sc_hd__fill_2
XFILLER_22_232 VGND VGND VPWR VPWR sky130_fd_sc_hd__fill_2
XFILLER_13_24 VGND VGND VPWR VPWR sky130_fd_sc_hd__decap_3
XFILLER_129_24 VGND VGND VPWR VPWR sky130_fd_sc_hd__decap_3
XFILLER_135_101 VGND VGND VPWR VPWR sky130_fd_sc_hd__decap_3
XFILLER_135_134 VGND VGND VPWR VPWR sky130_fd_sc_hd__decap_3
XFILLER_135_156 VGND VGND VPWR VPWR sky130_fd_sc_hd__decap_3
XFILLER_150_137 VGND VGND VPWR VPWR sky130_fd_sc_hd__decap_3
XFILLER_145_45 VGND VGND VPWR VPWR sky130_fd_sc_hd__decap_3
XFILLER_8_6 VGND VGND VPWR VPWR sky130_fd_sc_hd__decap_3
XFILLER_1_125 VGND VGND VPWR VPWR sky130_fd_sc_hd__decap_3
XFILLER_89_221 VGND VGND VPWR VPWR sky130_fd_sc_hd__decap_3
XFILLER_150_159 VGND VGND VPWR VPWR sky130_fd_sc_hd__decap_3
XFILLER_161_22 VGND VGND VPWR VPWR sky130_fd_sc_hd__fill_2
XFILLER_180_3 VGND VGND VPWR VPWR sky130_fd_sc_hd__decap_3
XFILLER_161_55 VGND VGND VPWR VPWR sky130_fd_sc_hd__fill_1
XFILLER_161_66 VGND VGND VPWR VPWR sky130_fd_sc_hd__decap_3
XFILLER_57_184 VGND VGND VPWR VPWR sky130_fd_sc_hd__decap_3
XFILLER_54_20 VGND VGND VPWR VPWR sky130_fd_sc_hd__decap_3
XFILLER_72_132 VGND VGND VPWR VPWR sky130_fd_sc_hd__decap_3
XFILLER_54_53 VGND VGND VPWR VPWR sky130_fd_sc_hd__decap_3
XFILLER_72_165 VGND VGND VPWR VPWR sky130_fd_sc_hd__decap_3
XFILLER_54_97 VGND VGND VPWR VPWR sky130_fd_sc_hd__decap_3
XFILLER_9_225 VGND VGND VPWR VPWR sky130_fd_sc_hd__decap_3
XFILLER_9_214 VGND VGND VPWR VPWR sky130_fd_sc_hd__decap_3
XFILLER_70_85 VGND VGND VPWR VPWR sky130_fd_sc_hd__decap_3
XFILLER_62_9 VGND VGND VPWR VPWR sky130_fd_sc_hd__fill_2
XFILLER_126_189 VGND VGND VPWR VPWR sky130_fd_sc_hd__decap_3
XFILLER_79_72 VGND VGND VPWR VPWR sky130_fd_sc_hd__decap_3
X_1350_ Tile_X0Y0_OpenRAM_top.Inst_OpenRAM_top_switch_matrix.W2BEG0 VGND VGND VPWR
+ VPWR net510 sky130_fd_sc_hd__buf_1
X_0301_ net67 net93 Tile_X0Y0_OpenRAM_top.Inst_OpenRAM_top_switch_matrix.J_NS4_BEG13
+ _0062_ Tile_X0Y0_OpenRAM_top.Inst_OpenRAM_top_ConfigMem.Inst_frame8_bit14.Q Tile_X0Y0_OpenRAM_top.Inst_OpenRAM_top_ConfigMem.Inst_frame8_bit15.Q
+ VGND VGND VPWR VPWR Tile_X0Y0_OpenRAM_top.Inst_OpenRAM_top_switch_matrix.N1BEG1
+ sky130_fd_sc_hd__mux4_1
X_1281_ net130 VGND VGND VPWR VPWR net433 sky130_fd_sc_hd__buf_1
X_0232_ Tile_X0Y0_OpenRAM_top.Inst_OpenRAM_top_ConfigMem.Inst_frame2_bit24.Q VGND
+ VGND VPWR VPWR _0005_ sky130_fd_sc_hd__inv_2
XTAP_TAPCELL_ROW_118_843 VGND VPWR sky130_fd_sc_hd__tapvpwrvgnd_1
XFILLER_48_162 VGND VGND VPWR VPWR sky130_fd_sc_hd__decap_3
XFILLER_95_60 VGND VGND VPWR VPWR sky130_fd_sc_hd__decap_3
XFILLER_48_195 VGND VGND VPWR VPWR sky130_fd_sc_hd__fill_1
XFILLER_63_110 VGND VGND VPWR VPWR sky130_fd_sc_hd__fill_2
XFILLER_63_121 VGND VGND VPWR VPWR sky130_fd_sc_hd__decap_3
XFILLER_63_154 VGND VGND VPWR VPWR sky130_fd_sc_hd__decap_3
XFILLER_63_187 VGND VGND VPWR VPWR sky130_fd_sc_hd__decap_3
XTAP_TAPCELL_ROW_101_776 VGND VPWR sky130_fd_sc_hd__tapvpwrvgnd_1
XFILLER_164_218 VGND VGND VPWR VPWR sky130_fd_sc_hd__decap_3
XFILLER_117_101 VGND VGND VPWR VPWR sky130_fd_sc_hd__decap_3
X_0996_ net244 net330 VGND VGND VPWR VPWR Tile_X0Y1_OpenRAM_bot.Inst_OpenRAM_bot_ConfigMem.Inst_frame0_bit2.Q
+ sky130_fd_sc_hd__dlxtp_1
XFILLER_117_134 VGND VGND VPWR VPWR sky130_fd_sc_hd__decap_3
Xoutput500 net583 VGND VGND VPWR VPWR Tile_X0Y1_FrameData_O[7] sky130_fd_sc_hd__buf_2
XFILLER_117_167 VGND VGND VPWR VPWR sky130_fd_sc_hd__fill_1
Xoutput511 net594 VGND VGND VPWR VPWR Tile_X0Y1_S2BEG[4] sky130_fd_sc_hd__buf_2
XFILLER_132_137 VGND VGND VPWR VPWR sky130_fd_sc_hd__decap_3
XFILLER_117_178 VGND VGND VPWR VPWR sky130_fd_sc_hd__decap_3
Xoutput544 net627 VGND VGND VPWR VPWR Tile_X0Y1_W2BEG[1] sky130_fd_sc_hd__buf_2
Xoutput533 net616 VGND VGND VPWR VPWR Tile_X0Y1_S4BEG[4] sky130_fd_sc_hd__buf_2
Xoutput522 net605 VGND VGND VPWR VPWR Tile_X0Y1_S2BEGb[7] sky130_fd_sc_hd__buf_2
XFILLER_132_159 VGND VGND VPWR VPWR sky130_fd_sc_hd__decap_3
Xoutput555 net638 VGND VGND VPWR VPWR Tile_X0Y1_W2BEGb[4] sky130_fd_sc_hd__buf_2
Xoutput577 net660 VGND VGND VPWR VPWR Tile_X0Y1_WW4BEG[15] sky130_fd_sc_hd__buf_2
Xoutput566 net649 VGND VGND VPWR VPWR Tile_X0Y1_W6BEG[5] sky130_fd_sc_hd__buf_2
Xoutput588 net671 VGND VGND VPWR VPWR WMASK_A_SRAM0 sky130_fd_sc_hd__buf_2
Xfanout259 Tile_X0Y0_OpenRAM_top.Inst_OpenRAM_top_switch_matrix.J_NS2_BEG0 VGND VGND
+ VPWR VPWR net259 sky130_fd_sc_hd__clkbuf_4
XFILLER_140_181 VGND VGND VPWR VPWR sky130_fd_sc_hd__decap_3
XFILLER_115_48 VGND VGND VPWR VPWR sky130_fd_sc_hd__decap_3
X_1479_ Tile_X0Y1_OpenRAM_bot.Inst_OpenRAM_bot_switch_matrix.W2BEGb5 VGND VGND VPWR
+ VPWR net639 sky130_fd_sc_hd__buf_1
XFILLER_86_224 VGND VGND VPWR VPWR sky130_fd_sc_hd__decap_3
XFILLER_39_151 VGND VGND VPWR VPWR sky130_fd_sc_hd__decap_3
XFILLER_54_121 VGND VGND VPWR VPWR sky130_fd_sc_hd__decap_3
XFILLER_131_69 VGND VGND VPWR VPWR sky130_fd_sc_hd__decap_3
XTAP_TAPCELL_ROW_124_868 VGND VPWR sky130_fd_sc_hd__tapvpwrvgnd_1
XFILLER_54_165 VGND VGND VPWR VPWR sky130_fd_sc_hd__decap_3
XFILLER_10_224 VGND VGND VPWR VPWR sky130_fd_sc_hd__decap_3
XFILLER_155_218 VGND VGND VPWR VPWR sky130_fd_sc_hd__decap_3
XFILLER_6_206 VGND VGND VPWR VPWR sky130_fd_sc_hd__decap_3
XFILLER_108_112 VGND VGND VPWR VPWR sky130_fd_sc_hd__decap_3
XFILLER_40_22 VGND VGND VPWR VPWR sky130_fd_sc_hd__decap_3
XFILLER_156_44 VGND VGND VPWR VPWR sky130_fd_sc_hd__decap_3
XFILLER_40_66 VGND VGND VPWR VPWR sky130_fd_sc_hd__decap_3
XFILLER_156_88 VGND VGND VPWR VPWR sky130_fd_sc_hd__decap_3
XFILLER_108_189 VGND VGND VPWR VPWR sky130_fd_sc_hd__decap_3
XFILLER_123_137 VGND VGND VPWR VPWR sky130_fd_sc_hd__decap_3
XFILLER_6_3 VGND VGND VPWR VPWR sky130_fd_sc_hd__decap_3
XFILLER_172_32 VGND VGND VPWR VPWR sky130_fd_sc_hd__decap_3
XFILLER_172_21 VGND VGND VPWR VPWR sky130_fd_sc_hd__decap_3
XFILLER_49_31 VGND VGND VPWR VPWR sky130_fd_sc_hd__fill_1
XFILLER_49_42 VGND VGND VPWR VPWR sky130_fd_sc_hd__decap_3
XFILLER_77_202 VGND VGND VPWR VPWR sky130_fd_sc_hd__fill_1
XFILLER_172_65 VGND VGND VPWR VPWR sky130_fd_sc_hd__decap_3
XFILLER_131_181 VGND VGND VPWR VPWR sky130_fd_sc_hd__fill_2
XFILLER_49_75 VGND VGND VPWR VPWR sky130_fd_sc_hd__decap_3
XFILLER_92_227 VGND VGND VPWR VPWR sky130_fd_sc_hd__decap_3
XTAP_TAPCELL_ROW_155_993 VGND VPWR sky130_fd_sc_hd__tapvpwrvgnd_1
XFILLER_65_63 VGND VGND VPWR VPWR sky130_fd_sc_hd__decap_3
XFILLER_45_165 VGND VGND VPWR VPWR sky130_fd_sc_hd__decap_3
XFILLER_65_96 VGND VGND VPWR VPWR sky130_fd_sc_hd__decap_3
XFILLER_60_124 VGND VGND VPWR VPWR sky130_fd_sc_hd__fill_1
X_0850_ net114 net300 VGND VGND VPWR VPWR Tile_X0Y0_OpenRAM_top.Inst_OpenRAM_top_ConfigMem.Inst_frame4_bit0.Q
+ sky130_fd_sc_hd__dlxtp_1
X_0781_ net141 net318 VGND VGND VPWR VPWR Tile_X0Y0_OpenRAM_top.Inst_OpenRAM_top_ConfigMem.Inst_frame2_bit5.Q
+ sky130_fd_sc_hd__dlxtp_1
X_1402_ net252 VGND VGND VPWR VPWR net584 sky130_fd_sc_hd__buf_6
XFILLER_39_3 VGND VGND VPWR VPWR sky130_fd_sc_hd__fill_1
X_1333_ Tile_X0Y1_N4END[12] VGND VGND VPWR VPWR net499 sky130_fd_sc_hd__clkbuf_1
XFILLER_122_181 VGND VGND VPWR VPWR sky130_fd_sc_hd__decap_3
XFILLER_68_224 VGND VGND VPWR VPWR sky130_fd_sc_hd__fill_2
X_1264_ net143 VGND VGND VPWR VPWR net446 sky130_fd_sc_hd__clkbuf_2
Xinput4 DOUT_A_SRAM10 VGND VGND VPWR VPWR net4 sky130_fd_sc_hd__buf_1
XFILLER_36_121 VGND VGND VPWR VPWR sky130_fd_sc_hd__decap_3
X_1195_ net241 net270 VGND VGND VPWR VPWR Tile_X0Y1_OpenRAM_bot.Inst_OpenRAM_bot_ConfigMem.Inst_frame7_bit27.Q
+ sky130_fd_sc_hd__dlxtp_1
XFILLER_36_165 VGND VGND VPWR VPWR sky130_fd_sc_hd__decap_3
XFILLER_51_102 VGND VGND VPWR VPWR sky130_fd_sc_hd__decap_3
XFILLER_101_28 VGND VGND VPWR VPWR sky130_fd_sc_hd__decap_3
XFILLER_51_113 VGND VGND VPWR VPWR sky130_fd_sc_hd__decap_3
XTAP_TAPCELL_ROW_62_620 VGND VPWR sky130_fd_sc_hd__tapvpwrvgnd_1
XFILLER_137_229 VGND VGND VPWR VPWR sky130_fd_sc_hd__fill_1
X_0979_ net232 net332 VGND VGND VPWR VPWR Tile_X0Y1_OpenRAM_bot.Inst_OpenRAM_bot_ConfigMem.Inst_frame0_bit19.Q
+ sky130_fd_sc_hd__dlxtp_1
XFILLER_160_221 VGND VGND VPWR VPWR sky130_fd_sc_hd__decap_3
Xoutput352 net435 VGND VGND VPWR VPWR Tile_X0Y0_FrameData_O[26] sky130_fd_sc_hd__buf_2
Xoutput341 net424 VGND VGND VPWR VPWR Tile_X0Y0_FrameData_O[16] sky130_fd_sc_hd__buf_2
XFILLER_10_47 VGND VGND VPWR VPWR sky130_fd_sc_hd__decap_3
Xoutput330 net413 VGND VGND VPWR VPWR DIN_A_SRAM6 sky130_fd_sc_hd__buf_2
Xoutput396 net479 VGND VGND VPWR VPWR Tile_X0Y0_N2BEG[6] sky130_fd_sc_hd__buf_2
Xoutput374 net457 VGND VGND VPWR VPWR Tile_X0Y0_FrameStrobe_O[17] sky130_fd_sc_hd__buf_2
Xoutput385 net468 VGND VGND VPWR VPWR Tile_X0Y0_FrameStrobe_O[9] sky130_fd_sc_hd__buf_2
Xoutput363 net446 VGND VGND VPWR VPWR Tile_X0Y0_FrameData_O[7] sky130_fd_sc_hd__buf_2
XFILLER_126_47 VGND VGND VPWR VPWR sky130_fd_sc_hd__fill_2
XFILLER_86_18 VGND VGND VPWR VPWR sky130_fd_sc_hd__decap_3
XFILLER_113_181 VGND VGND VPWR VPWR sky130_fd_sc_hd__decap_3
XFILLER_19_23 VGND VGND VPWR VPWR sky130_fd_sc_hd__decap_3
XFILLER_74_227 VGND VGND VPWR VPWR sky130_fd_sc_hd__decap_3
XTAP_TAPCELL_ROW_85_712 VGND VPWR sky130_fd_sc_hd__tapvpwrvgnd_1
XFILLER_142_79 VGND VGND VPWR VPWR sky130_fd_sc_hd__decap_3
XFILLER_27_143 VGND VGND VPWR VPWR sky130_fd_sc_hd__fill_2
XFILLER_35_33 VGND VGND VPWR VPWR sky130_fd_sc_hd__decap_3
XFILLER_42_179 VGND VGND VPWR VPWR sky130_fd_sc_hd__decap_3
XFILLER_167_21 VGND VGND VPWR VPWR sky130_fd_sc_hd__decap_3
XFILLER_128_218 VGND VGND VPWR VPWR sky130_fd_sc_hd__decap_3
XFILLER_167_54 VGND VGND VPWR VPWR sky130_fd_sc_hd__fill_2
XFILLER_151_221 VGND VGND VPWR VPWR sky130_fd_sc_hd__decap_3
XFILLER_2_220 VGND VGND VPWR VPWR sky130_fd_sc_hd__decap_3
XPHY_EDGE_ROW_168_Right_168 VGND VGND VPWR VPWR sky130_fd_sc_hd__decap_3
XFILLER_116_91 VGND VGND VPWR VPWR sky130_fd_sc_hd__decap_3
XFILLER_116_80 VGND VGND VPWR VPWR sky130_fd_sc_hd__decap_3
XFILLER_76_62 VGND VGND VPWR VPWR sky130_fd_sc_hd__decap_3
XTAP_TAPCELL_ROW_160_1013 VGND VPWR sky130_fd_sc_hd__tapvpwrvgnd_1
XTAP_TAPCELL_ROW_91_737 VGND VPWR sky130_fd_sc_hd__tapvpwrvgnd_1
XFILLER_33_113 VGND VGND VPWR VPWR sky130_fd_sc_hd__decap_3
XFILLER_92_50 VGND VGND VPWR VPWR sky130_fd_sc_hd__fill_1
XFILLER_92_61 VGND VGND VPWR VPWR sky130_fd_sc_hd__decap_3
XFILLER_178_118 VGND VGND VPWR VPWR sky130_fd_sc_hd__decap_3
X_0902_ net117 net285 VGND VGND VPWR VPWR Tile_X0Y0_OpenRAM_top.Inst_OpenRAM_top_ConfigMem.Inst_frame6_bit12.Q
+ sky130_fd_sc_hd__dlxtp_1
XFILLER_119_207 VGND VGND VPWR VPWR sky130_fd_sc_hd__decap_3
XFILLER_41_190 VGND VGND VPWR VPWR sky130_fd_sc_hd__decap_3
X_0833_ net122 net301 VGND VGND VPWR VPWR Tile_X0Y0_OpenRAM_top.Inst_OpenRAM_top_ConfigMem.Inst_frame4_bit17.Q
+ sky130_fd_sc_hd__dlxtp_1
X_0764_ net128 net319 VGND VGND VPWR VPWR Tile_X0Y0_OpenRAM_top.Inst_OpenRAM_top_ConfigMem.Inst_frame2_bit22.Q
+ sky130_fd_sc_hd__dlxtp_1
X_0695_ net133 net336 VGND VGND VPWR VPWR Tile_X0Y0_OpenRAM_top.Inst_OpenRAM_top_ConfigMem.Inst_frame0_bit27.Q
+ sky130_fd_sc_hd__dlxtp_1
XPHY_EDGE_ROW_135_Right_135 VGND VGND VPWR VPWR sky130_fd_sc_hd__decap_3
X_1316_ Tile_X0Y0_OpenRAM_top.Inst_OpenRAM_top_switch_matrix.N2BEG3 VGND VGND VPWR
+ VPWR net476 sky130_fd_sc_hd__clkbuf_1
XFILLER_2_70 VGND VGND VPWR VPWR sky130_fd_sc_hd__decap_3
X_1247_ net251 net265 VGND VGND VPWR VPWR Tile_X0Y1_OpenRAM_bot.Inst_OpenRAM_bot_ConfigMem.Inst_frame8_bit7.Q
+ sky130_fd_sc_hd__dlxtp_1
XFILLER_112_38 VGND VGND VPWR VPWR sky130_fd_sc_hd__decap_3
XFILLER_112_27 VGND VGND VPWR VPWR sky130_fd_sc_hd__fill_1
X_1178_ net225 net280 VGND VGND VPWR VPWR Tile_X0Y1_OpenRAM_bot.Inst_OpenRAM_bot_ConfigMem.Inst_frame6_bit12.Q
+ sky130_fd_sc_hd__dlxtp_1
XFILLER_24_135 VGND VGND VPWR VPWR sky130_fd_sc_hd__decap_3
XFILLER_24_179 VGND VGND VPWR VPWR sky130_fd_sc_hd__decap_3
XFILLER_177_140 VGND VGND VPWR VPWR sky130_fd_sc_hd__decap_3
XFILLER_177_184 VGND VGND VPWR VPWR sky130_fd_sc_hd__decap_3
XTAP_TAPCELL_ROW_176_1075 VGND VPWR sky130_fd_sc_hd__tapvpwrvgnd_1
XFILLER_21_57 VGND VGND VPWR VPWR sky130_fd_sc_hd__decap_3
XFILLER_133_221 VGND VGND VPWR VPWR sky130_fd_sc_hd__decap_3
XFILLER_153_23 VGND VGND VPWR VPWR sky130_fd_sc_hd__decap_3
XFILLER_99_190 VGND VGND VPWR VPWR sky130_fd_sc_hd__decap_3
XPHY_EDGE_ROW_102_Right_102 VGND VGND VPWR VPWR sky130_fd_sc_hd__decap_3
XFILLER_47_216 VGND VGND VPWR VPWR sky130_fd_sc_hd__decap_3
XFILLER_101_184 VGND VGND VPWR VPWR sky130_fd_sc_hd__decap_3
XTAP_TAPCELL_ROW_140_933 VGND VPWR sky130_fd_sc_hd__tapvpwrvgnd_1
XFILLER_15_146 VGND VGND VPWR VPWR sky130_fd_sc_hd__decap_3
XFILLER_62_53 VGND VGND VPWR VPWR sky130_fd_sc_hd__decap_3
XFILLER_178_53 VGND VGND VPWR VPWR sky130_fd_sc_hd__decap_3
XFILLER_30_138 VGND VGND VPWR VPWR sky130_fd_sc_hd__fill_2
XFILLER_62_97 VGND VGND VPWR VPWR sky130_fd_sc_hd__decap_3
XFILLER_178_97 VGND VGND VPWR VPWR sky130_fd_sc_hd__decap_3
XFILLER_168_173 VGND VGND VPWR VPWR sky130_fd_sc_hd__decap_3
XFILLER_7_15 VGND VGND VPWR VPWR sky130_fd_sc_hd__decap_3
XFILLER_7_48 VGND VGND VPWR VPWR sky130_fd_sc_hd__decap_3
X_0480_ _0014_ _0118_ _0122_ VGND VGND VPWR VPWR Tile_X0Y0_OpenRAM_top.Inst_OpenRAM_top_switch_matrix.N4BEG1
+ sky130_fd_sc_hd__o21a_1
XFILLER_11_90 VGND VGND VPWR VPWR sky130_fd_sc_hd__decap_3
XFILLER_30_7 VGND VGND VPWR VPWR sky130_fd_sc_hd__fill_1
XFILLER_87_72 VGND VGND VPWR VPWR sky130_fd_sc_hd__fill_2
XFILLER_38_216 VGND VGND VPWR VPWR sky130_fd_sc_hd__decap_3
X_1101_ net239 net296 VGND VGND VPWR VPWR Tile_X0Y1_OpenRAM_bot.Inst_OpenRAM_bot_ConfigMem.Inst_frame4_bit25.Q
+ sky130_fd_sc_hd__dlxtp_1
XFILLER_53_219 VGND VGND VPWR VPWR sky130_fd_sc_hd__fill_1
X_1032_ net245 net316 VGND VGND VPWR VPWR Tile_X0Y1_OpenRAM_bot.Inst_OpenRAM_bot_ConfigMem.Inst_frame2_bit30.Q
+ sky130_fd_sc_hd__dlxtp_1
XFILLER_21_105 VGND VGND VPWR VPWR sky130_fd_sc_hd__decap_3
XFILLER_21_116 VGND VGND VPWR VPWR sky130_fd_sc_hd__decap_3
XFILLER_159_140 VGND VGND VPWR VPWR sky130_fd_sc_hd__decap_3
XFILLER_21_149 VGND VGND VPWR VPWR sky130_fd_sc_hd__decap_3
XFILLER_174_121 VGND VGND VPWR VPWR sky130_fd_sc_hd__decap_3
XFILLER_159_195 VGND VGND VPWR VPWR sky130_fd_sc_hd__decap_3
Xinput40 DOUT_B_SRAM14 VGND VGND VPWR VPWR net40 sky130_fd_sc_hd__clkbuf_1
XFILLER_174_165 VGND VGND VPWR VPWR sky130_fd_sc_hd__decap_3
X_0816_ net136 net310 VGND VGND VPWR VPWR Tile_X0Y0_OpenRAM_top.Inst_OpenRAM_top_ConfigMem.Inst_frame3_bit2.Q
+ sky130_fd_sc_hd__dlxtp_1
Xinput73 Tile_X0Y0_E2END[3] VGND VGND VPWR VPWR net73 sky130_fd_sc_hd__dlymetal6s2s_1
Xinput62 DOUT_B_SRAM6 VGND VGND VPWR VPWR net62 sky130_fd_sc_hd__buf_1
Xinput51 DOUT_B_SRAM24 VGND VGND VPWR VPWR net51 sky130_fd_sc_hd__dlymetal6s2s_1
X_0747_ net143 net328 VGND VGND VPWR VPWR Tile_X0Y0_OpenRAM_top.Inst_OpenRAM_top_ConfigMem.Inst_frame1_bit7.Q
+ sky130_fd_sc_hd__dlxtp_1
Xinput95 Tile_X0Y0_E6END[7] VGND VGND VPWR VPWR net95 sky130_fd_sc_hd__clkbuf_2
Xinput84 Tile_X0Y0_E2MID[6] VGND VGND VPWR VPWR net84 sky130_fd_sc_hd__buf_1
X_0678_ net182 net161 Tile_X0Y1_OpenRAM_bot.Inst_OpenRAM_bot_ConfigMem.Inst_frame3_bit14.Q
+ VGND VGND VPWR VPWR _0215_ sky130_fd_sc_hd__mux2_1
XFILLER_123_15 VGND VGND VPWR VPWR sky130_fd_sc_hd__decap_3
XFILLER_96_193 VGND VGND VPWR VPWR sky130_fd_sc_hd__decap_3
XFILLER_177_9 VGND VGND VPWR VPWR sky130_fd_sc_hd__decap_3
XFILLER_16_68 VGND VGND VPWR VPWR sky130_fd_sc_hd__decap_3
XFILLER_8_109 VGND VGND VPWR VPWR sky130_fd_sc_hd__decap_3
XFILLER_165_110 VGND VGND VPWR VPWR sky130_fd_sc_hd__fill_2
XFILLER_32_23 VGND VGND VPWR VPWR sky130_fd_sc_hd__decap_3
XFILLER_165_143 VGND VGND VPWR VPWR sky130_fd_sc_hd__decap_3
XFILLER_20_171 VGND VGND VPWR VPWR sky130_fd_sc_hd__decap_3
XFILLER_165_187 VGND VGND VPWR VPWR sky130_fd_sc_hd__decap_3
XFILLER_180_124 VGND VGND VPWR VPWR sky130_fd_sc_hd__decap_3
XFILLER_180_157 VGND VGND VPWR VPWR sky130_fd_sc_hd__decap_3
XFILLER_164_55 VGND VGND VPWR VPWR sky130_fd_sc_hd__decap_3
XFILLER_79_116 VGND VGND VPWR VPWR sky130_fd_sc_hd__fill_1
XFILLER_164_88 VGND VGND VPWR VPWR sky130_fd_sc_hd__decap_3
XFILLER_180_21 VGND VGND VPWR VPWR sky130_fd_sc_hd__decap_3
XFILLER_57_31 VGND VGND VPWR VPWR sky130_fd_sc_hd__decap_3
XFILLER_87_160 VGND VGND VPWR VPWR sky130_fd_sc_hd__decap_3
XFILLER_180_43 VGND VGND VPWR VPWR sky130_fd_sc_hd__decap_3
XFILLER_180_32 VGND VGND VPWR VPWR sky130_fd_sc_hd__decap_3
XFILLER_87_193 VGND VGND VPWR VPWR sky130_fd_sc_hd__fill_1
XFILLER_92_9 VGND VGND VPWR VPWR sky130_fd_sc_hd__decap_3
XFILLER_7_131 VGND VGND VPWR VPWR sky130_fd_sc_hd__decap_3
XFILLER_171_113 VGND VGND VPWR VPWR sky130_fd_sc_hd__decap_3
XFILLER_171_102 VGND VGND VPWR VPWR sky130_fd_sc_hd__decap_3
XFILLER_156_187 VGND VGND VPWR VPWR sky130_fd_sc_hd__decap_3
XFILLER_7_175 VGND VGND VPWR VPWR sky130_fd_sc_hd__decap_3
XFILLER_7_164 VGND VGND VPWR VPWR sky130_fd_sc_hd__decap_3
XFILLER_171_146 VGND VGND VPWR VPWR sky130_fd_sc_hd__decap_3
X_0601_ net213 net221 net197 _0155_ Tile_X0Y1_OpenRAM_bot.Inst_OpenRAM_bot_ConfigMem.Inst_frame3_bit30.Q
+ Tile_X0Y1_OpenRAM_bot.Inst_OpenRAM_bot_ConfigMem.Inst_frame3_bit31.Q VGND VGND VPWR
+ VPWR net386 sky130_fd_sc_hd__mux4_1
X_0532_ net14 net46 net261 _0085_ Tile_X0Y1_OpenRAM_bot.Inst_OpenRAM_bot_ConfigMem.Inst_frame6_bit20.Q
+ Tile_X0Y1_OpenRAM_bot.Inst_OpenRAM_bot_ConfigMem.Inst_frame6_bit21.Q VGND VGND VPWR
+ VPWR Tile_X0Y1_OpenRAM_bot.Inst_OpenRAM_bot_switch_matrix.W2BEG2 sky130_fd_sc_hd__mux4_1
XFILLER_98_82 VGND VGND VPWR VPWR sky130_fd_sc_hd__fill_2
X_0463_ net80 net257 Tile_X0Y0_OpenRAM_top.Inst_OpenRAM_top_ConfigMem.Inst_frame1_bit5.Q
+ VGND VGND VPWR VPWR _0109_ sky130_fd_sc_hd__mux2_1
X_0394_ net16 net48 Tile_X0Y0_OpenRAM_top.Inst_OpenRAM_top_switch_matrix.J_NS4_BEG10
+ net257 Tile_X0Y0_OpenRAM_top.Inst_OpenRAM_top_ConfigMem.Inst_frame4_bit6.Q Tile_X0Y0_OpenRAM_top.Inst_OpenRAM_top_ConfigMem.Inst_frame4_bit7.Q
+ VGND VGND VPWR VPWR Tile_X0Y0_OpenRAM_top.Inst_OpenRAM_top_switch_matrix.WW4BEG5
+ sky130_fd_sc_hd__mux4_1
XFILLER_21_3 VGND VGND VPWR VPWR sky130_fd_sc_hd__fill_2
XFILLER_78_171 VGND VGND VPWR VPWR sky130_fd_sc_hd__decap_3
XFILLER_26_219 VGND VGND VPWR VPWR sky130_fd_sc_hd__decap_3
X_1015_ net228 net323 VGND VGND VPWR VPWR Tile_X0Y1_OpenRAM_bot.Inst_OpenRAM_bot_ConfigMem.Inst_frame1_bit15.Q
+ sky130_fd_sc_hd__dlxtp_1
XFILLER_147_187 VGND VGND VPWR VPWR sky130_fd_sc_hd__decap_3
XFILLER_8_91 VGND VGND VPWR VPWR sky130_fd_sc_hd__decap_3
XFILLER_8_80 VGND VGND VPWR VPWR sky130_fd_sc_hd__decap_3
XFILLER_118_26 VGND VGND VPWR VPWR sky130_fd_sc_hd__fill_2
XTAP_TAPCELL_ROW_9_407 VGND VPWR sky130_fd_sc_hd__tapvpwrvgnd_1
XFILLER_103_202 VGND VGND VPWR VPWR sky130_fd_sc_hd__decap_3
XFILLER_69_193 VGND VGND VPWR VPWR sky130_fd_sc_hd__decap_3
XFILLER_94_29 VGND VGND VPWR VPWR sky130_fd_sc_hd__decap_3
XFILLER_175_6 VGND VGND VPWR VPWR sky130_fd_sc_hd__decap_3
XFILLER_27_78 VGND VGND VPWR VPWR sky130_fd_sc_hd__decap_3
XFILLER_84_174 VGND VGND VPWR VPWR sky130_fd_sc_hd__decap_3
XFILLER_150_68 VGND VGND VPWR VPWR sky130_fd_sc_hd__decap_3
XTAP_TAPCELL_ROW_0_373 VGND VPWR sky130_fd_sc_hd__tapvpwrvgnd_1
XFILLER_159_22 VGND VGND VPWR VPWR sky130_fd_sc_hd__fill_1
XFILLER_40_233 VGND VGND VPWR VPWR sky130_fd_sc_hd__fill_1
XTAP_TAPCELL_ROW_23_464 VGND VPWR sky130_fd_sc_hd__tapvpwrvgnd_1
XFILLER_43_99 VGND VGND VPWR VPWR sky130_fd_sc_hd__decap_3
XFILLER_175_21 VGND VGND VPWR VPWR sky130_fd_sc_hd__decap_3
XFILLER_153_113 VGND VGND VPWR VPWR sky130_fd_sc_hd__decap_3
XFILLER_4_112 VGND VGND VPWR VPWR sky130_fd_sc_hd__decap_3
XFILLER_175_54 VGND VGND VPWR VPWR sky130_fd_sc_hd__fill_2
XFILLER_153_157 VGND VGND VPWR VPWR sky130_fd_sc_hd__decap_3
XFILLER_4_156 VGND VGND VPWR VPWR sky130_fd_sc_hd__decap_3
XFILLER_175_87 VGND VGND VPWR VPWR sky130_fd_sc_hd__decap_3
XFILLER_4_27 VGND VGND VPWR VPWR sky130_fd_sc_hd__fill_1
XFILLER_4_38 VGND VGND VPWR VPWR sky130_fd_sc_hd__decap_3
XFILLER_4_189 VGND VGND VPWR VPWR sky130_fd_sc_hd__decap_3
XFILLER_161_190 VGND VGND VPWR VPWR sky130_fd_sc_hd__decap_3
XFILLER_67_119 VGND VGND VPWR VPWR sky130_fd_sc_hd__decap_3
XFILLER_68_74 VGND VGND VPWR VPWR sky130_fd_sc_hd__decap_3
XFILLER_68_85 VGND VGND VPWR VPWR sky130_fd_sc_hd__decap_3
Xinput263 Tile_X0Y1_N2END[5] VGND VGND VPWR VPWR net346 sky130_fd_sc_hd__clkbuf_2
Xinput252 Tile_X0Y1_FrameData[8] VGND VGND VPWR VPWR net252 sky130_fd_sc_hd__buf_4
Xinput230 Tile_X0Y1_FrameData[17] VGND VGND VPWR VPWR net230 sky130_fd_sc_hd__clkbuf_4
Xinput241 Tile_X0Y1_FrameData[27] VGND VGND VPWR VPWR net241 sky130_fd_sc_hd__buf_4
XFILLER_124_91 VGND VGND VPWR VPWR sky130_fd_sc_hd__decap_3
XFILLER_124_80 VGND VGND VPWR VPWR sky130_fd_sc_hd__decap_3
Xinput274 Tile_X0Y1_N4END[0] VGND VGND VPWR VPWR net357 sky130_fd_sc_hd__clkbuf_2
XFILLER_75_196 VGND VGND VPWR VPWR sky130_fd_sc_hd__fill_2
XFILLER_84_51 VGND VGND VPWR VPWR sky130_fd_sc_hd__decap_3
XTAP_TAPCELL_ROW_46_556 VGND VPWR sky130_fd_sc_hd__tapvpwrvgnd_1
XFILLER_90_166 VGND VGND VPWR VPWR sky130_fd_sc_hd__decap_3
XFILLER_90_6 VGND VGND VPWR VPWR sky130_fd_sc_hd__decap_3
XFILLER_176_227 VGND VGND VPWR VPWR sky130_fd_sc_hd__decap_3
XFILLER_129_143 VGND VGND VPWR VPWR sky130_fd_sc_hd__decap_3
XFILLER_144_135 VGND VGND VPWR VPWR sky130_fd_sc_hd__decap_3
XFILLER_144_113 VGND VGND VPWR VPWR sky130_fd_sc_hd__decap_3
XFILLER_129_198 VGND VGND VPWR VPWR sky130_fd_sc_hd__decap_3
XFILLER_144_168 VGND VGND VPWR VPWR sky130_fd_sc_hd__decap_3
X_1495_ Tile_X0Y1_OpenRAM_bot.Inst_OpenRAM_bot_switch_matrix.WW4BEG1 VGND VGND VPWR
+ VPWR net661 sky130_fd_sc_hd__buf_1
X_0515_ net175 net205 Tile_X0Y1_OpenRAM_bot.Inst_OpenRAM_bot_switch_matrix.J_NS4_BEG13
+ _0066_ Tile_X0Y1_OpenRAM_bot.Inst_OpenRAM_bot_ConfigMem.Inst_frame7_bit6.Q Tile_X0Y1_OpenRAM_bot.Inst_OpenRAM_bot_ConfigMem.Inst_frame7_bit7.Q
+ VGND VGND VPWR VPWR Tile_X0Y1_OpenRAM_bot.Inst_OpenRAM_bot_switch_matrix.S1BEG1
+ sky130_fd_sc_hd__mux4_1
X_0446_ net70 Tile_X0Y0_OpenRAM_top.Inst_OpenRAM_top_ConfigMem.Inst_frame2_bit24.Q
+ VGND VGND VPWR VPWR _0098_ sky130_fd_sc_hd__nand2_1
XTAP_TAPCELL_ROW_69_648 VGND VPWR sky130_fd_sc_hd__tapvpwrvgnd_1
X_0377_ net18 net50 Tile_X0Y0_OpenRAM_top.Inst_OpenRAM_top_switch_matrix.J_NS2_BEG0
+ Tile_X0Y0_OpenRAM_top.Inst_OpenRAM_top_switch_matrix.J_NS2_BEG7 Tile_X0Y0_OpenRAM_top.Inst_OpenRAM_top_ConfigMem.Inst_frame5_bit10.Q
+ Tile_X0Y0_OpenRAM_top.Inst_OpenRAM_top_ConfigMem.Inst_frame5_bit11.Q VGND VGND VPWR
+ VPWR Tile_X0Y0_OpenRAM_top.Inst_OpenRAM_top_switch_matrix.W2BEG7 sky130_fd_sc_hd__mux4_1
XTAP_TAPCELL_ROW_77_681 VGND VPWR sky130_fd_sc_hd__tapvpwrvgnd_1
XFILLER_81_111 VGND VGND VPWR VPWR sky130_fd_sc_hd__fill_1
XFILLER_81_122 VGND VGND VPWR VPWR sky130_fd_sc_hd__decap_3
XFILLER_167_205 VGND VGND VPWR VPWR sky130_fd_sc_hd__decap_3
XFILLER_13_36 VGND VGND VPWR VPWR sky130_fd_sc_hd__decap_3
XFILLER_13_69 VGND VGND VPWR VPWR sky130_fd_sc_hd__decap_3
XFILLER_135_113 VGND VGND VPWR VPWR sky130_fd_sc_hd__decap_3
XFILLER_129_69 VGND VGND VPWR VPWR sky130_fd_sc_hd__decap_3
XFILLER_89_18 VGND VGND VPWR VPWR sky130_fd_sc_hd__decap_3
XFILLER_89_200 VGND VGND VPWR VPWR sky130_fd_sc_hd__decap_3
XFILLER_145_57 VGND VGND VPWR VPWR sky130_fd_sc_hd__fill_1
XFILLER_145_79 VGND VGND VPWR VPWR sky130_fd_sc_hd__decap_3
XFILLER_49_119 VGND VGND VPWR VPWR sky130_fd_sc_hd__decap_3
XFILLER_38_44 VGND VGND VPWR VPWR sky130_fd_sc_hd__fill_1
XFILLER_161_34 VGND VGND VPWR VPWR sky130_fd_sc_hd__decap_3
XFILLER_38_88 VGND VGND VPWR VPWR sky130_fd_sc_hd__decap_3
XFILLER_173_3 VGND VGND VPWR VPWR sky130_fd_sc_hd__decap_3
XFILLER_57_196 VGND VGND VPWR VPWR sky130_fd_sc_hd__fill_2
XFILLER_72_111 VGND VGND VPWR VPWR sky130_fd_sc_hd__decap_3
XFILLER_54_32 VGND VGND VPWR VPWR sky130_fd_sc_hd__decap_3
XFILLER_72_144 VGND VGND VPWR VPWR sky130_fd_sc_hd__decap_3
XFILLER_54_65 VGND VGND VPWR VPWR sky130_fd_sc_hd__decap_3
XFILLER_72_188 VGND VGND VPWR VPWR sky130_fd_sc_hd__decap_3
XFILLER_13_211 VGND VGND VPWR VPWR sky130_fd_sc_hd__decap_3
XFILLER_70_53 VGND VGND VPWR VPWR sky130_fd_sc_hd__decap_3
XFILLER_173_208 VGND VGND VPWR VPWR sky130_fd_sc_hd__decap_3
XFILLER_126_113 VGND VGND VPWR VPWR sky130_fd_sc_hd__decap_3
XFILLER_70_97 VGND VGND VPWR VPWR sky130_fd_sc_hd__decap_3
XFILLER_141_116 VGND VGND VPWR VPWR sky130_fd_sc_hd__decap_3
XFILLER_134_190 VGND VGND VPWR VPWR sky130_fd_sc_hd__decap_3
X_0300_ Tile_X0Y0_OpenRAM_top.Inst_OpenRAM_top_switch_matrix.N1END1 net362 net147
+ net167 Tile_X0Y0_OpenRAM_top.Inst_OpenRAM_top_ConfigMem.Inst_frame0_bit2.Q Tile_X0Y0_OpenRAM_top.Inst_OpenRAM_top_ConfigMem.Inst_frame0_bit3.Q
+ VGND VGND VPWR VPWR Tile_X0Y0_OpenRAM_top.Inst_OpenRAM_top_switch_matrix.J_NS4_BEG13
+ sky130_fd_sc_hd__mux4_2
X_1280_ net129 VGND VGND VPWR VPWR net432 sky130_fd_sc_hd__buf_1
X_0231_ Tile_X0Y0_OpenRAM_top.Inst_OpenRAM_top_ConfigMem.Inst_frame0_bit31.Q VGND
+ VGND VPWR VPWR _0004_ sky130_fd_sc_hd__inv_1
XTAP_TAPCELL_ROW_118_844 VGND VPWR sky130_fd_sc_hd__tapvpwrvgnd_1
XFILLER_0_192 VGND VGND VPWR VPWR sky130_fd_sc_hd__decap_3
XFILLER_48_141 VGND VGND VPWR VPWR sky130_fd_sc_hd__decap_3
XFILLER_95_83 VGND VGND VPWR VPWR sky130_fd_sc_hd__decap_3
XTAP_TAPCELL_ROW_163_1022 VGND VPWR sky130_fd_sc_hd__tapvpwrvgnd_1
XFILLER_48_174 VGND VGND VPWR VPWR sky130_fd_sc_hd__decap_3
XFILLER_63_133 VGND VGND VPWR VPWR sky130_fd_sc_hd__decap_3
XFILLER_63_166 VGND VGND VPWR VPWR sky130_fd_sc_hd__fill_2
XFILLER_63_199 VGND VGND VPWR VPWR sky130_fd_sc_hd__decap_3
XTAP_TAPCELL_ROW_101_777 VGND VPWR sky130_fd_sc_hd__tapvpwrvgnd_1
X_0995_ net247 net330 VGND VGND VPWR VPWR Tile_X0Y1_OpenRAM_bot.Inst_OpenRAM_bot_ConfigMem.Inst_frame0_bit3.Q
+ sky130_fd_sc_hd__dlxtp_1
XFILLER_117_113 VGND VGND VPWR VPWR sky130_fd_sc_hd__decap_3
Xoutput501 net584 VGND VGND VPWR VPWR Tile_X0Y1_FrameData_O[8] sky130_fd_sc_hd__buf_2
XFILLER_117_146 VGND VGND VPWR VPWR sky130_fd_sc_hd__decap_3
Xoutput545 net628 VGND VGND VPWR VPWR Tile_X0Y1_W2BEG[2] sky130_fd_sc_hd__buf_2
Xoutput534 net617 VGND VGND VPWR VPWR Tile_X0Y1_S4BEG[5] sky130_fd_sc_hd__buf_2
Xoutput523 net606 VGND VGND VPWR VPWR Tile_X0Y1_S4BEG[0] sky130_fd_sc_hd__buf_2
Xoutput512 net595 VGND VGND VPWR VPWR Tile_X0Y1_S2BEG[5] sky130_fd_sc_hd__buf_2
XFILLER_125_190 VGND VGND VPWR VPWR sky130_fd_sc_hd__decap_3
Xoutput556 net639 VGND VGND VPWR VPWR Tile_X0Y1_W2BEGb[5] sky130_fd_sc_hd__buf_2
Xoutput578 net661 VGND VGND VPWR VPWR Tile_X0Y1_WW4BEG[1] sky130_fd_sc_hd__buf_2
XFILLER_5_81 VGND VGND VPWR VPWR sky130_fd_sc_hd__decap_3
Xoutput567 net650 VGND VGND VPWR VPWR Tile_X0Y1_W6BEG[6] sky130_fd_sc_hd__buf_2
Xoutput589 net672 VGND VGND VPWR VPWR WMASK_A_SRAM1 sky130_fd_sc_hd__buf_2
XFILLER_140_193 VGND VGND VPWR VPWR sky130_fd_sc_hd__decap_3
X_1478_ Tile_X0Y1_OpenRAM_bot.Inst_OpenRAM_bot_switch_matrix.W2BEGb4 VGND VGND VPWR
+ VPWR net638 sky130_fd_sc_hd__clkbuf_1
X_0429_ net106 net99 net90 _0096_ Tile_X0Y0_OpenRAM_top.Inst_OpenRAM_top_ConfigMem.Inst_frame3_bit24.Q
+ Tile_X0Y0_OpenRAM_top.Inst_OpenRAM_top_ConfigMem.Inst_frame3_bit25.Q VGND VGND VPWR
+ VPWR net395 sky130_fd_sc_hd__mux4_2
XFILLER_54_100 VGND VGND VPWR VPWR sky130_fd_sc_hd__decap_3
XFILLER_131_48 VGND VGND VPWR VPWR sky130_fd_sc_hd__decap_3
XFILLER_54_133 VGND VGND VPWR VPWR sky130_fd_sc_hd__decap_3
XFILLER_54_144 VGND VGND VPWR VPWR sky130_fd_sc_hd__decap_3
XTAP_TAPCELL_ROW_124_869 VGND VPWR sky130_fd_sc_hd__tapvpwrvgnd_1
XFILLER_54_177 VGND VGND VPWR VPWR sky130_fd_sc_hd__decap_3
XFILLER_24_24 VGND VGND VPWR VPWR sky130_fd_sc_hd__decap_3
XFILLER_24_35 VGND VGND VPWR VPWR sky130_fd_sc_hd__decap_3
XFILLER_10_203 VGND VGND VPWR VPWR sky130_fd_sc_hd__decap_3
XFILLER_108_124 VGND VGND VPWR VPWR sky130_fd_sc_hd__decap_3
XPHY_EDGE_ROW_149_Right_149 VGND VGND VPWR VPWR sky130_fd_sc_hd__decap_3
XFILLER_108_168 VGND VGND VPWR VPWR sky130_fd_sc_hd__decap_3
XFILLER_40_78 VGND VGND VPWR VPWR sky130_fd_sc_hd__decap_3
XFILLER_156_56 VGND VGND VPWR VPWR sky130_fd_sc_hd__decap_3
XFILLER_123_105 VGND VGND VPWR VPWR sky130_fd_sc_hd__decap_3
XFILLER_123_149 VGND VGND VPWR VPWR sky130_fd_sc_hd__decap_3
XFILLER_49_54 VGND VGND VPWR VPWR sky130_fd_sc_hd__fill_2
XFILLER_172_44 VGND VGND VPWR VPWR sky130_fd_sc_hd__decap_3
XFILLER_49_87 VGND VGND VPWR VPWR sky130_fd_sc_hd__decap_3
XFILLER_172_88 VGND VGND VPWR VPWR sky130_fd_sc_hd__decap_3
XFILLER_172_77 VGND VGND VPWR VPWR sky130_fd_sc_hd__decap_3
XFILLER_105_60 VGND VGND VPWR VPWR sky130_fd_sc_hd__decap_3
XFILLER_92_206 VGND VGND VPWR VPWR sky130_fd_sc_hd__decap_3
XFILLER_45_100 VGND VGND VPWR VPWR sky130_fd_sc_hd__decap_3
XFILLER_65_42 VGND VGND VPWR VPWR sky130_fd_sc_hd__decap_3
XFILLER_65_75 VGND VGND VPWR VPWR sky130_fd_sc_hd__decap_3
XFILLER_121_81 VGND VGND VPWR VPWR sky130_fd_sc_hd__decap_3
XFILLER_60_147 VGND VGND VPWR VPWR sky130_fd_sc_hd__decap_3
XTAP_TAPCELL_ROW_71_654 VGND VPWR sky130_fd_sc_hd__tapvpwrvgnd_1
XFILLER_81_63 VGND VGND VPWR VPWR sky130_fd_sc_hd__decap_3
X_0780_ net142 net319 VGND VGND VPWR VPWR Tile_X0Y0_OpenRAM_top.Inst_OpenRAM_top_ConfigMem.Inst_frame2_bit6.Q
+ sky130_fd_sc_hd__dlxtp_1
XPHY_EDGE_ROW_116_Right_116 VGND VGND VPWR VPWR sky130_fd_sc_hd__decap_3
XFILLER_114_127 VGND VGND VPWR VPWR sky130_fd_sc_hd__decap_3
X_1401_ net251 VGND VGND VPWR VPWR net583 sky130_fd_sc_hd__buf_4
XPHY_EDGE_ROW_126_Left_309 VGND VGND VPWR VPWR sky130_fd_sc_hd__decap_3
XFILLER_68_203 VGND VGND VPWR VPWR sky130_fd_sc_hd__decap_3
X_1332_ Tile_X0Y1_N4END[11] VGND VGND VPWR VPWR net498 sky130_fd_sc_hd__clkbuf_1
XFILLER_122_193 VGND VGND VPWR VPWR sky130_fd_sc_hd__decap_3
X_1263_ net142 VGND VGND VPWR VPWR net445 sky130_fd_sc_hd__clkbuf_2
Xinput5 DOUT_A_SRAM11 VGND VGND VPWR VPWR net5 sky130_fd_sc_hd__buf_1
XFILLER_36_133 VGND VGND VPWR VPWR sky130_fd_sc_hd__decap_3
XFILLER_36_144 VGND VGND VPWR VPWR sky130_fd_sc_hd__decap_3
X_1194_ net242 net272 VGND VGND VPWR VPWR Tile_X0Y1_OpenRAM_bot.Inst_OpenRAM_bot_ConfigMem.Inst_frame7_bit28.Q
+ sky130_fd_sc_hd__dlxtp_1
XTAP_TAPCELL_ROW_94_746 VGND VPWR sky130_fd_sc_hd__tapvpwrvgnd_1
XFILLER_36_177 VGND VGND VPWR VPWR sky130_fd_sc_hd__decap_3
XPHY_EDGE_ROW_135_Left_318 VGND VGND VPWR VPWR sky130_fd_sc_hd__decap_3
XFILLER_51_125 VGND VGND VPWR VPWR sky130_fd_sc_hd__fill_1
XTAP_TAPCELL_ROW_62_621 VGND VPWR sky130_fd_sc_hd__tapvpwrvgnd_1
X_0978_ net234 net332 VGND VGND VPWR VPWR Tile_X0Y1_OpenRAM_bot.Inst_OpenRAM_bot_ConfigMem.Inst_frame0_bit20.Q
+ sky130_fd_sc_hd__dlxtp_1
XPHY_EDGE_ROW_144_Left_327 VGND VGND VPWR VPWR sky130_fd_sc_hd__decap_3
XFILLER_105_116 VGND VGND VPWR VPWR sky130_fd_sc_hd__fill_1
XFILLER_10_15 VGND VGND VPWR VPWR sky130_fd_sc_hd__decap_3
Xoutput353 net436 VGND VGND VPWR VPWR Tile_X0Y0_FrameData_O[27] sky130_fd_sc_hd__buf_2
Xoutput342 net425 VGND VGND VPWR VPWR Tile_X0Y0_FrameData_O[17] sky130_fd_sc_hd__buf_2
XFILLER_105_138 VGND VGND VPWR VPWR sky130_fd_sc_hd__decap_3
Xoutput320 net403 VGND VGND VPWR VPWR DIN_A_SRAM25 sky130_fd_sc_hd__buf_2
XFILLER_10_59 VGND VGND VPWR VPWR sky130_fd_sc_hd__decap_3
Xoutput331 net414 VGND VGND VPWR VPWR DIN_A_SRAM7 sky130_fd_sc_hd__buf_2
Xoutput375 net458 VGND VGND VPWR VPWR Tile_X0Y0_FrameStrobe_O[18] sky130_fd_sc_hd__buf_2
Xoutput386 net469 VGND VGND VPWR VPWR Tile_X0Y0_N1BEG[0] sky130_fd_sc_hd__buf_2
Xoutput364 net447 VGND VGND VPWR VPWR Tile_X0Y0_FrameData_O[8] sky130_fd_sc_hd__buf_2
Xoutput397 net480 VGND VGND VPWR VPWR Tile_X0Y0_N2BEG[7] sky130_fd_sc_hd__buf_2
XFILLER_59_225 VGND VGND VPWR VPWR sky130_fd_sc_hd__fill_2
XFILLER_113_193 VGND VGND VPWR VPWR sky130_fd_sc_hd__decap_3
XFILLER_19_35 VGND VGND VPWR VPWR sky130_fd_sc_hd__fill_2
XFILLER_142_25 VGND VGND VPWR VPWR sky130_fd_sc_hd__decap_3
XFILLER_19_57 VGND VGND VPWR VPWR sky130_fd_sc_hd__fill_2
XFILLER_74_206 VGND VGND VPWR VPWR sky130_fd_sc_hd__decap_3
XTAP_TAPCELL_ROW_85_713 VGND VPWR sky130_fd_sc_hd__tapvpwrvgnd_1
XFILLER_27_111 VGND VGND VPWR VPWR sky130_fd_sc_hd__fill_1
XFILLER_27_122 VGND VGND VPWR VPWR sky130_fd_sc_hd__decap_3
XPHY_EDGE_ROW_153_Left_336 VGND VGND VPWR VPWR sky130_fd_sc_hd__decap_3
XFILLER_27_166 VGND VGND VPWR VPWR sky130_fd_sc_hd__fill_2
XFILLER_27_188 VGND VGND VPWR VPWR sky130_fd_sc_hd__decap_3
XFILLER_35_45 VGND VGND VPWR VPWR sky130_fd_sc_hd__decap_3
XFILLER_42_147 VGND VGND VPWR VPWR sky130_fd_sc_hd__decap_3
XTAP_TAPCELL_ROW_120_850 VGND VPWR sky130_fd_sc_hd__tapvpwrvgnd_1
XFILLER_136_3 VGND VGND VPWR VPWR sky130_fd_sc_hd__fill_1
XFILLER_51_33 VGND VGND VPWR VPWR sky130_fd_sc_hd__decap_3
XFILLER_167_33 VGND VGND VPWR VPWR sky130_fd_sc_hd__decap_3
XFILLER_167_66 VGND VGND VPWR VPWR sky130_fd_sc_hd__decap_3
XPHY_EDGE_ROW_162_Left_345 VGND VGND VPWR VPWR sky130_fd_sc_hd__decap_3
XFILLER_51_99 VGND VGND VPWR VPWR sky130_fd_sc_hd__decap_3
XFILLER_76_41 VGND VGND VPWR VPWR sky130_fd_sc_hd__decap_3
XFILLER_65_206 VGND VGND VPWR VPWR sky130_fd_sc_hd__fill_2
XFILLER_76_74 VGND VGND VPWR VPWR sky130_fd_sc_hd__decap_3
XPHY_EDGE_ROW_171_Left_354 VGND VGND VPWR VPWR sky130_fd_sc_hd__decap_3
XTAP_TAPCELL_ROW_143_942 VGND VPWR sky130_fd_sc_hd__tapvpwrvgnd_1
XFILLER_18_144 VGND VGND VPWR VPWR sky130_fd_sc_hd__decap_3
XFILLER_80_209 VGND VGND VPWR VPWR sky130_fd_sc_hd__decap_3
XFILLER_33_147 VGND VGND VPWR VPWR sky130_fd_sc_hd__decap_3
X_0901_ net118 net284 VGND VGND VPWR VPWR Tile_X0Y0_OpenRAM_top.Inst_OpenRAM_top_ConfigMem.Inst_frame6_bit13.Q
+ sky130_fd_sc_hd__dlxtp_1
XFILLER_119_219 VGND VGND VPWR VPWR sky130_fd_sc_hd__fill_2
XPHY_EDGE_ROW_180_Left_363 VGND VGND VPWR VPWR sky130_fd_sc_hd__decap_3
X_0832_ net123 net303 VGND VGND VPWR VPWR Tile_X0Y0_OpenRAM_top.Inst_OpenRAM_top_ConfigMem.Inst_frame4_bit18.Q
+ sky130_fd_sc_hd__dlxtp_1
X_0763_ net129 net319 VGND VGND VPWR VPWR Tile_X0Y0_OpenRAM_top.Inst_OpenRAM_top_ConfigMem.Inst_frame2_bit23.Q
+ sky130_fd_sc_hd__dlxtp_1
XFILLER_142_200 VGND VGND VPWR VPWR sky130_fd_sc_hd__decap_3
X_0694_ net134 net335 VGND VGND VPWR VPWR Tile_X0Y0_OpenRAM_top.Inst_OpenRAM_top_ConfigMem.Inst_frame0_bit28.Q
+ sky130_fd_sc_hd__dlxtp_1
XFILLER_142_211 VGND VGND VPWR VPWR sky130_fd_sc_hd__fill_2
XFILLER_102_119 VGND VGND VPWR VPWR sky130_fd_sc_hd__fill_1
X_1315_ Tile_X0Y0_OpenRAM_top.Inst_OpenRAM_top_switch_matrix.N2BEG2 VGND VGND VPWR
+ VPWR net475 sky130_fd_sc_hd__clkbuf_2
XFILLER_110_152 VGND VGND VPWR VPWR sky130_fd_sc_hd__decap_3
XFILLER_56_217 VGND VGND VPWR VPWR sky130_fd_sc_hd__decap_3
X_1246_ net252 net265 VGND VGND VPWR VPWR Tile_X0Y1_OpenRAM_bot.Inst_OpenRAM_bot_ConfigMem.Inst_frame8_bit8.Q
+ sky130_fd_sc_hd__dlxtp_1
X_1177_ net226 net280 VGND VGND VPWR VPWR Tile_X0Y1_OpenRAM_bot.Inst_OpenRAM_bot_ConfigMem.Inst_frame6_bit13.Q
+ sky130_fd_sc_hd__dlxtp_1
XFILLER_169_119 VGND VGND VPWR VPWR sky130_fd_sc_hd__decap_3
XFILLER_169_108 VGND VGND VPWR VPWR sky130_fd_sc_hd__decap_3
XFILLER_24_147 VGND VGND VPWR VPWR sky130_fd_sc_hd__decap_3
XFILLER_177_152 VGND VGND VPWR VPWR sky130_fd_sc_hd__decap_3
XFILLER_32_180 VGND VGND VPWR VPWR sky130_fd_sc_hd__decap_3
XFILLER_177_196 VGND VGND VPWR VPWR sky130_fd_sc_hd__decap_3
XTAP_TAPCELL_ROW_176_1076 VGND VPWR sky130_fd_sc_hd__tapvpwrvgnd_1
XFILLER_21_69 VGND VGND VPWR VPWR sky130_fd_sc_hd__decap_3
XFILLER_137_69 VGND VGND VPWR VPWR sky130_fd_sc_hd__decap_3
XFILLER_108_7 VGND VGND VPWR VPWR sky130_fd_sc_hd__decap_3
XFILLER_97_18 VGND VGND VPWR VPWR sky130_fd_sc_hd__decap_3
XFILLER_153_35 VGND VGND VPWR VPWR sky130_fd_sc_hd__decap_3
XFILLER_101_141 VGND VGND VPWR VPWR sky130_fd_sc_hd__decap_3
XFILLER_46_22 VGND VGND VPWR VPWR sky130_fd_sc_hd__decap_3
XFILLER_46_44 VGND VGND VPWR VPWR sky130_fd_sc_hd__decap_3
XFILLER_46_66 VGND VGND VPWR VPWR sky130_fd_sc_hd__decap_3
XFILLER_62_209 VGND VGND VPWR VPWR sky130_fd_sc_hd__decap_3
XFILLER_15_125 VGND VGND VPWR VPWR sky130_fd_sc_hd__decap_3
XFILLER_15_103 VGND VGND VPWR VPWR sky130_fd_sc_hd__decap_3
XFILLER_15_169 VGND VGND VPWR VPWR sky130_fd_sc_hd__decap_3
XFILLER_15_158 VGND VGND VPWR VPWR sky130_fd_sc_hd__decap_3
XFILLER_178_21 VGND VGND VPWR VPWR sky130_fd_sc_hd__decap_3
XFILLER_102_94 VGND VGND VPWR VPWR sky130_fd_sc_hd__decap_3
XFILLER_102_83 VGND VGND VPWR VPWR sky130_fd_sc_hd__fill_1
XFILLER_178_32 VGND VGND VPWR VPWR sky130_fd_sc_hd__decap_3
XFILLER_168_141 VGND VGND VPWR VPWR sky130_fd_sc_hd__fill_2
XFILLER_178_65 VGND VGND VPWR VPWR sky130_fd_sc_hd__decap_3
XFILLER_168_185 VGND VGND VPWR VPWR sky130_fd_sc_hd__decap_3
XFILLER_7_27 VGND VGND VPWR VPWR sky130_fd_sc_hd__decap_3
XFILLER_124_200 VGND VGND VPWR VPWR sky130_fd_sc_hd__decap_3
XFILLER_97_106 VGND VGND VPWR VPWR sky130_fd_sc_hd__decap_3
XFILLER_97_128 VGND VGND VPWR VPWR sky130_fd_sc_hd__decap_3
XFILLER_87_51 VGND VGND VPWR VPWR sky130_fd_sc_hd__decap_3
X_1100_ net240 net297 VGND VGND VPWR VPWR Tile_X0Y1_OpenRAM_bot.Inst_OpenRAM_bot_ConfigMem.Inst_frame4_bit26.Q
+ sky130_fd_sc_hd__dlxtp_1
X_1031_ net246 net316 VGND VGND VPWR VPWR Tile_X0Y1_OpenRAM_bot.Inst_OpenRAM_bot_ConfigMem.Inst_frame2_bit31.Q
+ sky130_fd_sc_hd__dlxtp_1
XFILLER_99_3 VGND VGND VPWR VPWR sky130_fd_sc_hd__decap_3
XFILLER_159_152 VGND VGND VPWR VPWR sky130_fd_sc_hd__decap_3
XFILLER_14_180 VGND VGND VPWR VPWR sky130_fd_sc_hd__decap_3
XFILLER_21_128 VGND VGND VPWR VPWR sky130_fd_sc_hd__decap_3
XFILLER_174_100 VGND VGND VPWR VPWR sky130_fd_sc_hd__decap_3
XFILLER_174_144 VGND VGND VPWR VPWR sky130_fd_sc_hd__decap_3
XFILLER_174_133 VGND VGND VPWR VPWR sky130_fd_sc_hd__decap_3
Xinput30 DOUT_A_SRAM6 VGND VGND VPWR VPWR net30 sky130_fd_sc_hd__buf_1
XFILLER_174_177 VGND VGND VPWR VPWR sky130_fd_sc_hd__decap_3
X_0815_ net139 net310 VGND VGND VPWR VPWR Tile_X0Y0_OpenRAM_top.Inst_OpenRAM_top_ConfigMem.Inst_frame3_bit3.Q
+ sky130_fd_sc_hd__dlxtp_1
Xinput63 DOUT_B_SRAM7 VGND VGND VPWR VPWR net63 sky130_fd_sc_hd__buf_1
Xinput41 DOUT_B_SRAM15 VGND VGND VPWR VPWR net41 sky130_fd_sc_hd__buf_1
Xinput52 DOUT_B_SRAM25 VGND VGND VPWR VPWR net52 sky130_fd_sc_hd__clkbuf_2
X_0746_ net144 net327 VGND VGND VPWR VPWR Tile_X0Y0_OpenRAM_top.Inst_OpenRAM_top_ConfigMem.Inst_frame1_bit8.Q
+ sky130_fd_sc_hd__dlxtp_1
Xinput96 Tile_X0Y0_E6END[8] VGND VGND VPWR VPWR net96 sky130_fd_sc_hd__dlymetal6s2s_1
Xinput74 Tile_X0Y0_E2END[4] VGND VGND VPWR VPWR net74 sky130_fd_sc_hd__buf_1
Xinput85 Tile_X0Y0_E2MID[7] VGND VGND VPWR VPWR net85 sky130_fd_sc_hd__buf_1
XFILLER_107_17 VGND VGND VPWR VPWR sky130_fd_sc_hd__decap_3
XFILLER_88_106 VGND VGND VPWR VPWR sky130_fd_sc_hd__decap_3
X_0677_ Tile_X0Y1_OpenRAM_bot.Inst_OpenRAM_bot_ConfigMem.Inst_frame3_bit13.Q Tile_X0Y1_OpenRAM_bot.Inst_OpenRAM_bot_ConfigMem.Inst_frame3_bit14.Q
+ VGND VGND VPWR VPWR _0214_ sky130_fd_sc_hd__or2_1
XFILLER_96_150 VGND VGND VPWR VPWR sky130_fd_sc_hd__decap_3
XFILLER_44_209 VGND VGND VPWR VPWR sky130_fd_sc_hd__decap_3
X_1229_ net239 net264 VGND VGND VPWR VPWR Tile_X0Y1_OpenRAM_bot.Inst_OpenRAM_bot_ConfigMem.Inst_frame8_bit25.Q
+ sky130_fd_sc_hd__dlxtp_1
XFILLER_16_47 VGND VGND VPWR VPWR sky130_fd_sc_hd__decap_3
XFILLER_12_106 VGND VGND VPWR VPWR sky130_fd_sc_hd__decap_3
XFILLER_12_139 VGND VGND VPWR VPWR sky130_fd_sc_hd__fill_1
XFILLER_20_150 VGND VGND VPWR VPWR sky130_fd_sc_hd__decap_3
XFILLER_32_35 VGND VGND VPWR VPWR sky130_fd_sc_hd__decap_3
XFILLER_165_122 VGND VGND VPWR VPWR sky130_fd_sc_hd__decap_3
XFILLER_148_35 VGND VGND VPWR VPWR sky130_fd_sc_hd__decap_3
XFILLER_20_183 VGND VGND VPWR VPWR sky130_fd_sc_hd__decap_3
XFILLER_180_103 VGND VGND VPWR VPWR sky130_fd_sc_hd__decap_3
XFILLER_165_155 VGND VGND VPWR VPWR sky130_fd_sc_hd__decap_3
XFILLER_148_79 VGND VGND VPWR VPWR sky130_fd_sc_hd__decap_3
XFILLER_148_57 VGND VGND VPWR VPWR sky130_fd_sc_hd__fill_1
XFILLER_180_136 VGND VGND VPWR VPWR sky130_fd_sc_hd__decap_3
XFILLER_106_233 VGND VGND VPWR VPWR sky130_fd_sc_hd__fill_1
XFILLER_106_200 VGND VGND VPWR VPWR sky130_fd_sc_hd__decap_3
XFILLER_180_169 VGND VGND VPWR VPWR sky130_fd_sc_hd__decap_3
XFILLER_164_67 VGND VGND VPWR VPWR sky130_fd_sc_hd__decap_3
XFILLER_121_225 VGND VGND VPWR VPWR sky130_fd_sc_hd__fill_1
XFILLER_121_214 VGND VGND VPWR VPWR sky130_fd_sc_hd__decap_3
XFILLER_94_109 VGND VGND VPWR VPWR sky130_fd_sc_hd__decap_3
XFILLER_180_55 VGND VGND VPWR VPWR sky130_fd_sc_hd__decap_3
XFILLER_57_87 VGND VGND VPWR VPWR sky130_fd_sc_hd__decap_3
XFILLER_180_88 VGND VGND VPWR VPWR sky130_fd_sc_hd__decap_3
XTAP_TAPCELL_ROW_3_382 VGND VPWR sky130_fd_sc_hd__tapvpwrvgnd_1
XFILLER_73_31 VGND VGND VPWR VPWR sky130_fd_sc_hd__decap_3
XFILLER_73_53 VGND VGND VPWR VPWR sky130_fd_sc_hd__decap_3
XFILLER_73_75 VGND VGND VPWR VPWR sky130_fd_sc_hd__fill_2
XFILLER_156_100 VGND VGND VPWR VPWR sky130_fd_sc_hd__decap_3
XFILLER_85_9 VGND VGND VPWR VPWR sky130_fd_sc_hd__decap_3
XFILLER_156_144 VGND VGND VPWR VPWR sky130_fd_sc_hd__decap_3
XFILLER_156_133 VGND VGND VPWR VPWR sky130_fd_sc_hd__decap_3
XFILLER_11_161 VGND VGND VPWR VPWR sky130_fd_sc_hd__decap_3
XFILLER_7_143 VGND VGND VPWR VPWR sky130_fd_sc_hd__decap_3
XFILLER_171_125 VGND VGND VPWR VPWR sky130_fd_sc_hd__decap_3
XFILLER_7_187 VGND VGND VPWR VPWR sky130_fd_sc_hd__decap_3
X_0600_ net206 net220 net194 _0156_ Tile_X0Y1_OpenRAM_bot.Inst_OpenRAM_bot_ConfigMem.Inst_frame3_bit28.Q
+ Tile_X0Y1_OpenRAM_bot.Inst_OpenRAM_bot_ConfigMem.Inst_frame3_bit29.Q VGND VGND VPWR
+ VPWR net385 sky130_fd_sc_hd__mux4_2
XFILLER_171_169 VGND VGND VPWR VPWR sky130_fd_sc_hd__decap_3
XFILLER_171_158 VGND VGND VPWR VPWR sky130_fd_sc_hd__decap_3
XFILLER_98_61 VGND VGND VPWR VPWR sky130_fd_sc_hd__decap_3
X_0531_ net3 net35 net262 _0086_ Tile_X0Y1_OpenRAM_bot.Inst_OpenRAM_bot_ConfigMem.Inst_frame6_bit18.Q
+ Tile_X0Y1_OpenRAM_bot.Inst_OpenRAM_bot_ConfigMem.Inst_frame6_bit19.Q VGND VGND VPWR
+ VPWR Tile_X0Y1_OpenRAM_bot.Inst_OpenRAM_bot_switch_matrix.W2BEG1 sky130_fd_sc_hd__mux4_1
XFILLER_112_203 VGND VGND VPWR VPWR sky130_fd_sc_hd__decap_3
X_0462_ _0108_ Tile_X0Y0_OpenRAM_top.Inst_OpenRAM_top_ConfigMem.Inst_frame1_bit3.Q
+ _0010_ _0107_ VGND VGND VPWR VPWR net378 sky130_fd_sc_hd__a2bb2o_1
X_0393_ Tile_X0Y0_OpenRAM_top.Inst_OpenRAM_top_switch_matrix.N1END2 net363 net148
+ net168 Tile_X0Y0_OpenRAM_top.Inst_OpenRAM_top_ConfigMem.Inst_frame1_bit28.Q Tile_X0Y0_OpenRAM_top.Inst_OpenRAM_top_ConfigMem.Inst_frame1_bit29.Q
+ VGND VGND VPWR VPWR Tile_X0Y0_OpenRAM_top.Inst_OpenRAM_top_switch_matrix.J_NS4_BEG10
+ sky130_fd_sc_hd__mux4_2
XFILLER_78_150 VGND VGND VPWR VPWR sky130_fd_sc_hd__decap_3
XFILLER_85_109 VGND VGND VPWR VPWR sky130_fd_sc_hd__decap_3
XFILLER_78_183 VGND VGND VPWR VPWR sky130_fd_sc_hd__decap_3
XFILLER_93_131 VGND VGND VPWR VPWR sky130_fd_sc_hd__decap_3
XFILLER_179_203 VGND VGND VPWR VPWR sky130_fd_sc_hd__decap_3
X_1014_ net229 net323 VGND VGND VPWR VPWR Tile_X0Y1_OpenRAM_bot.Inst_OpenRAM_bot_ConfigMem.Inst_frame1_bit16.Q
+ sky130_fd_sc_hd__dlxtp_1
XFILLER_179_225 VGND VGND VPWR VPWR sky130_fd_sc_hd__decap_3
XTAP_TAPCELL_ROW_17_440 VGND VPWR sky130_fd_sc_hd__tapvpwrvgnd_1
XFILLER_147_111 VGND VGND VPWR VPWR sky130_fd_sc_hd__fill_1
XFILLER_147_122 VGND VGND VPWR VPWR sky130_fd_sc_hd__decap_3
XTAP_TAPCELL_ROW_32_498 VGND VPWR sky130_fd_sc_hd__tapvpwrvgnd_1
XFILLER_147_155 VGND VGND VPWR VPWR sky130_fd_sc_hd__decap_3
XFILLER_162_136 VGND VGND VPWR VPWR sky130_fd_sc_hd__decap_3
XFILLER_147_199 VGND VGND VPWR VPWR sky130_fd_sc_hd__decap_3
XFILLER_118_38 VGND VGND VPWR VPWR sky130_fd_sc_hd__decap_3
XTAP_TAPCELL_ROW_9_408 VGND VPWR sky130_fd_sc_hd__tapvpwrvgnd_1
X_0729_ net131 net327 VGND VGND VPWR VPWR Tile_X0Y0_OpenRAM_top.Inst_OpenRAM_top_ConfigMem.Inst_frame1_bit25.Q
+ sky130_fd_sc_hd__dlxtp_1
XFILLER_103_225 VGND VGND VPWR VPWR sky130_fd_sc_hd__decap_3
XFILLER_103_214 VGND VGND VPWR VPWR sky130_fd_sc_hd__decap_3
XFILLER_170_180 VGND VGND VPWR VPWR sky130_fd_sc_hd__decap_3
XFILLER_69_161 VGND VGND VPWR VPWR sky130_fd_sc_hd__decap_3
XFILLER_76_109 VGND VGND VPWR VPWR sky130_fd_sc_hd__decap_3
XFILLER_69_172 VGND VGND VPWR VPWR sky130_fd_sc_hd__decap_3
XFILLER_27_24 VGND VGND VPWR VPWR sky130_fd_sc_hd__decap_3
XFILLER_84_153 VGND VGND VPWR VPWR sky130_fd_sc_hd__decap_3
XFILLER_150_47 VGND VGND VPWR VPWR sky130_fd_sc_hd__decap_3
XFILLER_27_46 VGND VGND VPWR VPWR sky130_fd_sc_hd__decap_3
XFILLER_27_57 VGND VGND VPWR VPWR sky130_fd_sc_hd__decap_3
XFILLER_84_186 VGND VGND VPWR VPWR sky130_fd_sc_hd__decap_3
XFILLER_84_197 VGND VGND VPWR VPWR sky130_fd_sc_hd__fill_2
XFILLER_43_34 VGND VGND VPWR VPWR sky130_fd_sc_hd__decap_3
XFILLER_138_100 VGND VGND VPWR VPWR sky130_fd_sc_hd__decap_3
XTAP_TAPCELL_ROW_23_465 VGND VPWR sky130_fd_sc_hd__tapvpwrvgnd_1
XFILLER_43_78 VGND VGND VPWR VPWR sky130_fd_sc_hd__decap_3
XFILLER_138_144 VGND VGND VPWR VPWR sky130_fd_sc_hd__decap_3
XFILLER_138_122 VGND VGND VPWR VPWR sky130_fd_sc_hd__decap_3
XFILLER_138_177 VGND VGND VPWR VPWR sky130_fd_sc_hd__decap_3
XFILLER_175_33 VGND VGND VPWR VPWR sky130_fd_sc_hd__decap_3
XFILLER_153_125 VGND VGND VPWR VPWR sky130_fd_sc_hd__fill_2
XFILLER_4_124 VGND VGND VPWR VPWR sky130_fd_sc_hd__decap_3
XFILLER_175_66 VGND VGND VPWR VPWR sky130_fd_sc_hd__decap_3
XFILLER_153_169 VGND VGND VPWR VPWR sky130_fd_sc_hd__decap_3
XFILLER_175_99 VGND VGND VPWR VPWR sky130_fd_sc_hd__decap_3
XFILLER_4_168 VGND VGND VPWR VPWR sky130_fd_sc_hd__decap_3
Xinput220 Tile_X0Y1_EE4END[8] VGND VGND VPWR VPWR net220 sky130_fd_sc_hd__clkbuf_1
Xinput253 Tile_X0Y1_FrameData[9] VGND VGND VPWR VPWR net253 sky130_fd_sc_hd__buf_4
Xinput231 Tile_X0Y1_FrameData[18] VGND VGND VPWR VPWR net231 sky130_fd_sc_hd__clkbuf_4
Xinput242 Tile_X0Y1_FrameData[28] VGND VGND VPWR VPWR net242 sky130_fd_sc_hd__buf_4
Xinput275 Tile_X0Y1_N4END[1] VGND VGND VPWR VPWR net358 sky130_fd_sc_hd__clkbuf_2
Xinput264 Tile_X0Y1_N2END[6] VGND VGND VPWR VPWR net347 sky130_fd_sc_hd__clkbuf_2
XFILLER_75_164 VGND VGND VPWR VPWR sky130_fd_sc_hd__decap_3
XTAP_TAPCELL_ROW_46_557 VGND VPWR sky130_fd_sc_hd__tapvpwrvgnd_1
XFILLER_84_85 VGND VGND VPWR VPWR sky130_fd_sc_hd__decap_3
XFILLER_17_90 VGND VGND VPWR VPWR sky130_fd_sc_hd__decap_3
XFILLER_90_178 VGND VGND VPWR VPWR sky130_fd_sc_hd__decap_3
XFILLER_176_206 VGND VGND VPWR VPWR sky130_fd_sc_hd__decap_3
XFILLER_83_6 VGND VGND VPWR VPWR sky130_fd_sc_hd__decap_3
XFILLER_144_103 VGND VGND VPWR VPWR sky130_fd_sc_hd__decap_3
XFILLER_129_155 VGND VGND VPWR VPWR sky130_fd_sc_hd__decap_3
XFILLER_144_147 VGND VGND VPWR VPWR sky130_fd_sc_hd__decap_3
XFILLER_98_212 VGND VGND VPWR VPWR sky130_fd_sc_hd__decap_3
XFILLER_3_190 VGND VGND VPWR VPWR sky130_fd_sc_hd__decap_3
X_1494_ Tile_X0Y1_OpenRAM_bot.Inst_OpenRAM_bot_switch_matrix.WW4BEG0 VGND VGND VPWR
+ VPWR net654 sky130_fd_sc_hd__clkbuf_1
X_0514_ net174 net204 Tile_X0Y1_OpenRAM_bot.Inst_OpenRAM_bot_switch_matrix.J_NS4_BEG12
+ _0094_ Tile_X0Y1_OpenRAM_bot.Inst_OpenRAM_bot_ConfigMem.Inst_frame7_bit4.Q Tile_X0Y1_OpenRAM_bot.Inst_OpenRAM_bot_ConfigMem.Inst_frame7_bit5.Q
+ VGND VGND VPWR VPWR Tile_X0Y1_OpenRAM_bot.Inst_OpenRAM_bot_switch_matrix.S1BEG0
+ sky130_fd_sc_hd__mux4_1
X_0445_ net78 net259 Tile_X0Y0_OpenRAM_top.Inst_OpenRAM_top_ConfigMem.Inst_frame2_bit25.Q
+ VGND VGND VPWR VPWR _0097_ sky130_fd_sc_hd__mux2_1
XFILLER_100_206 VGND VGND VPWR VPWR sky130_fd_sc_hd__fill_2
XFILLER_104_18 VGND VGND VPWR VPWR sky130_fd_sc_hd__decap_3
XTAP_TAPCELL_ROW_69_649 VGND VPWR sky130_fd_sc_hd__tapvpwrvgnd_1
X_0376_ net17 net49 net258 Tile_X0Y0_OpenRAM_top.Inst_OpenRAM_top_switch_matrix.J_NS2_BEG6
+ Tile_X0Y0_OpenRAM_top.Inst_OpenRAM_top_ConfigMem.Inst_frame5_bit8.Q Tile_X0Y0_OpenRAM_top.Inst_OpenRAM_top_ConfigMem.Inst_frame5_bit9.Q
+ VGND VGND VPWR VPWR Tile_X0Y0_OpenRAM_top.Inst_OpenRAM_top_switch_matrix.W2BEG6
+ sky130_fd_sc_hd__mux4_1
XFILLER_104_29 VGND VGND VPWR VPWR sky130_fd_sc_hd__decap_3
XFILLER_81_134 VGND VGND VPWR VPWR sky130_fd_sc_hd__decap_3
XFILLER_120_39 VGND VGND VPWR VPWR sky130_fd_sc_hd__decap_3
XTAP_TAPCELL_ROW_104_786 VGND VPWR sky130_fd_sc_hd__tapvpwrvgnd_1
XFILLER_167_228 VGND VGND VPWR VPWR sky130_fd_sc_hd__fill_2
XFILLER_167_217 VGND VGND VPWR VPWR sky130_fd_sc_hd__decap_3
XFILLER_13_15 VGND VGND VPWR VPWR sky130_fd_sc_hd__decap_3
XFILLER_13_48 VGND VGND VPWR VPWR sky130_fd_sc_hd__decap_3
XFILLER_135_125 VGND VGND VPWR VPWR sky130_fd_sc_hd__decap_3
XFILLER_150_128 VGND VGND VPWR VPWR sky130_fd_sc_hd__decap_3
XFILLER_150_106 VGND VGND VPWR VPWR sky130_fd_sc_hd__decap_3
XFILLER_145_25 VGND VGND VPWR VPWR sky130_fd_sc_hd__fill_2
XFILLER_89_212 VGND VGND VPWR VPWR sky130_fd_sc_hd__decap_3
XFILLER_161_46 VGND VGND VPWR VPWR sky130_fd_sc_hd__decap_3
XFILLER_38_78 VGND VGND VPWR VPWR sky130_fd_sc_hd__decap_3
XFILLER_57_153 VGND VGND VPWR VPWR sky130_fd_sc_hd__fill_1
XFILLER_161_79 VGND VGND VPWR VPWR sky130_fd_sc_hd__decap_3
XFILLER_161_57 VGND VGND VPWR VPWR sky130_fd_sc_hd__decap_3
XTAP_TAPCELL_ROW_127_878 VGND VPWR sky130_fd_sc_hd__tapvpwrvgnd_1
XFILLER_54_11 VGND VGND VPWR VPWR sky130_fd_sc_hd__decap_3
XFILLER_72_123 VGND VGND VPWR VPWR sky130_fd_sc_hd__decap_3
XFILLER_54_44 VGND VGND VPWR VPWR sky130_fd_sc_hd__decap_3
XFILLER_72_156 VGND VGND VPWR VPWR sky130_fd_sc_hd__decap_3
XFILLER_13_223 VGND VGND VPWR VPWR sky130_fd_sc_hd__fill_1
XFILLER_158_206 VGND VGND VPWR VPWR sky130_fd_sc_hd__decap_3
XFILLER_110_50 VGND VGND VPWR VPWR sky130_fd_sc_hd__decap_3
XFILLER_9_205 VGND VGND VPWR VPWR sky130_fd_sc_hd__decap_3
XFILLER_110_94 VGND VGND VPWR VPWR sky130_fd_sc_hd__fill_2
XFILLER_110_83 VGND VGND VPWR VPWR sky130_fd_sc_hd__fill_1
XFILLER_70_21 VGND VGND VPWR VPWR sky130_fd_sc_hd__decap_3
XFILLER_70_65 VGND VGND VPWR VPWR sky130_fd_sc_hd__fill_2
XFILLER_126_125 VGND VGND VPWR VPWR sky130_fd_sc_hd__decap_3
XPHY_EDGE_ROW_39_Left_222 VGND VGND VPWR VPWR sky130_fd_sc_hd__decap_3
XFILLER_119_92 VGND VGND VPWR VPWR sky130_fd_sc_hd__decap_3
XFILLER_79_52 VGND VGND VPWR VPWR sky130_fd_sc_hd__decap_3
XFILLER_141_139 VGND VGND VPWR VPWR sky130_fd_sc_hd__decap_3
X_0230_ Tile_X0Y0_OpenRAM_top.Inst_OpenRAM_top_ConfigMem.Inst_frame0_bit29.Q VGND
+ VGND VPWR VPWR _0003_ sky130_fd_sc_hd__inv_1
XTAP_TAPCELL_ROW_118_845 VGND VPWR sky130_fd_sc_hd__tapvpwrvgnd_1
XFILLER_48_120 VGND VGND VPWR VPWR sky130_fd_sc_hd__decap_3
XFILLER_48_153 VGND VGND VPWR VPWR sky130_fd_sc_hd__decap_3
XFILLER_95_51 VGND VGND VPWR VPWR sky130_fd_sc_hd__decap_3
XTAP_TAPCELL_ROW_163_1023 VGND VPWR sky130_fd_sc_hd__tapvpwrvgnd_1
XPHY_EDGE_ROW_48_Left_231 VGND VGND VPWR VPWR sky130_fd_sc_hd__decap_3
XFILLER_48_186 VGND VGND VPWR VPWR sky130_fd_sc_hd__decap_3
XFILLER_95_95 VGND VGND VPWR VPWR sky130_fd_sc_hd__decap_3
XFILLER_48_197 VGND VGND VPWR VPWR sky130_fd_sc_hd__decap_3
XFILLER_151_90 VGND VGND VPWR VPWR sky130_fd_sc_hd__decap_3
XFILLER_63_178 VGND VGND VPWR VPWR sky130_fd_sc_hd__decap_3
XFILLER_149_228 VGND VGND VPWR VPWR sky130_fd_sc_hd__fill_2
XFILLER_81_3 VGND VGND VPWR VPWR sky130_fd_sc_hd__decap_3
XFILLER_164_209 VGND VGND VPWR VPWR sky130_fd_sc_hd__decap_3
X_0994_ net248 net330 VGND VGND VPWR VPWR Tile_X0Y1_OpenRAM_bot.Inst_OpenRAM_bot_ConfigMem.Inst_frame0_bit4.Q
+ sky130_fd_sc_hd__dlxtp_1
XFILLER_117_125 VGND VGND VPWR VPWR sky130_fd_sc_hd__decap_3
XPHY_EDGE_ROW_57_Left_240 VGND VGND VPWR VPWR sky130_fd_sc_hd__decap_3
Xoutput502 net585 VGND VGND VPWR VPWR Tile_X0Y1_FrameData_O[9] sky130_fd_sc_hd__buf_2
XFILLER_117_158 VGND VGND VPWR VPWR sky130_fd_sc_hd__decap_3
XFILLER_132_128 VGND VGND VPWR VPWR sky130_fd_sc_hd__decap_3
XFILLER_117_169 VGND VGND VPWR VPWR sky130_fd_sc_hd__decap_3
Xoutput535 net618 VGND VGND VPWR VPWR Tile_X0Y1_S4BEG[6] sky130_fd_sc_hd__buf_2
Xoutput513 net596 VGND VGND VPWR VPWR Tile_X0Y1_S2BEG[6] sky130_fd_sc_hd__buf_2
Xoutput524 net607 VGND VGND VPWR VPWR Tile_X0Y1_S4BEG[10] sky130_fd_sc_hd__buf_2
Xoutput557 net640 VGND VGND VPWR VPWR Tile_X0Y1_W2BEGb[6] sky130_fd_sc_hd__buf_2
Xoutput546 net629 VGND VGND VPWR VPWR Tile_X0Y1_W2BEG[3] sky130_fd_sc_hd__buf_2
XFILLER_5_60 VGND VGND VPWR VPWR sky130_fd_sc_hd__decap_3
Xoutput568 net651 VGND VGND VPWR VPWR Tile_X0Y1_W6BEG[7] sky130_fd_sc_hd__buf_2
XFILLER_5_93 VGND VGND VPWR VPWR sky130_fd_sc_hd__decap_3
Xoutput579 net662 VGND VGND VPWR VPWR Tile_X0Y1_WW4BEG[2] sky130_fd_sc_hd__buf_2
XFILLER_115_39 VGND VGND VPWR VPWR sky130_fd_sc_hd__decap_3
X_1477_ Tile_X0Y1_OpenRAM_bot.Inst_OpenRAM_bot_switch_matrix.W2BEGb3 VGND VGND VPWR
+ VPWR net637 sky130_fd_sc_hd__clkbuf_1
XFILLER_86_215 VGND VGND VPWR VPWR sky130_fd_sc_hd__decap_3
X_0428_ net105 net113 net89 Tile_X0Y0_OpenRAM_top.Inst_OpenRAM_top_switch_matrix.J_NS4_BEG1
+ Tile_X0Y0_OpenRAM_top.Inst_OpenRAM_top_ConfigMem.Inst_frame3_bit22.Q Tile_X0Y0_OpenRAM_top.Inst_OpenRAM_top_ConfigMem.Inst_frame3_bit23.Q
+ VGND VGND VPWR VPWR net394 sky130_fd_sc_hd__mux4_2
X_0359_ Tile_X0Y0_OpenRAM_top.Inst_OpenRAM_top_ConfigMem.Inst_frame0_bit24.Q Tile_X0Y0_OpenRAM_top.Inst_OpenRAM_top_ConfigMem.Inst_frame0_bit25.Q
+ net146 VGND VGND VPWR VPWR _0089_ sky130_fd_sc_hd__and3b_1
XFILLER_39_175 VGND VGND VPWR VPWR sky130_fd_sc_hd__decap_3
XFILLER_131_27 VGND VGND VPWR VPWR sky130_fd_sc_hd__decap_3
XFILLER_54_112 VGND VGND VPWR VPWR sky130_fd_sc_hd__decap_3
XTAP_TAPCELL_ROW_65_630 VGND VPWR sky130_fd_sc_hd__tapvpwrvgnd_1
XFILLER_54_156 VGND VGND VPWR VPWR sky130_fd_sc_hd__decap_3
XFILLER_54_189 VGND VGND VPWR VPWR sky130_fd_sc_hd__decap_3
XFILLER_24_47 VGND VGND VPWR VPWR sky130_fd_sc_hd__decap_3
XFILLER_10_215 VGND VGND VPWR VPWR sky130_fd_sc_hd__decap_3
XFILLER_108_103 VGND VGND VPWR VPWR sky130_fd_sc_hd__decap_3
XFILLER_40_35 VGND VGND VPWR VPWR sky130_fd_sc_hd__fill_1
XFILLER_156_35 VGND VGND VPWR VPWR sky130_fd_sc_hd__decap_3
XFILLER_108_147 VGND VGND VPWR VPWR sky130_fd_sc_hd__decap_3
XFILLER_108_136 VGND VGND VPWR VPWR sky130_fd_sc_hd__decap_3
XFILLER_156_68 VGND VGND VPWR VPWR sky130_fd_sc_hd__decap_3
XFILLER_116_191 VGND VGND VPWR VPWR sky130_fd_sc_hd__decap_3
XFILLER_116_180 VGND VGND VPWR VPWR sky130_fd_sc_hd__decap_3
XFILLER_172_12 VGND VGND VPWR VPWR sky130_fd_sc_hd__decap_3
XFILLER_49_22 VGND VGND VPWR VPWR sky130_fd_sc_hd__decap_3
XFILLER_172_56 VGND VGND VPWR VPWR sky130_fd_sc_hd__decap_3
XFILLER_49_66 VGND VGND VPWR VPWR sky130_fd_sc_hd__decap_3
XTAP_TAPCELL_ROW_88_722 VGND VPWR sky130_fd_sc_hd__tapvpwrvgnd_1
XFILLER_1_18 VGND VGND VPWR VPWR sky130_fd_sc_hd__decap_3
XFILLER_49_99 VGND VGND VPWR VPWR sky130_fd_sc_hd__fill_1
XFILLER_105_72 VGND VGND VPWR VPWR sky130_fd_sc_hd__decap_3
XFILLER_65_21 VGND VGND VPWR VPWR sky130_fd_sc_hd__decap_3
XFILLER_92_218 VGND VGND VPWR VPWR sky130_fd_sc_hd__decap_3
XFILLER_65_54 VGND VGND VPWR VPWR sky130_fd_sc_hd__fill_2
XFILLER_65_87 VGND VGND VPWR VPWR sky130_fd_sc_hd__decap_3
XFILLER_121_60 VGND VGND VPWR VPWR sky130_fd_sc_hd__decap_3
XFILLER_60_115 VGND VGND VPWR VPWR sky130_fd_sc_hd__decap_3
XFILLER_60_137 VGND VGND VPWR VPWR sky130_fd_sc_hd__decap_3
XFILLER_60_159 VGND VGND VPWR VPWR sky130_fd_sc_hd__fill_1
XTAP_TAPCELL_ROW_71_655 VGND VPWR sky130_fd_sc_hd__tapvpwrvgnd_1
XFILLER_81_53 VGND VGND VPWR VPWR sky130_fd_sc_hd__decap_3
XFILLER_81_75 VGND VGND VPWR VPWR sky130_fd_sc_hd__fill_2
XFILLER_146_209 VGND VGND VPWR VPWR sky130_fd_sc_hd__decap_3
XFILLER_154_220 VGND VGND VPWR VPWR sky130_fd_sc_hd__decap_3
XFILLER_114_106 VGND VGND VPWR VPWR sky130_fd_sc_hd__decap_3
XFILLER_114_139 VGND VGND VPWR VPWR sky130_fd_sc_hd__fill_1
XFILLER_107_191 VGND VGND VPWR VPWR sky130_fd_sc_hd__decap_3
X_1400_ net250 VGND VGND VPWR VPWR net582 sky130_fd_sc_hd__buf_6
XFILLER_122_150 VGND VGND VPWR VPWR sky130_fd_sc_hd__decap_3
X_1331_ Tile_X0Y1_N4END[10] VGND VGND VPWR VPWR net497 sky130_fd_sc_hd__clkbuf_1
XFILLER_68_215 VGND VGND VPWR VPWR sky130_fd_sc_hd__decap_3
X_1262_ net141 VGND VGND VPWR VPWR net444 sky130_fd_sc_hd__clkbuf_2
Xinput6 DOUT_A_SRAM12 VGND VGND VPWR VPWR net6 sky130_fd_sc_hd__buf_1
XFILLER_83_218 VGND VGND VPWR VPWR sky130_fd_sc_hd__decap_3
XFILLER_36_112 VGND VGND VPWR VPWR sky130_fd_sc_hd__decap_3
X_1193_ net243 net272 VGND VGND VPWR VPWR Tile_X0Y1_OpenRAM_bot.Inst_OpenRAM_bot_ConfigMem.Inst_frame7_bit29.Q
+ sky130_fd_sc_hd__dlxtp_1
XTAP_TAPCELL_ROW_94_747 VGND VPWR sky130_fd_sc_hd__tapvpwrvgnd_1
XFILLER_36_156 VGND VGND VPWR VPWR sky130_fd_sc_hd__decap_3
XFILLER_36_189 VGND VGND VPWR VPWR sky130_fd_sc_hd__decap_3
XFILLER_137_209 VGND VGND VPWR VPWR sky130_fd_sc_hd__fill_2
X_0977_ net235 net332 VGND VGND VPWR VPWR Tile_X0Y1_OpenRAM_bot.Inst_OpenRAM_bot_ConfigMem.Inst_frame0_bit21.Q
+ sky130_fd_sc_hd__dlxtp_1
XFILLER_10_27 VGND VGND VPWR VPWR sky130_fd_sc_hd__fill_1
Xoutput310 net393 VGND VGND VPWR VPWR DIN_A_SRAM16 sky130_fd_sc_hd__buf_2
XFILLER_160_212 VGND VGND VPWR VPWR sky130_fd_sc_hd__decap_3
Xoutput343 net426 VGND VGND VPWR VPWR Tile_X0Y0_FrameData_O[18] sky130_fd_sc_hd__buf_2
Xoutput321 net404 VGND VGND VPWR VPWR DIN_A_SRAM26 sky130_fd_sc_hd__buf_2
XFILLER_10_38 VGND VGND VPWR VPWR sky130_fd_sc_hd__decap_3
Xoutput332 net415 VGND VGND VPWR VPWR DIN_A_SRAM8 sky130_fd_sc_hd__buf_2
Xoutput376 net459 VGND VGND VPWR VPWR Tile_X0Y0_FrameStrobe_O[19] sky130_fd_sc_hd__buf_2
Xoutput387 net470 VGND VGND VPWR VPWR Tile_X0Y0_N1BEG[1] sky130_fd_sc_hd__buf_2
Xoutput354 net437 VGND VGND VPWR VPWR Tile_X0Y0_FrameData_O[28] sky130_fd_sc_hd__buf_2
Xoutput365 net448 VGND VGND VPWR VPWR Tile_X0Y0_FrameData_O[9] sky130_fd_sc_hd__buf_2
XFILLER_126_38 VGND VGND VPWR VPWR sky130_fd_sc_hd__decap_3
Xoutput398 net481 VGND VGND VPWR VPWR Tile_X0Y0_N2BEGb[0] sky130_fd_sc_hd__buf_2
XFILLER_113_172 VGND VGND VPWR VPWR sky130_fd_sc_hd__decap_3
XFILLER_59_215 VGND VGND VPWR VPWR sky130_fd_sc_hd__decap_3
XFILLER_74_218 VGND VGND VPWR VPWR sky130_fd_sc_hd__decap_3
XFILLER_142_59 VGND VGND VPWR VPWR sky130_fd_sc_hd__fill_2
XFILLER_27_134 VGND VGND VPWR VPWR sky130_fd_sc_hd__decap_3
XFILLER_35_24 VGND VGND VPWR VPWR sky130_fd_sc_hd__decap_3
XPHY_EDGE_ROW_182_Right_182 VGND VGND VPWR VPWR sky130_fd_sc_hd__decap_3
XTAP_TAPCELL_ROW_112_818 VGND VPWR sky130_fd_sc_hd__tapvpwrvgnd_1
XFILLER_35_57 VGND VGND VPWR VPWR sky130_fd_sc_hd__decap_3
XFILLER_42_137 VGND VGND VPWR VPWR sky130_fd_sc_hd__decap_3
XTAP_TAPCELL_ROW_120_851 VGND VPWR sky130_fd_sc_hd__tapvpwrvgnd_1
XFILLER_128_209 VGND VGND VPWR VPWR sky130_fd_sc_hd__decap_3
XPHY_EDGE_ROW_14_Right_14 VGND VGND VPWR VPWR sky130_fd_sc_hd__decap_3
XFILLER_167_45 VGND VGND VPWR VPWR sky130_fd_sc_hd__decap_3
XFILLER_129_3 VGND VGND VPWR VPWR sky130_fd_sc_hd__fill_2
XFILLER_51_78 VGND VGND VPWR VPWR sky130_fd_sc_hd__decap_3
XFILLER_167_78 VGND VGND VPWR VPWR sky130_fd_sc_hd__decap_3
XFILLER_151_212 VGND VGND VPWR VPWR sky130_fd_sc_hd__decap_3
XFILLER_2_200 VGND VGND VPWR VPWR sky130_fd_sc_hd__decap_3
XFILLER_104_172 VGND VGND VPWR VPWR sky130_fd_sc_hd__decap_3
XPHY_EDGE_ROW_23_Right_23 VGND VGND VPWR VPWR sky130_fd_sc_hd__decap_3
XFILLER_116_71 VGND VGND VPWR VPWR sky130_fd_sc_hd__decap_3
XFILLER_76_53 VGND VGND VPWR VPWR sky130_fd_sc_hd__decap_3
XFILLER_18_123 VGND VGND VPWR VPWR sky130_fd_sc_hd__decap_3
XFILLER_76_97 VGND VGND VPWR VPWR sky130_fd_sc_hd__decap_3
XTAP_TAPCELL_ROW_143_943 VGND VPWR sky130_fd_sc_hd__tapvpwrvgnd_1
XFILLER_132_81 VGND VGND VPWR VPWR sky130_fd_sc_hd__decap_3
XFILLER_18_189 VGND VGND VPWR VPWR sky130_fd_sc_hd__decap_3
XFILLER_92_41 VGND VGND VPWR VPWR sky130_fd_sc_hd__decap_3
XFILLER_178_109 VGND VGND VPWR VPWR sky130_fd_sc_hd__decap_3
XPHY_EDGE_ROW_32_Right_32 VGND VGND VPWR VPWR sky130_fd_sc_hd__decap_3
XFILLER_33_137 VGND VGND VPWR VPWR sky130_fd_sc_hd__decap_3
XFILLER_92_85 VGND VGND VPWR VPWR sky130_fd_sc_hd__decap_3
X_0900_ net119 net282 VGND VGND VPWR VPWR Tile_X0Y0_OpenRAM_top.Inst_OpenRAM_top_ConfigMem.Inst_frame6_bit14.Q
+ sky130_fd_sc_hd__dlxtp_1
XFILLER_41_181 VGND VGND VPWR VPWR sky130_fd_sc_hd__decap_3
X_0831_ net124 net303 VGND VGND VPWR VPWR Tile_X0Y0_OpenRAM_top.Inst_OpenRAM_top_ConfigMem.Inst_frame4_bit19.Q
+ sky130_fd_sc_hd__dlxtp_1
X_0762_ net130 net321 VGND VGND VPWR VPWR Tile_X0Y0_OpenRAM_top.Inst_OpenRAM_top_ConfigMem.Inst_frame2_bit24.Q
+ sky130_fd_sc_hd__dlxtp_1
X_0693_ net135 net335 VGND VGND VPWR VPWR Tile_X0Y0_OpenRAM_top.Inst_OpenRAM_top_ConfigMem.Inst_frame0_bit29.Q
+ sky130_fd_sc_hd__dlxtp_1
XPHY_EDGE_ROW_41_Right_41 VGND VGND VPWR VPWR sky130_fd_sc_hd__decap_3
XFILLER_44_3 VGND VGND VPWR VPWR sky130_fd_sc_hd__fill_1
X_1314_ Tile_X0Y0_OpenRAM_top.Inst_OpenRAM_top_switch_matrix.N2BEG1 VGND VGND VPWR
+ VPWR net474 sky130_fd_sc_hd__clkbuf_2
XFILLER_110_120 VGND VGND VPWR VPWR sky130_fd_sc_hd__decap_3
XFILLER_2_61 VGND VGND VPWR VPWR sky130_fd_sc_hd__decap_3
XFILLER_56_229 VGND VGND VPWR VPWR sky130_fd_sc_hd__fill_1
XFILLER_2_94 VGND VGND VPWR VPWR sky130_fd_sc_hd__decap_3
X_1245_ net253 net265 VGND VGND VPWR VPWR Tile_X0Y1_OpenRAM_bot.Inst_OpenRAM_bot_ConfigMem.Inst_frame8_bit9.Q
+ sky130_fd_sc_hd__dlxtp_1
XFILLER_112_29 VGND VGND VPWR VPWR sky130_fd_sc_hd__decap_3
X_1176_ net227 net278 VGND VGND VPWR VPWR Tile_X0Y1_OpenRAM_bot.Inst_OpenRAM_bot_ConfigMem.Inst_frame6_bit14.Q
+ sky130_fd_sc_hd__dlxtp_1
XFILLER_24_126 VGND VGND VPWR VPWR sky130_fd_sc_hd__decap_3
XPHY_EDGE_ROW_50_Right_50 VGND VGND VPWR VPWR sky130_fd_sc_hd__decap_3
XFILLER_24_159 VGND VGND VPWR VPWR sky130_fd_sc_hd__fill_2
XFILLER_177_131 VGND VGND VPWR VPWR sky130_fd_sc_hd__decap_3
XFILLER_32_192 VGND VGND VPWR VPWR sky130_fd_sc_hd__decap_3
XFILLER_177_175 VGND VGND VPWR VPWR sky130_fd_sc_hd__decap_3
XFILLER_177_164 VGND VGND VPWR VPWR sky130_fd_sc_hd__decap_3
XTAP_TAPCELL_ROW_176_1077 VGND VPWR sky130_fd_sc_hd__tapvpwrvgnd_1
XFILLER_21_48 VGND VGND VPWR VPWR sky130_fd_sc_hd__decap_3
XFILLER_137_48 VGND VGND VPWR VPWR sky130_fd_sc_hd__decap_3
XFILLER_99_181 VGND VGND VPWR VPWR sky130_fd_sc_hd__decap_3
XFILLER_153_47 VGND VGND VPWR VPWR sky130_fd_sc_hd__decap_3
XFILLER_101_120 VGND VGND VPWR VPWR sky130_fd_sc_hd__decap_3
XFILLER_47_229 VGND VGND VPWR VPWR sky130_fd_sc_hd__fill_1
XFILLER_15_137 VGND VGND VPWR VPWR sky130_fd_sc_hd__decap_3
XFILLER_62_44 VGND VGND VPWR VPWR sky130_fd_sc_hd__decap_3
XFILLER_178_44 VGND VGND VPWR VPWR sky130_fd_sc_hd__decap_3
XFILLER_62_88 VGND VGND VPWR VPWR sky130_fd_sc_hd__decap_3
XFILLER_178_88 VGND VGND VPWR VPWR sky130_fd_sc_hd__decap_3
XFILLER_178_77 VGND VGND VPWR VPWR sky130_fd_sc_hd__decap_3
XFILLER_168_164 VGND VGND VPWR VPWR sky130_fd_sc_hd__decap_3
XFILLER_168_197 VGND VGND VPWR VPWR sky130_fd_sc_hd__decap_3
XFILLER_7_39 VGND VGND VPWR VPWR sky130_fd_sc_hd__decap_3
XFILLER_124_212 VGND VGND VPWR VPWR sky130_fd_sc_hd__fill_1
XPHY_EDGE_ROW_12_Left_195 VGND VGND VPWR VPWR sky130_fd_sc_hd__decap_3
XFILLER_11_81 VGND VGND VPWR VPWR sky130_fd_sc_hd__decap_3
XFILLER_87_30 VGND VGND VPWR VPWR sky130_fd_sc_hd__decap_3
XFILLER_87_63 VGND VGND VPWR VPWR sky130_fd_sc_hd__decap_3
XFILLER_38_207 VGND VGND VPWR VPWR sky130_fd_sc_hd__decap_3
XFILLER_16_7 VGND VGND VPWR VPWR sky130_fd_sc_hd__decap_3
X_1030_ net222 net325 VGND VGND VPWR VPWR Tile_X0Y1_OpenRAM_bot.Inst_OpenRAM_bot_ConfigMem.Inst_frame1_bit0.Q
+ sky130_fd_sc_hd__dlxtp_1
XFILLER_159_131 VGND VGND VPWR VPWR sky130_fd_sc_hd__decap_3
XFILLER_14_192 VGND VGND VPWR VPWR sky130_fd_sc_hd__decap_3
XFILLER_174_112 VGND VGND VPWR VPWR sky130_fd_sc_hd__decap_3
XFILLER_159_175 VGND VGND VPWR VPWR sky130_fd_sc_hd__fill_2
XFILLER_159_164 VGND VGND VPWR VPWR sky130_fd_sc_hd__decap_3
X_0814_ net140 net308 VGND VGND VPWR VPWR Tile_X0Y0_OpenRAM_top.Inst_OpenRAM_top_ConfigMem.Inst_frame3_bit4.Q
+ sky130_fd_sc_hd__dlxtp_1
Xinput31 DOUT_A_SRAM7 VGND VGND VPWR VPWR net31 sky130_fd_sc_hd__dlymetal6s2s_1
Xinput20 DOUT_A_SRAM25 VGND VGND VPWR VPWR net20 sky130_fd_sc_hd__buf_2
XFILLER_174_156 VGND VGND VPWR VPWR sky130_fd_sc_hd__decap_3
Xinput64 DOUT_B_SRAM8 VGND VGND VPWR VPWR net64 sky130_fd_sc_hd__buf_1
Xinput42 DOUT_B_SRAM16 VGND VGND VPWR VPWR net42 sky130_fd_sc_hd__clkbuf_2
Xinput53 DOUT_B_SRAM26 VGND VGND VPWR VPWR net53 sky130_fd_sc_hd__buf_1
XFILLER_174_189 VGND VGND VPWR VPWR sky130_fd_sc_hd__decap_3
X_0745_ net145 net327 VGND VGND VPWR VPWR Tile_X0Y0_OpenRAM_top.Inst_OpenRAM_top_ConfigMem.Inst_frame1_bit9.Q
+ sky130_fd_sc_hd__dlxtp_1
Xinput97 Tile_X0Y0_E6END[9] VGND VGND VPWR VPWR net97 sky130_fd_sc_hd__buf_1
Xinput86 Tile_X0Y0_E6END[0] VGND VGND VPWR VPWR net86 sky130_fd_sc_hd__clkbuf_2
Xinput75 Tile_X0Y0_E2END[5] VGND VGND VPWR VPWR net75 sky130_fd_sc_hd__buf_1
X_0676_ Tile_X0Y1_OpenRAM_bot.Inst_OpenRAM_bot_ConfigMem.Inst_frame3_bit14.Q Tile_X0Y0_OpenRAM_top.Inst_OpenRAM_top_switch_matrix.S2BEG0
+ Tile_X0Y1_OpenRAM_bot.Inst_OpenRAM_bot_ConfigMem.Inst_frame3_bit13.Q VGND VGND VPWR
+ VPWR _0213_ sky130_fd_sc_hd__or3b_1
XFILLER_88_129 VGND VGND VPWR VPWR sky130_fd_sc_hd__fill_2
XFILLER_96_162 VGND VGND VPWR VPWR sky130_fd_sc_hd__fill_1
XFILLER_29_218 VGND VGND VPWR VPWR sky130_fd_sc_hd__decap_3
XFILLER_96_184 VGND VGND VPWR VPWR sky130_fd_sc_hd__decap_3
X_1228_ net240 net264 VGND VGND VPWR VPWR Tile_X0Y1_OpenRAM_bot.Inst_OpenRAM_bot_ConfigMem.Inst_frame8_bit26.Q
+ sky130_fd_sc_hd__dlxtp_1
XFILLER_16_26 VGND VGND VPWR VPWR sky130_fd_sc_hd__fill_2
XFILLER_16_59 VGND VGND VPWR VPWR sky130_fd_sc_hd__decap_3
X_1159_ net246 net281 VGND VGND VPWR VPWR Tile_X0Y1_OpenRAM_bot.Inst_OpenRAM_bot_ConfigMem.Inst_frame6_bit31.Q
+ sky130_fd_sc_hd__dlxtp_1
XFILLER_165_101 VGND VGND VPWR VPWR sky130_fd_sc_hd__decap_3
XFILLER_165_134 VGND VGND VPWR VPWR sky130_fd_sc_hd__decap_3
XFILLER_148_47 VGND VGND VPWR VPWR sky130_fd_sc_hd__decap_3
XFILLER_20_162 VGND VGND VPWR VPWR sky130_fd_sc_hd__decap_3
XFILLER_165_178 VGND VGND VPWR VPWR sky130_fd_sc_hd__decap_3
XFILLER_165_167 VGND VGND VPWR VPWR sky130_fd_sc_hd__fill_1
XFILLER_20_195 VGND VGND VPWR VPWR sky130_fd_sc_hd__fill_1
XFILLER_164_24 VGND VGND VPWR VPWR sky130_fd_sc_hd__decap_3
XFILLER_164_35 VGND VGND VPWR VPWR sky130_fd_sc_hd__fill_2
XFILLER_180_12 VGND VGND VPWR VPWR sky130_fd_sc_hd__decap_3
XFILLER_57_22 VGND VGND VPWR VPWR sky130_fd_sc_hd__decap_3
XFILLER_87_151 VGND VGND VPWR VPWR sky130_fd_sc_hd__decap_3
XFILLER_57_55 VGND VGND VPWR VPWR sky130_fd_sc_hd__fill_1
XFILLER_113_72 VGND VGND VPWR VPWR sky130_fd_sc_hd__fill_1
XTAP_TAPCELL_ROW_3_383 VGND VPWR sky130_fd_sc_hd__tapvpwrvgnd_1
XFILLER_43_221 VGND VGND VPWR VPWR sky130_fd_sc_hd__decap_3
XTAP_TAPCELL_ROW_26_474 VGND VPWR sky130_fd_sc_hd__tapvpwrvgnd_1
XFILLER_11_140 VGND VGND VPWR VPWR sky130_fd_sc_hd__decap_3
XFILLER_156_112 VGND VGND VPWR VPWR sky130_fd_sc_hd__decap_3
XFILLER_7_122 VGND VGND VPWR VPWR sky130_fd_sc_hd__decap_3
XFILLER_7_111 VGND VGND VPWR VPWR sky130_fd_sc_hd__fill_1
XFILLER_78_9 VGND VGND VPWR VPWR sky130_fd_sc_hd__decap_3
XFILLER_156_156 VGND VGND VPWR VPWR sky130_fd_sc_hd__fill_1
XPHY_EDGE_ROW_20_Left_203 VGND VGND VPWR VPWR sky130_fd_sc_hd__decap_3
XFILLER_7_155 VGND VGND VPWR VPWR sky130_fd_sc_hd__decap_3
XFILLER_171_137 VGND VGND VPWR VPWR sky130_fd_sc_hd__decap_3
XFILLER_7_199 VGND VGND VPWR VPWR sky130_fd_sc_hd__decap_3
XFILLER_22_91 VGND VGND VPWR VPWR sky130_fd_sc_hd__decap_3
XFILLER_138_91 VGND VGND VPWR VPWR sky130_fd_sc_hd__decap_3
X_0530_ net2 net34 net263 _0087_ Tile_X0Y1_OpenRAM_bot.Inst_OpenRAM_bot_ConfigMem.Inst_frame6_bit16.Q
+ Tile_X0Y1_OpenRAM_bot.Inst_OpenRAM_bot_ConfigMem.Inst_frame6_bit17.Q VGND VGND VPWR
+ VPWR Tile_X0Y1_OpenRAM_bot.Inst_OpenRAM_bot_switch_matrix.W2BEG0 sky130_fd_sc_hd__mux4_1
XFILLER_98_73 VGND VGND VPWR VPWR sky130_fd_sc_hd__fill_1
X_0461_ net71 Tile_X0Y0_OpenRAM_top.Inst_OpenRAM_top_ConfigMem.Inst_frame1_bit2.Q
+ VGND VGND VPWR VPWR _0108_ sky130_fd_sc_hd__nand2_1
X_0392_ net15 net47 Tile_X0Y0_OpenRAM_top.Inst_OpenRAM_top_switch_matrix.J_NS4_BEG11
+ net256 Tile_X0Y0_OpenRAM_top.Inst_OpenRAM_top_ConfigMem.Inst_frame4_bit4.Q Tile_X0Y0_OpenRAM_top.Inst_OpenRAM_top_ConfigMem.Inst_frame4_bit5.Q
+ VGND VGND VPWR VPWR Tile_X0Y0_OpenRAM_top.Inst_OpenRAM_top_switch_matrix.WW4BEG4
+ sky130_fd_sc_hd__mux4_1
XFILLER_78_195 VGND VGND VPWR VPWR sky130_fd_sc_hd__fill_1
XFILLER_93_110 VGND VGND VPWR VPWR sky130_fd_sc_hd__fill_2
XTAP_TAPCELL_ROW_49_566 VGND VPWR sky130_fd_sc_hd__tapvpwrvgnd_1
XFILLER_93_143 VGND VGND VPWR VPWR sky130_fd_sc_hd__decap_3
X_1013_ net230 net323 VGND VGND VPWR VPWR Tile_X0Y1_OpenRAM_bot.Inst_OpenRAM_bot_ConfigMem.Inst_frame1_bit17.Q
+ sky130_fd_sc_hd__dlxtp_1
XFILLER_93_165 VGND VGND VPWR VPWR sky130_fd_sc_hd__decap_3
XFILLER_34_232 VGND VGND VPWR VPWR sky130_fd_sc_hd__fill_2
XFILLER_179_215 VGND VGND VPWR VPWR sky130_fd_sc_hd__decap_3
XTAP_TAPCELL_ROW_17_441 VGND VPWR sky130_fd_sc_hd__tapvpwrvgnd_1
XTAP_TAPCELL_ROW_32_499 VGND VPWR sky130_fd_sc_hd__tapvpwrvgnd_1
XFILLER_162_104 VGND VGND VPWR VPWR sky130_fd_sc_hd__decap_3
XFILLER_147_167 VGND VGND VPWR VPWR sky130_fd_sc_hd__fill_1
XFILLER_8_71 VGND VGND VPWR VPWR sky130_fd_sc_hd__decap_3
X_0728_ net132 net327 VGND VGND VPWR VPWR Tile_X0Y0_OpenRAM_top.Inst_OpenRAM_top_ConfigMem.Inst_frame1_bit26.Q
+ sky130_fd_sc_hd__dlxtp_1
XTAP_TAPCELL_ROW_9_409 VGND VPWR sky130_fd_sc_hd__tapvpwrvgnd_1
XPHY_EDGE_ROW_4_Right_4 VGND VGND VPWR VPWR sky130_fd_sc_hd__decap_3
XFILLER_170_192 VGND VGND VPWR VPWR sky130_fd_sc_hd__decap_3
X_0659_ Tile_X0Y1_OpenRAM_bot.Inst_OpenRAM_bot_ConfigMem.Inst_frame6_bit0.Q _0198_
+ VGND VGND VPWR VPWR _0199_ sky130_fd_sc_hd__and2b_1
XFILLER_134_38 VGND VGND VPWR VPWR sky130_fd_sc_hd__decap_3
XFILLER_69_140 VGND VGND VPWR VPWR sky130_fd_sc_hd__decap_3
XFILLER_69_184 VGND VGND VPWR VPWR sky130_fd_sc_hd__decap_3
XFILLER_84_121 VGND VGND VPWR VPWR sky130_fd_sc_hd__decap_3
XFILLER_182_9 VGND VGND VPWR VPWR sky130_fd_sc_hd__decap_3
XFILLER_150_26 VGND VGND VPWR VPWR sky130_fd_sc_hd__fill_2
XFILLER_27_69 VGND VGND VPWR VPWR sky130_fd_sc_hd__decap_3
XFILLER_84_165 VGND VGND VPWR VPWR sky130_fd_sc_hd__decap_3
XFILLER_150_59 VGND VGND VPWR VPWR sky130_fd_sc_hd__decap_3
XFILLER_159_57 VGND VGND VPWR VPWR sky130_fd_sc_hd__decap_3
XFILLER_43_57 VGND VGND VPWR VPWR sky130_fd_sc_hd__decap_3
XFILLER_138_134 VGND VGND VPWR VPWR sky130_fd_sc_hd__decap_3
XFILLER_138_156 VGND VGND VPWR VPWR sky130_fd_sc_hd__decap_3
XFILLER_175_12 VGND VGND VPWR VPWR sky130_fd_sc_hd__decap_3
XFILLER_138_189 VGND VGND VPWR VPWR sky130_fd_sc_hd__decap_3
XFILLER_4_103 VGND VGND VPWR VPWR sky130_fd_sc_hd__decap_3
XFILLER_175_45 VGND VGND VPWR VPWR sky130_fd_sc_hd__decap_3
XFILLER_153_148 VGND VGND VPWR VPWR sky130_fd_sc_hd__decap_3
XFILLER_4_136 VGND VGND VPWR VPWR sky130_fd_sc_hd__decap_3
XFILLER_4_147 VGND VGND VPWR VPWR sky130_fd_sc_hd__decap_3
XFILLER_175_78 VGND VGND VPWR VPWR sky130_fd_sc_hd__decap_3
XFILLER_108_50 VGND VGND VPWR VPWR sky130_fd_sc_hd__fill_1
XFILLER_4_18 VGND VGND VPWR VPWR sky130_fd_sc_hd__decap_3
XFILLER_4_29 VGND VGND VPWR VPWR sky130_fd_sc_hd__decap_3
XFILLER_161_181 VGND VGND VPWR VPWR sky130_fd_sc_hd__decap_3
XFILLER_108_94 VGND VGND VPWR VPWR sky130_fd_sc_hd__decap_3
Xinput210 Tile_X0Y1_EE4END[13] VGND VGND VPWR VPWR net210 sky130_fd_sc_hd__dlymetal6s2s_1
Xinput254 Tile_X0Y1_N1END[0] VGND VGND VPWR VPWR net254 sky130_fd_sc_hd__buf_2
Xinput221 Tile_X0Y1_EE4END[9] VGND VGND VPWR VPWR net221 sky130_fd_sc_hd__dlymetal6s2s_1
Xinput232 Tile_X0Y1_FrameData[19] VGND VGND VPWR VPWR net232 sky130_fd_sc_hd__clkbuf_4
Xinput243 Tile_X0Y1_FrameData[29] VGND VGND VPWR VPWR net243 sky130_fd_sc_hd__buf_4
XFILLER_124_71 VGND VGND VPWR VPWR sky130_fd_sc_hd__decap_3
Xinput276 Tile_X0Y1_N4END[2] VGND VGND VPWR VPWR net359 sky130_fd_sc_hd__clkbuf_2
Xinput265 Tile_X0Y1_N2END[7] VGND VGND VPWR VPWR net348 sky130_fd_sc_hd__clkbuf_2
XFILLER_75_143 VGND VGND VPWR VPWR sky130_fd_sc_hd__decap_3
XFILLER_75_187 VGND VGND VPWR VPWR sky130_fd_sc_hd__decap_3
XFILLER_16_221 VGND VGND VPWR VPWR sky130_fd_sc_hd__decap_3
XFILLER_84_97 VGND VGND VPWR VPWR sky130_fd_sc_hd__decap_3
XFILLER_90_124 VGND VGND VPWR VPWR sky130_fd_sc_hd__decap_3
XFILLER_90_157 VGND VGND VPWR VPWR sky130_fd_sc_hd__decap_3
XFILLER_31_202 VGND VGND VPWR VPWR sky130_fd_sc_hd__fill_1
XFILLER_176_218 VGND VGND VPWR VPWR sky130_fd_sc_hd__decap_3
XFILLER_129_134 VGND VGND VPWR VPWR sky130_fd_sc_hd__decap_3
XFILLER_129_167 VGND VGND VPWR VPWR sky130_fd_sc_hd__fill_1
XFILLER_33_90 VGND VGND VPWR VPWR sky130_fd_sc_hd__decap_3
XFILLER_76_6 VGND VGND VPWR VPWR sky130_fd_sc_hd__decap_3
XFILLER_149_90 VGND VGND VPWR VPWR sky130_fd_sc_hd__decap_3
XFILLER_144_126 VGND VGND VPWR VPWR sky130_fd_sc_hd__decap_3
XFILLER_144_159 VGND VGND VPWR VPWR sky130_fd_sc_hd__decap_3
X_0513_ net66 Tile_X0Y0_OpenRAM_top.Inst_OpenRAM_top_switch_matrix.J_NS4_BEG12 net92
+ _0090_ Tile_X0Y0_OpenRAM_top.Inst_OpenRAM_top_ConfigMem.Inst_frame8_bit13.Q Tile_X0Y0_OpenRAM_top.Inst_OpenRAM_top_ConfigMem.Inst_frame8_bit12.Q
+ VGND VGND VPWR VPWR Tile_X0Y0_OpenRAM_top.Inst_OpenRAM_top_switch_matrix.N1BEG0
+ sky130_fd_sc_hd__mux4_1
XFILLER_98_224 VGND VGND VPWR VPWR sky130_fd_sc_hd__decap_3
X_1493_ Tile_X0Y1_OpenRAM_bot.Inst_OpenRAM_bot_switch_matrix.W6BEG11 VGND VGND VPWR
+ VPWR net644 sky130_fd_sc_hd__buf_1
X_0444_ net105 net113 net89 Tile_X0Y0_OpenRAM_top.Inst_OpenRAM_top_switch_matrix.J_NS4_BEG1
+ Tile_X0Y0_OpenRAM_top.Inst_OpenRAM_top_ConfigMem.Inst_frame2_bit22.Q Tile_X0Y0_OpenRAM_top.Inst_OpenRAM_top_ConfigMem.Inst_frame2_bit23.Q
+ VGND VGND VPWR VPWR net674 sky130_fd_sc_hd__mux4_2
XFILLER_100_229 VGND VGND VPWR VPWR sky130_fd_sc_hd__fill_1
X_0375_ net16 net48 net257 Tile_X0Y0_OpenRAM_top.Inst_OpenRAM_top_switch_matrix.J_NS2_BEG5
+ Tile_X0Y0_OpenRAM_top.Inst_OpenRAM_top_ConfigMem.Inst_frame5_bit6.Q Tile_X0Y0_OpenRAM_top.Inst_OpenRAM_top_ConfigMem.Inst_frame5_bit7.Q
+ VGND VGND VPWR VPWR Tile_X0Y0_OpenRAM_top.Inst_OpenRAM_top_switch_matrix.W2BEG5
+ sky130_fd_sc_hd__mux4_1
XFILLER_81_102 VGND VGND VPWR VPWR sky130_fd_sc_hd__decap_3
XFILLER_81_146 VGND VGND VPWR VPWR sky130_fd_sc_hd__decap_3
XFILLER_120_29 VGND VGND VPWR VPWR sky130_fd_sc_hd__decap_3
XTAP_TAPCELL_ROW_104_787 VGND VPWR sky130_fd_sc_hd__tapvpwrvgnd_1
XFILLER_13_27 VGND VGND VPWR VPWR sky130_fd_sc_hd__decap_3
XFILLER_129_27 VGND VGND VPWR VPWR sky130_fd_sc_hd__decap_3
XFILLER_135_104 VGND VGND VPWR VPWR sky130_fd_sc_hd__decap_3
XFILLER_135_159 VGND VGND VPWR VPWR sky130_fd_sc_hd__decap_3
XFILLER_135_137 VGND VGND VPWR VPWR sky130_fd_sc_hd__fill_1
XFILLER_145_48 VGND VGND VPWR VPWR sky130_fd_sc_hd__decap_3
XFILLER_143_181 VGND VGND VPWR VPWR sky130_fd_sc_hd__fill_1
XFILLER_8_9 VGND VGND VPWR VPWR sky130_fd_sc_hd__decap_3
XFILLER_1_128 VGND VGND VPWR VPWR sky130_fd_sc_hd__decap_3
XFILLER_180_6 VGND VGND VPWR VPWR sky130_fd_sc_hd__decap_3
XTAP_TAPCELL_ROW_127_879 VGND VPWR sky130_fd_sc_hd__tapvpwrvgnd_1
XFILLER_57_187 VGND VGND VPWR VPWR sky130_fd_sc_hd__decap_3
XFILLER_72_102 VGND VGND VPWR VPWR sky130_fd_sc_hd__decap_3
XPHY_EDGE_ROW_79_Right_79 VGND VGND VPWR VPWR sky130_fd_sc_hd__decap_3
XFILLER_54_23 VGND VGND VPWR VPWR sky130_fd_sc_hd__decap_3
XFILLER_72_135 VGND VGND VPWR VPWR sky130_fd_sc_hd__decap_3
XFILLER_54_56 VGND VGND VPWR VPWR sky130_fd_sc_hd__decap_3
XFILLER_72_168 VGND VGND VPWR VPWR sky130_fd_sc_hd__decap_3
XFILLER_13_202 VGND VGND VPWR VPWR sky130_fd_sc_hd__decap_3
XTAP_TAPCELL_ROW_11_414 VGND VPWR sky130_fd_sc_hd__tapvpwrvgnd_1
XFILLER_9_228 VGND VGND VPWR VPWR sky130_fd_sc_hd__decap_3
XFILLER_9_217 VGND VGND VPWR VPWR sky130_fd_sc_hd__decap_3
XFILLER_70_88 VGND VGND VPWR VPWR sky130_fd_sc_hd__fill_2
XPHY_EDGE_ROW_88_Right_88 VGND VGND VPWR VPWR sky130_fd_sc_hd__decap_3
XFILLER_119_60 VGND VGND VPWR VPWR sky130_fd_sc_hd__decap_3
XFILLER_134_181 VGND VGND VPWR VPWR sky130_fd_sc_hd__decap_3
XFILLER_79_75 VGND VGND VPWR VPWR sky130_fd_sc_hd__decap_3
XFILLER_135_92 VGND VGND VPWR VPWR sky130_fd_sc_hd__decap_3
XFILLER_135_81 VGND VGND VPWR VPWR sky130_fd_sc_hd__fill_2
XPHY_EDGE_ROW_97_Right_97 VGND VGND VPWR VPWR sky130_fd_sc_hd__decap_3
XFILLER_48_132 VGND VGND VPWR VPWR sky130_fd_sc_hd__decap_3
XFILLER_95_63 VGND VGND VPWR VPWR sky130_fd_sc_hd__fill_2
XTAP_TAPCELL_ROW_163_1024 VGND VPWR sky130_fd_sc_hd__tapvpwrvgnd_1
XFILLER_48_165 VGND VGND VPWR VPWR sky130_fd_sc_hd__decap_3
XFILLER_63_113 VGND VGND VPWR VPWR sky130_fd_sc_hd__fill_1
XFILLER_63_124 VGND VGND VPWR VPWR sky130_fd_sc_hd__decap_3
XTAP_TAPCELL_ROW_34_506 VGND VPWR sky130_fd_sc_hd__tapvpwrvgnd_1
XFILLER_63_157 VGND VGND VPWR VPWR sky130_fd_sc_hd__decap_3
XFILLER_149_218 VGND VGND VPWR VPWR sky130_fd_sc_hd__decap_3
X_0993_ net249 net330 VGND VGND VPWR VPWR Tile_X0Y1_OpenRAM_bot.Inst_OpenRAM_bot_ConfigMem.Inst_frame0_bit5.Q
+ sky130_fd_sc_hd__dlxtp_1
XPHY_EDGE_ROW_4_Left_187 VGND VGND VPWR VPWR sky130_fd_sc_hd__decap_3
XFILLER_117_104 VGND VGND VPWR VPWR sky130_fd_sc_hd__decap_3
XFILLER_172_221 VGND VGND VPWR VPWR sky130_fd_sc_hd__decap_3
XFILLER_117_137 VGND VGND VPWR VPWR sky130_fd_sc_hd__decap_3
Xoutput536 net619 VGND VGND VPWR VPWR Tile_X0Y1_S4BEG[7] sky130_fd_sc_hd__buf_2
Xoutput514 net597 VGND VGND VPWR VPWR Tile_X0Y1_S2BEG[7] sky130_fd_sc_hd__buf_2
Xoutput503 net586 VGND VGND VPWR VPWR Tile_X0Y1_S1BEG[0] sky130_fd_sc_hd__buf_2
Xoutput525 net608 VGND VGND VPWR VPWR Tile_X0Y1_S4BEG[11] sky130_fd_sc_hd__buf_2
XFILLER_125_181 VGND VGND VPWR VPWR sky130_fd_sc_hd__decap_3
Xoutput558 net641 VGND VGND VPWR VPWR Tile_X0Y1_W2BEGb[7] sky130_fd_sc_hd__buf_2
Xoutput547 net630 VGND VGND VPWR VPWR Tile_X0Y1_W2BEG[4] sky130_fd_sc_hd__buf_2
XFILLER_5_72 VGND VGND VPWR VPWR sky130_fd_sc_hd__decap_3
Xoutput569 net652 VGND VGND VPWR VPWR Tile_X0Y1_W6BEG[8] sky130_fd_sc_hd__buf_2
XPHY_EDGE_ROW_163_Right_163 VGND VGND VPWR VPWR sky130_fd_sc_hd__decap_3
XFILLER_140_184 VGND VGND VPWR VPWR sky130_fd_sc_hd__decap_3
XFILLER_140_162 VGND VGND VPWR VPWR sky130_fd_sc_hd__fill_1
X_1476_ Tile_X0Y1_OpenRAM_bot.Inst_OpenRAM_bot_switch_matrix.W2BEGb2 VGND VGND VPWR
+ VPWR net636 sky130_fd_sc_hd__clkbuf_2
XFILLER_86_227 VGND VGND VPWR VPWR sky130_fd_sc_hd__decap_3
X_0427_ net98 net112 net86 Tile_X0Y0_OpenRAM_top.Inst_OpenRAM_top_switch_matrix.J_NS4_BEG0
+ Tile_X0Y0_OpenRAM_top.Inst_OpenRAM_top_ConfigMem.Inst_frame3_bit20.Q Tile_X0Y0_OpenRAM_top.Inst_OpenRAM_top_ConfigMem.Inst_frame3_bit21.Q
+ VGND VGND VPWR VPWR net393 sky130_fd_sc_hd__mux4_2
X_0358_ Tile_X0Y0_OpenRAM_top.Inst_OpenRAM_top_switch_matrix.N1END0 net86 Tile_X0Y0_OpenRAM_top.Inst_OpenRAM_top_ConfigMem.Inst_frame0_bit24.Q
+ VGND VGND VPWR VPWR _0088_ sky130_fd_sc_hd__mux2_1
XFILLER_39_154 VGND VGND VPWR VPWR sky130_fd_sc_hd__fill_2
XFILLER_54_124 VGND VGND VPWR VPWR sky130_fd_sc_hd__decap_3
XTAP_TAPCELL_ROW_65_631 VGND VPWR sky130_fd_sc_hd__tapvpwrvgnd_1
XFILLER_54_168 VGND VGND VPWR VPWR sky130_fd_sc_hd__decap_3
X_0289_ Tile_X0Y1_OpenRAM_bot.Inst_OpenRAM_bot_ConfigMem.Inst_frame2_bit30.Q _0054_
+ _0057_ VGND VGND VPWR VPWR _0058_ sky130_fd_sc_hd__a21oi_1
XFILLER_24_15 VGND VGND VPWR VPWR sky130_fd_sc_hd__decap_3
XTAP_TAPCELL_ROW_179_1086 VGND VPWR sky130_fd_sc_hd__tapvpwrvgnd_1
XFILLER_10_227 VGND VGND VPWR VPWR sky130_fd_sc_hd__decap_3
XFILLER_108_115 VGND VGND VPWR VPWR sky130_fd_sc_hd__decap_3
XFILLER_6_209 VGND VGND VPWR VPWR sky130_fd_sc_hd__decap_3
XFILLER_40_25 VGND VGND VPWR VPWR sky130_fd_sc_hd__decap_3
XFILLER_40_69 VGND VGND VPWR VPWR sky130_fd_sc_hd__decap_3
XFILLER_156_47 VGND VGND VPWR VPWR sky130_fd_sc_hd__decap_3
XFILLER_6_6 VGND VGND VPWR VPWR sky130_fd_sc_hd__decap_3
XFILLER_131_151 VGND VGND VPWR VPWR sky130_fd_sc_hd__decap_3
XFILLER_49_45 VGND VGND VPWR VPWR sky130_fd_sc_hd__decap_3
XFILLER_172_35 VGND VGND VPWR VPWR sky130_fd_sc_hd__decap_3
XFILLER_172_24 VGND VGND VPWR VPWR sky130_fd_sc_hd__decap_3
XFILLER_49_78 VGND VGND VPWR VPWR sky130_fd_sc_hd__decap_3
XTAP_TAPCELL_ROW_88_723 VGND VPWR sky130_fd_sc_hd__tapvpwrvgnd_1
XFILLER_172_68 VGND VGND VPWR VPWR sky130_fd_sc_hd__decap_3
XFILLER_131_195 VGND VGND VPWR VPWR sky130_fd_sc_hd__fill_2
XPHY_EDGE_ROW_130_Right_130 VGND VGND VPWR VPWR sky130_fd_sc_hd__decap_3
XFILLER_105_51 VGND VGND VPWR VPWR sky130_fd_sc_hd__decap_3
XFILLER_65_66 VGND VGND VPWR VPWR sky130_fd_sc_hd__decap_3
XFILLER_65_99 VGND VGND VPWR VPWR sky130_fd_sc_hd__decap_3
XFILLER_121_72 VGND VGND VPWR VPWR sky130_fd_sc_hd__decap_3
XFILLER_53_190 VGND VGND VPWR VPWR sky130_fd_sc_hd__decap_3
XTAP_TAPCELL_ROW_71_656 VGND VPWR sky130_fd_sc_hd__tapvpwrvgnd_1
XFILLER_81_32 VGND VGND VPWR VPWR sky130_fd_sc_hd__decap_3
XFILLER_5_220 VGND VGND VPWR VPWR sky130_fd_sc_hd__decap_3
XFILLER_30_80 VGND VGND VPWR VPWR sky130_fd_sc_hd__decap_3
XFILLER_30_91 VGND VGND VPWR VPWR sky130_fd_sc_hd__decap_3
XFILLER_146_80 VGND VGND VPWR VPWR sky130_fd_sc_hd__decap_3
X_1330_ Tile_X0Y1_N4END[9] VGND VGND VPWR VPWR net496 sky130_fd_sc_hd__buf_6
XFILLER_122_184 VGND VGND VPWR VPWR sky130_fd_sc_hd__decap_3
XFILLER_122_162 VGND VGND VPWR VPWR sky130_fd_sc_hd__decap_3
X_1261_ net140 VGND VGND VPWR VPWR net443 sky130_fd_sc_hd__clkbuf_2
Xinput7 DOUT_A_SRAM13 VGND VGND VPWR VPWR net7 sky130_fd_sc_hd__buf_1
X_1192_ net245 net272 VGND VGND VPWR VPWR Tile_X0Y1_OpenRAM_bot.Inst_OpenRAM_bot_ConfigMem.Inst_frame7_bit30.Q
+ sky130_fd_sc_hd__dlxtp_1
XFILLER_36_124 VGND VGND VPWR VPWR sky130_fd_sc_hd__decap_3
XTAP_TAPCELL_ROW_94_748 VGND VPWR sky130_fd_sc_hd__tapvpwrvgnd_1
XFILLER_36_168 VGND VGND VPWR VPWR sky130_fd_sc_hd__decap_3
XFILLER_51_105 VGND VGND VPWR VPWR sky130_fd_sc_hd__decap_3
XFILLER_51_116 VGND VGND VPWR VPWR sky130_fd_sc_hd__decap_3
XFILLER_51_138 VGND VGND VPWR VPWR sky130_fd_sc_hd__decap_3
X_0976_ net236 net332 VGND VGND VPWR VPWR Tile_X0Y1_OpenRAM_bot.Inst_OpenRAM_bot_ConfigMem.Inst_frame0_bit22.Q
+ sky130_fd_sc_hd__dlxtp_1
XFILLER_145_210 VGND VGND VPWR VPWR sky130_fd_sc_hd__decap_3
XFILLER_160_202 VGND VGND VPWR VPWR sky130_fd_sc_hd__fill_1
Xoutput300 net383 VGND VGND VPWR VPWR CSB_A_SRAM sky130_fd_sc_hd__buf_2
XFILLER_160_224 VGND VGND VPWR VPWR sky130_fd_sc_hd__decap_3
Xoutput344 net427 VGND VGND VPWR VPWR Tile_X0Y0_FrameData_O[19] sky130_fd_sc_hd__buf_2
Xoutput322 net405 VGND VGND VPWR VPWR DIN_A_SRAM27 sky130_fd_sc_hd__buf_2
Xoutput311 net394 VGND VGND VPWR VPWR DIN_A_SRAM17 sky130_fd_sc_hd__buf_2
Xoutput333 net416 VGND VGND VPWR VPWR DIN_A_SRAM9 sky130_fd_sc_hd__buf_2
Xoutput377 net460 VGND VGND VPWR VPWR Tile_X0Y0_FrameStrobe_O[1] sky130_fd_sc_hd__buf_2
Xoutput366 net449 VGND VGND VPWR VPWR Tile_X0Y0_FrameStrobe_O[0] sky130_fd_sc_hd__buf_2
Xoutput355 net438 VGND VGND VPWR VPWR Tile_X0Y0_FrameData_O[29] sky130_fd_sc_hd__buf_2
Xoutput388 net471 VGND VGND VPWR VPWR Tile_X0Y0_N1BEG[2] sky130_fd_sc_hd__buf_2
Xoutput399 net482 VGND VGND VPWR VPWR Tile_X0Y0_N2BEGb[1] sky130_fd_sc_hd__buf_2
XFILLER_113_184 VGND VGND VPWR VPWR sky130_fd_sc_hd__decap_3
XFILLER_19_26 VGND VGND VPWR VPWR sky130_fd_sc_hd__decap_3
X_1459_ Tile_X0Y1_OpenRAM_bot.Inst_OpenRAM_bot_switch_matrix.S4BEG1 VGND VGND VPWR
+ VPWR net610 sky130_fd_sc_hd__clkbuf_2
XFILLER_27_102 VGND VGND VPWR VPWR sky130_fd_sc_hd__decap_3
XFILLER_27_113 VGND VGND VPWR VPWR sky130_fd_sc_hd__decap_3
XFILLER_27_157 VGND VGND VPWR VPWR sky130_fd_sc_hd__decap_3
XTAP_TAPCELL_ROW_112_819 VGND VPWR sky130_fd_sc_hd__tapvpwrvgnd_1
XFILLER_35_36 VGND VGND VPWR VPWR sky130_fd_sc_hd__decap_3
XFILLER_35_190 VGND VGND VPWR VPWR sky130_fd_sc_hd__decap_3
XTAP_TAPCELL_ROW_120_852 VGND VPWR sky130_fd_sc_hd__tapvpwrvgnd_1
XFILLER_51_13 VGND VGND VPWR VPWR sky130_fd_sc_hd__fill_2
XFILLER_167_24 VGND VGND VPWR VPWR sky130_fd_sc_hd__decap_3
XFILLER_2_223 VGND VGND VPWR VPWR sky130_fd_sc_hd__fill_1
XFILLER_4_3 VGND VGND VPWR VPWR sky130_fd_sc_hd__decap_3
XPHY_EDGE_ROW_76_Left_259 VGND VGND VPWR VPWR sky130_fd_sc_hd__decap_3
XFILLER_116_83 VGND VGND VPWR VPWR sky130_fd_sc_hd__fill_1
XFILLER_76_21 VGND VGND VPWR VPWR sky130_fd_sc_hd__decap_3
XFILLER_76_32 VGND VGND VPWR VPWR sky130_fd_sc_hd__decap_3
XFILLER_76_65 VGND VGND VPWR VPWR sky130_fd_sc_hd__decap_3
XTAP_TAPCELL_ROW_143_944 VGND VPWR sky130_fd_sc_hd__tapvpwrvgnd_1
XFILLER_33_105 VGND VGND VPWR VPWR sky130_fd_sc_hd__decap_3
XFILLER_33_116 VGND VGND VPWR VPWR sky130_fd_sc_hd__decap_3
XPHY_EDGE_ROW_85_Left_268 VGND VGND VPWR VPWR sky130_fd_sc_hd__decap_3
XFILLER_92_64 VGND VGND VPWR VPWR sky130_fd_sc_hd__fill_2
XFILLER_41_193 VGND VGND VPWR VPWR sky130_fd_sc_hd__decap_3
X_0830_ net126 net301 VGND VGND VPWR VPWR Tile_X0Y0_OpenRAM_top.Inst_OpenRAM_top_ConfigMem.Inst_frame4_bit20.Q
+ sky130_fd_sc_hd__dlxtp_1
X_0761_ net131 net321 VGND VGND VPWR VPWR Tile_X0Y0_OpenRAM_top.Inst_OpenRAM_top_ConfigMem.Inst_frame2_bit25.Q
+ sky130_fd_sc_hd__dlxtp_1
XFILLER_157_90 VGND VGND VPWR VPWR sky130_fd_sc_hd__decap_3
X_0692_ net137 net337 VGND VGND VPWR VPWR Tile_X0Y0_OpenRAM_top.Inst_OpenRAM_top_ConfigMem.Inst_frame0_bit30.Q
+ sky130_fd_sc_hd__dlxtp_1
XPHY_EDGE_ROW_94_Left_277 VGND VGND VPWR VPWR sky130_fd_sc_hd__decap_3
X_1313_ Tile_X0Y0_OpenRAM_top.Inst_OpenRAM_top_switch_matrix.N2BEG0 VGND VGND VPWR
+ VPWR net473 sky130_fd_sc_hd__buf_1
X_1244_ net223 net267 VGND VGND VPWR VPWR Tile_X0Y1_OpenRAM_bot.Inst_OpenRAM_bot_ConfigMem.Inst_frame8_bit10.Q
+ sky130_fd_sc_hd__dlxtp_1
XFILLER_2_73 VGND VGND VPWR VPWR sky130_fd_sc_hd__fill_2
X_1175_ net228 net278 VGND VGND VPWR VPWR Tile_X0Y1_OpenRAM_bot.Inst_OpenRAM_bot_ConfigMem.Inst_frame6_bit15.Q
+ sky130_fd_sc_hd__dlxtp_1
XFILLER_24_138 VGND VGND VPWR VPWR sky130_fd_sc_hd__fill_2
XFILLER_177_143 VGND VGND VPWR VPWR sky130_fd_sc_hd__decap_3
XFILLER_32_171 VGND VGND VPWR VPWR sky130_fd_sc_hd__decap_3
XFILLER_177_187 VGND VGND VPWR VPWR sky130_fd_sc_hd__decap_3
XFILLER_118_232 VGND VGND VPWR VPWR sky130_fd_sc_hd__fill_2
X_0959_ net124 net268 VGND VGND VPWR VPWR Tile_X0Y0_OpenRAM_top.Inst_OpenRAM_top_ConfigMem.Inst_frame8_bit19.Q
+ sky130_fd_sc_hd__dlxtp_1
XFILLER_153_26 VGND VGND VPWR VPWR sky130_fd_sc_hd__decap_3
XFILLER_101_132 VGND VGND VPWR VPWR sky130_fd_sc_hd__decap_3
XFILLER_99_193 VGND VGND VPWR VPWR sky130_fd_sc_hd__fill_2
XFILLER_47_219 VGND VGND VPWR VPWR sky130_fd_sc_hd__decap_3
XFILLER_101_187 VGND VGND VPWR VPWR sky130_fd_sc_hd__decap_3
XFILLER_46_13 VGND VGND VPWR VPWR sky130_fd_sc_hd__decap_3
XFILLER_70_200 VGND VGND VPWR VPWR sky130_fd_sc_hd__decap_3
XFILLER_15_149 VGND VGND VPWR VPWR sky130_fd_sc_hd__decap_3
XFILLER_70_233 VGND VGND VPWR VPWR sky130_fd_sc_hd__fill_1
XFILLER_178_12 VGND VGND VPWR VPWR sky130_fd_sc_hd__decap_3
XFILLER_102_85 VGND VGND VPWR VPWR sky130_fd_sc_hd__decap_3
XFILLER_62_23 VGND VGND VPWR VPWR sky130_fd_sc_hd__decap_3
XFILLER_168_121 VGND VGND VPWR VPWR sky130_fd_sc_hd__decap_3
XFILLER_62_56 VGND VGND VPWR VPWR sky130_fd_sc_hd__fill_1
XFILLER_178_56 VGND VGND VPWR VPWR sky130_fd_sc_hd__decap_3
XFILLER_168_176 VGND VGND VPWR VPWR sky130_fd_sc_hd__decap_3
XFILLER_7_18 VGND VGND VPWR VPWR sky130_fd_sc_hd__decap_3
XFILLER_11_60 VGND VGND VPWR VPWR sky130_fd_sc_hd__decap_3
XFILLER_127_60 VGND VGND VPWR VPWR sky130_fd_sc_hd__decap_3
XFILLER_11_93 VGND VGND VPWR VPWR sky130_fd_sc_hd__decap_3
XFILLER_87_42 VGND VGND VPWR VPWR sky130_fd_sc_hd__decap_3
XFILLER_38_219 VGND VGND VPWR VPWR sky130_fd_sc_hd__decap_3
XFILLER_143_81 VGND VGND VPWR VPWR sky130_fd_sc_hd__decap_3
XFILLER_61_211 VGND VGND VPWR VPWR sky130_fd_sc_hd__fill_1
XFILLER_21_108 VGND VGND VPWR VPWR sky130_fd_sc_hd__decap_3
XFILLER_159_143 VGND VGND VPWR VPWR sky130_fd_sc_hd__decap_3
XFILLER_14_171 VGND VGND VPWR VPWR sky130_fd_sc_hd__decap_3
XFILLER_21_119 VGND VGND VPWR VPWR sky130_fd_sc_hd__decap_3
XFILLER_174_124 VGND VGND VPWR VPWR sky130_fd_sc_hd__decap_3
XFILLER_159_198 VGND VGND VPWR VPWR sky130_fd_sc_hd__decap_3
X_0813_ net141 net308 VGND VGND VPWR VPWR Tile_X0Y0_OpenRAM_top.Inst_OpenRAM_top_ConfigMem.Inst_frame3_bit5.Q
+ sky130_fd_sc_hd__dlxtp_1
Xinput10 DOUT_A_SRAM16 VGND VGND VPWR VPWR net10 sky130_fd_sc_hd__buf_2
Xinput21 DOUT_A_SRAM26 VGND VGND VPWR VPWR net21 sky130_fd_sc_hd__clkbuf_2
XFILLER_174_168 VGND VGND VPWR VPWR sky130_fd_sc_hd__decap_3
Xinput32 DOUT_A_SRAM8 VGND VGND VPWR VPWR net32 sky130_fd_sc_hd__dlymetal6s2s_1
Xinput43 DOUT_B_SRAM17 VGND VGND VPWR VPWR net43 sky130_fd_sc_hd__clkbuf_2
Xinput54 DOUT_B_SRAM27 VGND VGND VPWR VPWR net54 sky130_fd_sc_hd__buf_1
Xinput87 Tile_X0Y0_E6END[10] VGND VGND VPWR VPWR net87 sky130_fd_sc_hd__dlymetal6s2s_1
X_0744_ net115 net327 VGND VGND VPWR VPWR Tile_X0Y0_OpenRAM_top.Inst_OpenRAM_top_ConfigMem.Inst_frame1_bit10.Q
+ sky130_fd_sc_hd__dlxtp_1
Xinput76 Tile_X0Y0_E2END[6] VGND VGND VPWR VPWR net76 sky130_fd_sc_hd__buf_1
Xinput98 Tile_X0Y0_EE4END[0] VGND VGND VPWR VPWR net98 sky130_fd_sc_hd__clkbuf_2
XFILLER_115_202 VGND VGND VPWR VPWR sky130_fd_sc_hd__fill_1
Xinput65 DOUT_B_SRAM9 VGND VGND VPWR VPWR net65 sky130_fd_sc_hd__buf_1
X_0675_ _0209_ _0211_ _0212_ Tile_X0Y1_OpenRAM_bot.Inst_OpenRAM_bot_ConfigMem.Inst_frame6_bit7.Q
+ VGND VGND VPWR VPWR Tile_X0Y1_OpenRAM_bot.Inst_OpenRAM_bot_switch_matrix.S4BEG3
+ sky130_fd_sc_hd__o22a_1
XFILLER_96_141 VGND VGND VPWR VPWR sky130_fd_sc_hd__decap_3
XFILLER_123_18 VGND VGND VPWR VPWR sky130_fd_sc_hd__decap_3
X_1227_ net241 net266 VGND VGND VPWR VPWR Tile_X0Y1_OpenRAM_bot.Inst_OpenRAM_bot_ConfigMem.Inst_frame8_bit27.Q
+ sky130_fd_sc_hd__dlxtp_1
X_1158_ net222 net287 VGND VGND VPWR VPWR Tile_X0Y1_OpenRAM_bot.Inst_OpenRAM_bot_ConfigMem.Inst_frame5_bit0.Q
+ sky130_fd_sc_hd__dlxtp_1
XFILLER_52_233 VGND VGND VPWR VPWR sky130_fd_sc_hd__fill_1
X_1089_ net249 net307 VGND VGND VPWR VPWR Tile_X0Y1_OpenRAM_bot.Inst_OpenRAM_bot_ConfigMem.Inst_frame3_bit5.Q
+ sky130_fd_sc_hd__dlxtp_1
XFILLER_12_119 VGND VGND VPWR VPWR sky130_fd_sc_hd__decap_3
XFILLER_20_141 VGND VGND VPWR VPWR sky130_fd_sc_hd__decap_3
XFILLER_32_26 VGND VGND VPWR VPWR sky130_fd_sc_hd__fill_2
XFILLER_165_113 VGND VGND VPWR VPWR sky130_fd_sc_hd__decap_3
XFILLER_148_26 VGND VGND VPWR VPWR sky130_fd_sc_hd__fill_2
XFILLER_20_174 VGND VGND VPWR VPWR sky130_fd_sc_hd__decap_3
XFILLER_165_146 VGND VGND VPWR VPWR sky130_fd_sc_hd__decap_3
XFILLER_180_127 VGND VGND VPWR VPWR sky130_fd_sc_hd__decap_3
XFILLER_173_190 VGND VGND VPWR VPWR sky130_fd_sc_hd__decap_3
XFILLER_57_34 VGND VGND VPWR VPWR sky130_fd_sc_hd__decap_3
XFILLER_87_130 VGND VGND VPWR VPWR sky130_fd_sc_hd__decap_3
XFILLER_87_163 VGND VGND VPWR VPWR sky130_fd_sc_hd__decap_3
XFILLER_180_46 VGND VGND VPWR VPWR sky130_fd_sc_hd__decap_3
XFILLER_180_35 VGND VGND VPWR VPWR sky130_fd_sc_hd__decap_3
XFILLER_180_24 VGND VGND VPWR VPWR sky130_fd_sc_hd__decap_3
XTAP_TAPCELL_ROW_3_384 VGND VPWR sky130_fd_sc_hd__tapvpwrvgnd_1
XPHY_EDGE_ROW_159_Left_342 VGND VGND VPWR VPWR sky130_fd_sc_hd__decap_3
XTAP_TAPCELL_ROW_26_475 VGND VPWR sky130_fd_sc_hd__tapvpwrvgnd_1
XFILLER_11_152 VGND VGND VPWR VPWR sky130_fd_sc_hd__decap_3
XFILLER_7_134 VGND VGND VPWR VPWR sky130_fd_sc_hd__decap_3
XFILLER_22_70 VGND VGND VPWR VPWR sky130_fd_sc_hd__decap_3
XFILLER_171_116 VGND VGND VPWR VPWR sky130_fd_sc_hd__decap_3
XFILLER_171_105 VGND VGND VPWR VPWR sky130_fd_sc_hd__decap_3
XFILLER_7_178 VGND VGND VPWR VPWR sky130_fd_sc_hd__decap_3
XFILLER_7_167 VGND VGND VPWR VPWR sky130_fd_sc_hd__fill_1
XFILLER_171_149 VGND VGND VPWR VPWR sky130_fd_sc_hd__decap_3
XFILLER_138_81 VGND VGND VPWR VPWR sky130_fd_sc_hd__decap_3
XFILLER_98_41 VGND VGND VPWR VPWR sky130_fd_sc_hd__decap_3
X_0460_ net79 net258 Tile_X0Y0_OpenRAM_top.Inst_OpenRAM_top_ConfigMem.Inst_frame1_bit3.Q
+ VGND VGND VPWR VPWR _0107_ sky130_fd_sc_hd__mux2_1
XPHY_EDGE_ROW_168_Left_351 VGND VGND VPWR VPWR sky130_fd_sc_hd__decap_3
XFILLER_154_91 VGND VGND VPWR VPWR sky130_fd_sc_hd__fill_1
XFILLER_154_80 VGND VGND VPWR VPWR sky130_fd_sc_hd__decap_3
X_0391_ Tile_X0Y0_OpenRAM_top.Inst_OpenRAM_top_switch_matrix.N1END3 net364 net149
+ net169 Tile_X0Y0_OpenRAM_top.Inst_OpenRAM_top_ConfigMem.Inst_frame1_bit30.Q Tile_X0Y0_OpenRAM_top.Inst_OpenRAM_top_ConfigMem.Inst_frame1_bit31.Q
+ VGND VGND VPWR VPWR Tile_X0Y0_OpenRAM_top.Inst_OpenRAM_top_switch_matrix.J_NS4_BEG11
+ sky130_fd_sc_hd__mux4_2
XFILLER_78_141 VGND VGND VPWR VPWR sky130_fd_sc_hd__decap_3
XFILLER_78_174 VGND VGND VPWR VPWR sky130_fd_sc_hd__decap_3
X_1012_ net231 net322 VGND VGND VPWR VPWR Tile_X0Y1_OpenRAM_bot.Inst_OpenRAM_bot_ConfigMem.Inst_frame1_bit18.Q
+ sky130_fd_sc_hd__dlxtp_1
XTAP_TAPCELL_ROW_49_567 VGND VPWR sky130_fd_sc_hd__tapvpwrvgnd_1
XPHY_EDGE_ROW_177_Left_360 VGND VGND VPWR VPWR sky130_fd_sc_hd__decap_3
XFILLER_147_102 VGND VGND VPWR VPWR sky130_fd_sc_hd__decap_3
XFILLER_147_113 VGND VGND VPWR VPWR sky130_fd_sc_hd__decap_3
XFILLER_8_50 VGND VGND VPWR VPWR sky130_fd_sc_hd__decap_3
XFILLER_8_94 VGND VGND VPWR VPWR sky130_fd_sc_hd__decap_3
XFILLER_8_83 VGND VGND VPWR VPWR sky130_fd_sc_hd__fill_1
XFILLER_118_29 VGND VGND VPWR VPWR sky130_fd_sc_hd__decap_3
X_0727_ net133 net328 VGND VGND VPWR VPWR Tile_X0Y0_OpenRAM_top.Inst_OpenRAM_top_ConfigMem.Inst_frame1_bit27.Q
+ sky130_fd_sc_hd__dlxtp_1
XFILLER_103_205 VGND VGND VPWR VPWR sky130_fd_sc_hd__decap_3
XFILLER_170_171 VGND VGND VPWR VPWR sky130_fd_sc_hd__decap_3
X_0658_ _0151_ _0147_ Tile_X0Y1_OpenRAM_bot.Inst_OpenRAM_bot_ConfigMem.Inst_frame7_bit31.Q
+ VGND VGND VPWR VPWR _0198_ sky130_fd_sc_hd__mux2_1
XFILLER_69_152 VGND VGND VPWR VPWR sky130_fd_sc_hd__decap_3
X_0589_ net178 _0022_ _0157_ VGND VGND VPWR VPWR _0158_ sky130_fd_sc_hd__o21a_1
XFILLER_27_15 VGND VGND VPWR VPWR sky130_fd_sc_hd__decap_3
XFILLER_69_196 VGND VGND VPWR VPWR sky130_fd_sc_hd__decap_3
XFILLER_175_9 VGND VGND VPWR VPWR sky130_fd_sc_hd__decap_3
XFILLER_84_177 VGND VGND VPWR VPWR sky130_fd_sc_hd__decap_3
XFILLER_25_222 VGND VGND VPWR VPWR sky130_fd_sc_hd__fill_2
XPHY_EDGE_ROW_177_Right_177 VGND VGND VPWR VPWR sky130_fd_sc_hd__decap_3
XFILLER_175_24 VGND VGND VPWR VPWR sky130_fd_sc_hd__decap_3
XFILLER_153_116 VGND VGND VPWR VPWR sky130_fd_sc_hd__decap_3
XFILLER_4_115 VGND VGND VPWR VPWR sky130_fd_sc_hd__decap_3
XFILLER_175_57 VGND VGND VPWR VPWR sky130_fd_sc_hd__decap_3
XFILLER_104_3 VGND VGND VPWR VPWR sky130_fd_sc_hd__decap_3
XFILLER_4_159 VGND VGND VPWR VPWR sky130_fd_sc_hd__decap_3
XFILLER_161_193 VGND VGND VPWR VPWR sky130_fd_sc_hd__fill_2
Xinput211 Tile_X0Y1_EE4END[14] VGND VGND VPWR VPWR net211 sky130_fd_sc_hd__buf_1
Xinput200 Tile_X0Y1_E6END[4] VGND VGND VPWR VPWR net200 sky130_fd_sc_hd__buf_1
XFILLER_68_77 VGND VGND VPWR VPWR sky130_fd_sc_hd__decap_3
Xinput222 Tile_X0Y1_FrameData[0] VGND VGND VPWR VPWR net222 sky130_fd_sc_hd__clkbuf_4
Xinput233 Tile_X0Y1_FrameData[1] VGND VGND VPWR VPWR net233 sky130_fd_sc_hd__clkbuf_4
Xinput244 Tile_X0Y1_FrameData[2] VGND VGND VPWR VPWR net244 sky130_fd_sc_hd__clkbuf_4
XFILLER_68_88 VGND VGND VPWR VPWR sky130_fd_sc_hd__decap_3
XFILLER_75_100 VGND VGND VPWR VPWR sky130_fd_sc_hd__decap_3
XFILLER_75_111 VGND VGND VPWR VPWR sky130_fd_sc_hd__fill_1
XFILLER_124_83 VGND VGND VPWR VPWR sky130_fd_sc_hd__fill_1
XFILLER_124_50 VGND VGND VPWR VPWR sky130_fd_sc_hd__decap_3
Xinput277 Tile_X0Y1_N4END[3] VGND VGND VPWR VPWR net360 sky130_fd_sc_hd__clkbuf_2
Xinput255 Tile_X0Y1_N1END[1] VGND VGND VPWR VPWR net255 sky130_fd_sc_hd__buf_2
Xinput266 Tile_X0Y1_N2MID[0] VGND VGND VPWR VPWR net349 sky130_fd_sc_hd__clkbuf_2
XFILLER_124_94 VGND VGND VPWR VPWR sky130_fd_sc_hd__decap_3
XFILLER_84_54 VGND VGND VPWR VPWR sky130_fd_sc_hd__fill_1
XFILLER_17_81 VGND VGND VPWR VPWR sky130_fd_sc_hd__decap_3
XFILLER_90_169 VGND VGND VPWR VPWR sky130_fd_sc_hd__decap_3
XFILLER_140_71 VGND VGND VPWR VPWR sky130_fd_sc_hd__fill_1
XFILLER_90_9 VGND VGND VPWR VPWR sky130_fd_sc_hd__decap_3
XFILLER_129_146 VGND VGND VPWR VPWR sky130_fd_sc_hd__decap_3
XFILLER_144_116 VGND VGND VPWR VPWR sky130_fd_sc_hd__decap_3
XPHY_EDGE_ROW_144_Right_144 VGND VGND VPWR VPWR sky130_fd_sc_hd__decap_3
XFILLER_144_138 VGND VGND VPWR VPWR sky130_fd_sc_hd__fill_2
XFILLER_152_182 VGND VGND VPWR VPWR sky130_fd_sc_hd__fill_2
XFILLER_3_181 VGND VGND VPWR VPWR sky130_fd_sc_hd__decap_3
X_1492_ Tile_X0Y1_OpenRAM_bot.Inst_OpenRAM_bot_switch_matrix.W6BEG10 VGND VGND VPWR
+ VPWR net643 sky130_fd_sc_hd__buf_1
X_0512_ net340 net360 _0077_ net173 Tile_X0Y1_OpenRAM_bot.Inst_OpenRAM_bot_ConfigMem.Inst_frame0_bit6.Q
+ Tile_X0Y1_OpenRAM_bot.Inst_OpenRAM_bot_ConfigMem.Inst_frame0_bit7.Q VGND VGND VPWR
+ VPWR Tile_X0Y1_OpenRAM_bot.Inst_OpenRAM_bot_switch_matrix.J_NS4_BEG15 sky130_fd_sc_hd__mux4_2
X_0443_ net98 net112 net86 Tile_X0Y0_OpenRAM_top.Inst_OpenRAM_top_switch_matrix.J_NS4_BEG0
+ Tile_X0Y0_OpenRAM_top.Inst_OpenRAM_top_ConfigMem.Inst_frame2_bit20.Q Tile_X0Y0_OpenRAM_top.Inst_OpenRAM_top_ConfigMem.Inst_frame2_bit21.Q
+ VGND VGND VPWR VPWR net673 sky130_fd_sc_hd__mux4_2
X_0374_ net15 net47 net256 Tile_X0Y0_OpenRAM_top.Inst_OpenRAM_top_switch_matrix.J_NS2_BEG4
+ Tile_X0Y0_OpenRAM_top.Inst_OpenRAM_top_ConfigMem.Inst_frame5_bit4.Q Tile_X0Y0_OpenRAM_top.Inst_OpenRAM_top_ConfigMem.Inst_frame5_bit5.Q
+ VGND VGND VPWR VPWR Tile_X0Y0_OpenRAM_top.Inst_OpenRAM_top_switch_matrix.W2BEG4
+ sky130_fd_sc_hd__mux4_1
XFILLER_66_144 VGND VGND VPWR VPWR sky130_fd_sc_hd__decap_3
XFILLER_81_125 VGND VGND VPWR VPWR sky130_fd_sc_hd__decap_3
XFILLER_167_208 VGND VGND VPWR VPWR sky130_fd_sc_hd__decap_3
XTAP_TAPCELL_ROW_104_788 VGND VPWR sky130_fd_sc_hd__tapvpwrvgnd_1
XFILLER_13_39 VGND VGND VPWR VPWR sky130_fd_sc_hd__decap_3
XFILLER_135_116 VGND VGND VPWR VPWR sky130_fd_sc_hd__decap_3
XPHY_EDGE_ROW_111_Right_111 VGND VGND VPWR VPWR sky130_fd_sc_hd__decap_3
XFILLER_145_16 VGND VGND VPWR VPWR sky130_fd_sc_hd__decap_3
XFILLER_89_203 VGND VGND VPWR VPWR sky130_fd_sc_hd__decap_3
XFILLER_89_225 VGND VGND VPWR VPWR sky130_fd_sc_hd__decap_3
XFILLER_57_111 VGND VGND VPWR VPWR sky130_fd_sc_hd__fill_1
XFILLER_161_37 VGND VGND VPWR VPWR sky130_fd_sc_hd__decap_3
XFILLER_57_166 VGND VGND VPWR VPWR sky130_fd_sc_hd__fill_2
XFILLER_173_6 VGND VGND VPWR VPWR sky130_fd_sc_hd__decap_3
XFILLER_72_114 VGND VGND VPWR VPWR sky130_fd_sc_hd__decap_3
XFILLER_54_35 VGND VGND VPWR VPWR sky130_fd_sc_hd__decap_3
XFILLER_13_225 VGND VGND VPWR VPWR sky130_fd_sc_hd__decap_3
XFILLER_13_214 VGND VGND VPWR VPWR sky130_fd_sc_hd__decap_3
XFILLER_54_68 VGND VGND VPWR VPWR sky130_fd_sc_hd__decap_3
XFILLER_110_41 VGND VGND VPWR VPWR sky130_fd_sc_hd__decap_3
XFILLER_80_191 VGND VGND VPWR VPWR sky130_fd_sc_hd__decap_3
XFILLER_110_85 VGND VGND VPWR VPWR sky130_fd_sc_hd__decap_3
XTAP_TAPCELL_ROW_11_415 VGND VPWR sky130_fd_sc_hd__tapvpwrvgnd_1
XFILLER_70_56 VGND VGND VPWR VPWR sky130_fd_sc_hd__decap_3
XFILLER_126_116 VGND VGND VPWR VPWR sky130_fd_sc_hd__decap_3
XFILLER_181_222 VGND VGND VPWR VPWR sky130_fd_sc_hd__fill_2
XFILLER_141_119 VGND VGND VPWR VPWR sky130_fd_sc_hd__decap_3
XFILLER_119_83 VGND VGND VPWR VPWR sky130_fd_sc_hd__decap_3
XFILLER_134_193 VGND VGND VPWR VPWR sky130_fd_sc_hd__decap_3
XFILLER_135_60 VGND VGND VPWR VPWR sky130_fd_sc_hd__decap_3
XFILLER_0_195 VGND VGND VPWR VPWR sky130_fd_sc_hd__fill_1
XFILLER_48_111 VGND VGND VPWR VPWR sky130_fd_sc_hd__decap_3
XFILLER_48_144 VGND VGND VPWR VPWR sky130_fd_sc_hd__decap_3
XFILLER_95_42 VGND VGND VPWR VPWR sky130_fd_sc_hd__decap_3
XTAP_TAPCELL_ROW_163_1025 VGND VPWR sky130_fd_sc_hd__tapvpwrvgnd_1
XFILLER_48_177 VGND VGND VPWR VPWR sky130_fd_sc_hd__decap_3
XFILLER_95_86 VGND VGND VPWR VPWR sky130_fd_sc_hd__decap_3
XFILLER_151_81 VGND VGND VPWR VPWR sky130_fd_sc_hd__decap_3
XTAP_TAPCELL_ROW_34_507 VGND VPWR sky130_fd_sc_hd__tapvpwrvgnd_1
XFILLER_63_169 VGND VGND VPWR VPWR sky130_fd_sc_hd__decap_3
X_0992_ net250 net330 VGND VGND VPWR VPWR Tile_X0Y1_OpenRAM_bot.Inst_OpenRAM_bot_ConfigMem.Inst_frame0_bit6.Q
+ sky130_fd_sc_hd__dlxtp_1
XTAP_TAPCELL_ROW_42_540 VGND VPWR sky130_fd_sc_hd__tapvpwrvgnd_1
XFILLER_172_200 VGND VGND VPWR VPWR sky130_fd_sc_hd__decap_3
XFILLER_117_116 VGND VGND VPWR VPWR sky130_fd_sc_hd__decap_3
XFILLER_117_149 VGND VGND VPWR VPWR sky130_fd_sc_hd__decap_3
XFILLER_67_3 VGND VGND VPWR VPWR sky130_fd_sc_hd__fill_1
Xoutput515 net598 VGND VGND VPWR VPWR Tile_X0Y1_S2BEGb[0] sky130_fd_sc_hd__buf_2
Xoutput504 net587 VGND VGND VPWR VPWR Tile_X0Y1_S1BEG[1] sky130_fd_sc_hd__buf_2
Xoutput526 net609 VGND VGND VPWR VPWR Tile_X0Y1_S4BEG[12] sky130_fd_sc_hd__buf_2
XFILLER_132_119 VGND VGND VPWR VPWR sky130_fd_sc_hd__decap_3
Xoutput548 net631 VGND VGND VPWR VPWR Tile_X0Y1_W2BEG[5] sky130_fd_sc_hd__buf_2
XFILLER_5_51 VGND VGND VPWR VPWR sky130_fd_sc_hd__decap_3
Xoutput537 net620 VGND VGND VPWR VPWR Tile_X0Y1_S4BEG[8] sky130_fd_sc_hd__buf_2
Xoutput559 net642 VGND VGND VPWR VPWR Tile_X0Y1_W6BEG[0] sky130_fd_sc_hd__buf_2
XFILLER_125_193 VGND VGND VPWR VPWR sky130_fd_sc_hd__fill_2
XFILLER_115_19 VGND VGND VPWR VPWR sky130_fd_sc_hd__decap_3
XFILLER_5_84 VGND VGND VPWR VPWR sky130_fd_sc_hd__decap_3
X_1475_ Tile_X0Y1_OpenRAM_bot.Inst_OpenRAM_bot_switch_matrix.W2BEGb1 VGND VGND VPWR
+ VPWR net635 sky130_fd_sc_hd__buf_1
X_0426_ net50 Tile_X0Y0_OpenRAM_top.Inst_OpenRAM_top_switch_matrix.J_NS4_BEG0 Tile_X0Y0_OpenRAM_top.Inst_OpenRAM_top_switch_matrix.J_NS4_BEG4
+ Tile_X0Y0_OpenRAM_top.Inst_OpenRAM_top_switch_matrix.J_NS2_BEG7 Tile_X0Y0_OpenRAM_top.Inst_OpenRAM_top_ConfigMem.Inst_frame3_bit18.Q
+ Tile_X0Y0_OpenRAM_top.Inst_OpenRAM_top_ConfigMem.Inst_frame3_bit19.Q VGND VGND VPWR
+ VPWR Tile_X0Y0_OpenRAM_top.Inst_OpenRAM_top_switch_matrix.W6BEG11 sky130_fd_sc_hd__mux4_1
X_0357_ net78 net70 net86 Tile_X0Y0_OpenRAM_top.Inst_OpenRAM_top_switch_matrix.J_NS2_BEG7
+ Tile_X0Y0_OpenRAM_top.Inst_OpenRAM_top_ConfigMem.Inst_frame7_bit2.Q Tile_X0Y0_OpenRAM_top.Inst_OpenRAM_top_ConfigMem.Inst_frame7_bit3.Q
+ VGND VGND VPWR VPWR Tile_X0Y0_OpenRAM_top.Inst_OpenRAM_top_switch_matrix.N2BEG7
+ sky130_fd_sc_hd__mux4_1
XPHY_EDGE_ROW_105_Left_288 VGND VGND VPWR VPWR sky130_fd_sc_hd__decap_3
XFILLER_54_103 VGND VGND VPWR VPWR sky130_fd_sc_hd__decap_3
XFILLER_54_136 VGND VGND VPWR VPWR sky130_fd_sc_hd__decap_3
XTAP_TAPCELL_ROW_65_632 VGND VPWR sky130_fd_sc_hd__tapvpwrvgnd_1
X_0288_ Tile_X0Y1_OpenRAM_bot.Inst_OpenRAM_bot_ConfigMem.Inst_frame2_bit30.Q _0053_
+ Tile_X0Y1_OpenRAM_bot.Inst_OpenRAM_bot_ConfigMem.Inst_frame2_bit29.Q VGND VGND VPWR
+ VPWR _0057_ sky130_fd_sc_hd__and3b_1
XFILLER_54_147 VGND VGND VPWR VPWR sky130_fd_sc_hd__decap_3
XFILLER_24_27 VGND VGND VPWR VPWR sky130_fd_sc_hd__fill_1
XFILLER_24_38 VGND VGND VPWR VPWR sky130_fd_sc_hd__decap_3
XFILLER_62_180 VGND VGND VPWR VPWR sky130_fd_sc_hd__decap_3
XTAP_TAPCELL_ROW_179_1087 VGND VPWR sky130_fd_sc_hd__tapvpwrvgnd_1
XFILLER_10_206 VGND VGND VPWR VPWR sky130_fd_sc_hd__decap_3
XPHY_EDGE_ROW_114_Left_297 VGND VGND VPWR VPWR sky130_fd_sc_hd__decap_3
XFILLER_163_222 VGND VGND VPWR VPWR sky130_fd_sc_hd__fill_2
XFILLER_163_211 VGND VGND VPWR VPWR sky130_fd_sc_hd__decap_3
XFILLER_156_26 VGND VGND VPWR VPWR sky130_fd_sc_hd__fill_2
XFILLER_108_127 VGND VGND VPWR VPWR sky130_fd_sc_hd__decap_3
XFILLER_156_59 VGND VGND VPWR VPWR sky130_fd_sc_hd__decap_3
XFILLER_123_108 VGND VGND VPWR VPWR sky130_fd_sc_hd__decap_3
XFILLER_172_47 VGND VGND VPWR VPWR sky130_fd_sc_hd__decap_3
XFILLER_49_57 VGND VGND VPWR VPWR sky130_fd_sc_hd__decap_3
XTAP_TAPCELL_ROW_88_724 VGND VPWR sky130_fd_sc_hd__tapvpwrvgnd_1
XFILLER_105_30 VGND VGND VPWR VPWR sky130_fd_sc_hd__decap_3
XFILLER_105_63 VGND VGND VPWR VPWR sky130_fd_sc_hd__decap_3
XFILLER_92_209 VGND VGND VPWR VPWR sky130_fd_sc_hd__decap_3
XFILLER_45_103 VGND VGND VPWR VPWR sky130_fd_sc_hd__decap_3
XFILLER_45_125 VGND VGND VPWR VPWR sky130_fd_sc_hd__fill_1
XFILLER_65_45 VGND VGND VPWR VPWR sky130_fd_sc_hd__decap_3
XFILLER_45_169 VGND VGND VPWR VPWR sky130_fd_sc_hd__decap_3
XFILLER_65_78 VGND VGND VPWR VPWR sky130_fd_sc_hd__decap_3
XFILLER_121_51 VGND VGND VPWR VPWR sky130_fd_sc_hd__decap_3
XFILLER_60_106 VGND VGND VPWR VPWR sky130_fd_sc_hd__decap_3
XFILLER_121_84 VGND VGND VPWR VPWR sky130_fd_sc_hd__decap_3
XTAP_TAPCELL_ROW_71_657 VGND VPWR sky130_fd_sc_hd__tapvpwrvgnd_1
XFILLER_81_66 VGND VGND VPWR VPWR sky130_fd_sc_hd__decap_3
XFILLER_81_88 VGND VGND VPWR VPWR sky130_fd_sc_hd__decap_3
XFILLER_154_200 VGND VGND VPWR VPWR sky130_fd_sc_hd__decap_3
XFILLER_107_182 VGND VGND VPWR VPWR sky130_fd_sc_hd__decap_3
XFILLER_107_160 VGND VGND VPWR VPWR sky130_fd_sc_hd__decap_3
XFILLER_146_70 VGND VGND VPWR VPWR sky130_fd_sc_hd__decap_3
XFILLER_122_141 VGND VGND VPWR VPWR sky130_fd_sc_hd__decap_3
XFILLER_122_130 VGND VGND VPWR VPWR sky130_fd_sc_hd__decap_3
XFILLER_68_206 VGND VGND VPWR VPWR sky130_fd_sc_hd__decap_3
X_1260_ net139 VGND VGND VPWR VPWR net442 sky130_fd_sc_hd__buf_1
XFILLER_162_80 VGND VGND VPWR VPWR sky130_fd_sc_hd__decap_3
Xinput8 DOUT_A_SRAM14 VGND VGND VPWR VPWR net8 sky130_fd_sc_hd__buf_1
XFILLER_39_90 VGND VGND VPWR VPWR sky130_fd_sc_hd__decap_3
X_1191_ net246 net271 VGND VGND VPWR VPWR Tile_X0Y1_OpenRAM_bot.Inst_OpenRAM_bot_ConfigMem.Inst_frame7_bit31.Q
+ sky130_fd_sc_hd__dlxtp_1
XFILLER_162_91 VGND VGND VPWR VPWR sky130_fd_sc_hd__fill_1
XFILLER_91_220 VGND VGND VPWR VPWR sky130_fd_sc_hd__decap_3
XTAP_TAPCELL_ROW_94_749 VGND VPWR sky130_fd_sc_hd__tapvpwrvgnd_1
XFILLER_36_136 VGND VGND VPWR VPWR sky130_fd_sc_hd__decap_3
XFILLER_36_147 VGND VGND VPWR VPWR sky130_fd_sc_hd__decap_3
XFILLER_44_191 VGND VGND VPWR VPWR sky130_fd_sc_hd__decap_3
X_0975_ net237 net332 VGND VGND VPWR VPWR Tile_X0Y1_OpenRAM_bot.Inst_OpenRAM_bot_ConfigMem.Inst_frame0_bit23.Q
+ sky130_fd_sc_hd__dlxtp_1
XFILLER_145_222 VGND VGND VPWR VPWR sky130_fd_sc_hd__fill_2
Xoutput301 net384 VGND VGND VPWR VPWR CSB_B_SRAM sky130_fd_sc_hd__buf_2
XFILLER_10_18 VGND VGND VPWR VPWR sky130_fd_sc_hd__decap_3
Xoutput334 net417 VGND VGND VPWR VPWR Tile_X0Y0_FrameData_O[0] sky130_fd_sc_hd__buf_2
Xoutput323 net406 VGND VGND VPWR VPWR DIN_A_SRAM28 sky130_fd_sc_hd__buf_2
Xoutput312 net395 VGND VGND VPWR VPWR DIN_A_SRAM18 sky130_fd_sc_hd__buf_2
XFILLER_10_29 VGND VGND VPWR VPWR sky130_fd_sc_hd__decap_3
Xoutput367 net450 VGND VGND VPWR VPWR Tile_X0Y0_FrameStrobe_O[10] sky130_fd_sc_hd__buf_2
Xoutput378 net461 VGND VGND VPWR VPWR Tile_X0Y0_FrameStrobe_O[2] sky130_fd_sc_hd__buf_2
Xoutput356 net439 VGND VGND VPWR VPWR Tile_X0Y0_FrameData_O[2] sky130_fd_sc_hd__buf_2
Xoutput345 net428 VGND VGND VPWR VPWR Tile_X0Y0_FrameData_O[1] sky130_fd_sc_hd__buf_2
Xoutput389 net472 VGND VGND VPWR VPWR Tile_X0Y0_N1BEG[3] sky130_fd_sc_hd__buf_2
XFILLER_113_163 VGND VGND VPWR VPWR sky130_fd_sc_hd__decap_3
XFILLER_113_152 VGND VGND VPWR VPWR sky130_fd_sc_hd__decap_3
XFILLER_113_196 VGND VGND VPWR VPWR sky130_fd_sc_hd__decap_3
X_1458_ Tile_X0Y1_OpenRAM_bot.Inst_OpenRAM_bot_switch_matrix.S4BEG0 VGND VGND VPWR
+ VPWR net609 sky130_fd_sc_hd__clkbuf_2
XTAP_TAPCELL_ROW_137_920 VGND VPWR sky130_fd_sc_hd__tapvpwrvgnd_1
X_0409_ Tile_X0Y0_OpenRAM_top.Inst_OpenRAM_top_switch_matrix.N1END2 net363 net148
+ net168 Tile_X0Y0_OpenRAM_top.Inst_OpenRAM_top_ConfigMem.Inst_frame1_bit12.Q Tile_X0Y0_OpenRAM_top.Inst_OpenRAM_top_ConfigMem.Inst_frame1_bit13.Q
+ VGND VGND VPWR VPWR _0096_ sky130_fd_sc_hd__mux4_2
XFILLER_19_49 VGND VGND VPWR VPWR sky130_fd_sc_hd__decap_3
XFILLER_74_209 VGND VGND VPWR VPWR sky130_fd_sc_hd__decap_3
X_1389_ Tile_X0Y0_OpenRAM_top.Inst_OpenRAM_top_switch_matrix.WW4BEG11 VGND VGND VPWR
+ VPWR net540 sky130_fd_sc_hd__buf_1
XFILLER_27_125 VGND VGND VPWR VPWR sky130_fd_sc_hd__decap_3
XFILLER_82_220 VGND VGND VPWR VPWR sky130_fd_sc_hd__decap_3
XTAP_TAPCELL_ROW_152_978 VGND VPWR sky130_fd_sc_hd__tapvpwrvgnd_1
XFILLER_27_169 VGND VGND VPWR VPWR sky130_fd_sc_hd__fill_1
XFILLER_35_48 VGND VGND VPWR VPWR sky130_fd_sc_hd__decap_3
XPHY_EDGE_ROW_122_Left_305 VGND VGND VPWR VPWR sky130_fd_sc_hd__decap_3
XFILLER_50_150 VGND VGND VPWR VPWR sky130_fd_sc_hd__decap_3
XTAP_TAPCELL_ROW_120_853 VGND VPWR sky130_fd_sc_hd__tapvpwrvgnd_1
XFILLER_50_194 VGND VGND VPWR VPWR sky130_fd_sc_hd__fill_2
XFILLER_51_36 VGND VGND VPWR VPWR sky130_fd_sc_hd__decap_3
XFILLER_167_36 VGND VGND VPWR VPWR sky130_fd_sc_hd__decap_3
XFILLER_167_69 VGND VGND VPWR VPWR sky130_fd_sc_hd__decap_3
XFILLER_151_225 VGND VGND VPWR VPWR sky130_fd_sc_hd__decap_3
XPHY_EDGE_ROW_131_Left_314 VGND VGND VPWR VPWR sky130_fd_sc_hd__decap_3
XFILLER_104_141 VGND VGND VPWR VPWR sky130_fd_sc_hd__decap_3
XFILLER_76_44 VGND VGND VPWR VPWR sky130_fd_sc_hd__decap_3
XFILLER_76_77 VGND VGND VPWR VPWR sky130_fd_sc_hd__decap_3
XTAP_TAPCELL_ROW_143_945 VGND VPWR sky130_fd_sc_hd__tapvpwrvgnd_1
XFILLER_132_50 VGND VGND VPWR VPWR sky130_fd_sc_hd__decap_3
XFILLER_92_21 VGND VGND VPWR VPWR sky130_fd_sc_hd__decap_3
XFILLER_92_32 VGND VGND VPWR VPWR sky130_fd_sc_hd__decap_3
XPHY_EDGE_ROW_140_Left_323 VGND VGND VPWR VPWR sky130_fd_sc_hd__decap_3
XFILLER_26_180 VGND VGND VPWR VPWR sky130_fd_sc_hd__decap_3
XFILLER_33_128 VGND VGND VPWR VPWR sky130_fd_sc_hd__decap_3
XFILLER_41_161 VGND VGND VPWR VPWR sky130_fd_sc_hd__decap_3
XFILLER_41_172 VGND VGND VPWR VPWR sky130_fd_sc_hd__decap_3
XFILLER_127_222 VGND VGND VPWR VPWR sky130_fd_sc_hd__fill_2
X_0760_ net132 net316 VGND VGND VPWR VPWR Tile_X0Y0_OpenRAM_top.Inst_OpenRAM_top_ConfigMem.Inst_frame2_bit26.Q
+ sky130_fd_sc_hd__dlxtp_1
XFILLER_142_203 VGND VGND VPWR VPWR sky130_fd_sc_hd__decap_3
X_0691_ net138 net337 VGND VGND VPWR VPWR Tile_X0Y0_OpenRAM_top.Inst_OpenRAM_top_ConfigMem.Inst_frame0_bit31.Q
+ sky130_fd_sc_hd__dlxtp_1
X_1312_ Tile_X0Y0_OpenRAM_top.Inst_OpenRAM_top_switch_matrix.N1BEG3 VGND VGND VPWR
+ VPWR net472 sky130_fd_sc_hd__clkbuf_2
XFILLER_173_90 VGND VGND VPWR VPWR sky130_fd_sc_hd__decap_3
XFILLER_110_155 VGND VGND VPWR VPWR sky130_fd_sc_hd__decap_3
X_1243_ net224 net267 VGND VGND VPWR VPWR Tile_X0Y1_OpenRAM_bot.Inst_OpenRAM_bot_ConfigMem.Inst_frame8_bit11.Q
+ sky130_fd_sc_hd__dlxtp_1
X_1174_ net229 net278 VGND VGND VPWR VPWR Tile_X0Y1_OpenRAM_bot.Inst_OpenRAM_bot_ConfigMem.Inst_frame6_bit16.Q
+ sky130_fd_sc_hd__dlxtp_1
XTAP_TAPCELL_ROW_90_730 VGND VPWR sky130_fd_sc_hd__tapvpwrvgnd_1
XFILLER_177_111 VGND VGND VPWR VPWR sky130_fd_sc_hd__fill_1
XFILLER_32_150 VGND VGND VPWR VPWR sky130_fd_sc_hd__decap_3
XFILLER_177_122 VGND VGND VPWR VPWR sky130_fd_sc_hd__decap_3
XFILLER_32_183 VGND VGND VPWR VPWR sky130_fd_sc_hd__decap_3
XFILLER_177_155 VGND VGND VPWR VPWR sky130_fd_sc_hd__decap_3
XFILLER_177_199 VGND VGND VPWR VPWR sky130_fd_sc_hd__decap_3
X_0958_ net126 net268 VGND VGND VPWR VPWR Tile_X0Y0_OpenRAM_top.Inst_OpenRAM_top_ConfigMem.Inst_frame8_bit20.Q
+ sky130_fd_sc_hd__dlxtp_1
XFILLER_21_17 VGND VGND VPWR VPWR sky130_fd_sc_hd__fill_1
XFILLER_21_39 VGND VGND VPWR VPWR sky130_fd_sc_hd__decap_3
X_0889_ net131 net282 VGND VGND VPWR VPWR Tile_X0Y0_OpenRAM_top.Inst_OpenRAM_top_ConfigMem.Inst_frame6_bit25.Q
+ sky130_fd_sc_hd__dlxtp_1
XFILLER_99_172 VGND VGND VPWR VPWR sky130_fd_sc_hd__decap_3
XFILLER_153_38 VGND VGND VPWR VPWR sky130_fd_sc_hd__decap_3
XFILLER_101_144 VGND VGND VPWR VPWR sky130_fd_sc_hd__decap_3
XFILLER_46_25 VGND VGND VPWR VPWR sky130_fd_sc_hd__decap_3
XFILLER_55_231 VGND VGND VPWR VPWR sky130_fd_sc_hd__decap_3
XFILLER_15_106 VGND VGND VPWR VPWR sky130_fd_sc_hd__decap_3
XFILLER_46_69 VGND VGND VPWR VPWR sky130_fd_sc_hd__decap_3
XFILLER_15_128 VGND VGND VPWR VPWR sky130_fd_sc_hd__decap_3
XFILLER_168_100 VGND VGND VPWR VPWR sky130_fd_sc_hd__decap_3
XFILLER_102_97 VGND VGND VPWR VPWR sky130_fd_sc_hd__decap_3
XFILLER_62_35 VGND VGND VPWR VPWR sky130_fd_sc_hd__decap_3
XFILLER_178_35 VGND VGND VPWR VPWR sky130_fd_sc_hd__decap_3
XFILLER_178_24 VGND VGND VPWR VPWR sky130_fd_sc_hd__decap_3
XFILLER_23_172 VGND VGND VPWR VPWR sky130_fd_sc_hd__fill_1
XFILLER_178_68 VGND VGND VPWR VPWR sky130_fd_sc_hd__decap_3
XFILLER_168_188 VGND VGND VPWR VPWR sky130_fd_sc_hd__decap_3
XFILLER_109_222 VGND VGND VPWR VPWR sky130_fd_sc_hd__fill_2
XFILLER_124_203 VGND VGND VPWR VPWR sky130_fd_sc_hd__decap_3
XFILLER_11_72 VGND VGND VPWR VPWR sky130_fd_sc_hd__decap_3
XFILLER_127_83 VGND VGND VPWR VPWR sky130_fd_sc_hd__decap_3
XFILLER_97_109 VGND VGND VPWR VPWR sky130_fd_sc_hd__decap_3
XFILLER_87_21 VGND VGND VPWR VPWR sky130_fd_sc_hd__decap_3
XFILLER_87_54 VGND VGND VPWR VPWR sky130_fd_sc_hd__fill_2
XFILLER_87_87 VGND VGND VPWR VPWR sky130_fd_sc_hd__decap_3
XFILLER_36_91 VGND VGND VPWR VPWR sky130_fd_sc_hd__decap_3
XFILLER_159_111 VGND VGND VPWR VPWR sky130_fd_sc_hd__fill_1
XFILLER_99_6 VGND VGND VPWR VPWR sky130_fd_sc_hd__decap_3
XFILLER_14_150 VGND VGND VPWR VPWR sky130_fd_sc_hd__decap_3
XFILLER_174_103 VGND VGND VPWR VPWR sky130_fd_sc_hd__decap_3
XFILLER_159_155 VGND VGND VPWR VPWR sky130_fd_sc_hd__decap_3
XFILLER_14_183 VGND VGND VPWR VPWR sky130_fd_sc_hd__decap_3
XFILLER_174_136 VGND VGND VPWR VPWR sky130_fd_sc_hd__decap_3
X_0812_ net142 net308 VGND VGND VPWR VPWR Tile_X0Y0_OpenRAM_top.Inst_OpenRAM_top_ConfigMem.Inst_frame3_bit6.Q
+ sky130_fd_sc_hd__dlxtp_1
Xinput11 DOUT_A_SRAM17 VGND VGND VPWR VPWR net11 sky130_fd_sc_hd__buf_2
Xinput22 DOUT_A_SRAM27 VGND VGND VPWR VPWR net22 sky130_fd_sc_hd__clkbuf_2
XFILLER_174_147 VGND VGND VPWR VPWR sky130_fd_sc_hd__decap_3
Xinput33 DOUT_A_SRAM9 VGND VGND VPWR VPWR net33 sky130_fd_sc_hd__buf_1
Xinput44 DOUT_B_SRAM18 VGND VGND VPWR VPWR net44 sky130_fd_sc_hd__buf_2
Xinput55 DOUT_B_SRAM28 VGND VGND VPWR VPWR net55 sky130_fd_sc_hd__buf_1
Xinput88 Tile_X0Y0_E6END[11] VGND VGND VPWR VPWR net88 sky130_fd_sc_hd__clkbuf_2
X_0743_ net116 net327 VGND VGND VPWR VPWR Tile_X0Y0_OpenRAM_top.Inst_OpenRAM_top_ConfigMem.Inst_frame1_bit11.Q
+ sky130_fd_sc_hd__dlxtp_1
Xinput77 Tile_X0Y0_E2END[7] VGND VGND VPWR VPWR net77 sky130_fd_sc_hd__buf_1
Xinput66 Tile_X0Y0_E1END[0] VGND VGND VPWR VPWR net66 sky130_fd_sc_hd__buf_2
Xinput99 Tile_X0Y0_EE4END[10] VGND VGND VPWR VPWR net99 sky130_fd_sc_hd__buf_1
X_0674_ net177 net212 net203 _0153_ Tile_X0Y1_OpenRAM_bot.Inst_OpenRAM_bot_ConfigMem.Inst_frame6_bit5.Q
+ Tile_X0Y1_OpenRAM_bot.Inst_OpenRAM_bot_ConfigMem.Inst_frame6_bit6.Q VGND VGND VPWR
+ VPWR _0212_ sky130_fd_sc_hd__mux4_1
XFILLER_130_206 VGND VGND VPWR VPWR sky130_fd_sc_hd__decap_3
XFILLER_88_109 VGND VGND VPWR VPWR sky130_fd_sc_hd__decap_3
XFILLER_96_153 VGND VGND VPWR VPWR sky130_fd_sc_hd__decap_3
XFILLER_37_220 VGND VGND VPWR VPWR sky130_fd_sc_hd__decap_3
X_1226_ net242 net266 VGND VGND VPWR VPWR Tile_X0Y1_OpenRAM_bot.Inst_OpenRAM_bot_ConfigMem.Inst_frame8_bit28.Q
+ sky130_fd_sc_hd__dlxtp_1
X_1157_ net233 net287 VGND VGND VPWR VPWR Tile_X0Y1_OpenRAM_bot.Inst_OpenRAM_bot_ConfigMem.Inst_frame5_bit1.Q
+ sky130_fd_sc_hd__dlxtp_1
XFILLER_12_109 VGND VGND VPWR VPWR sky130_fd_sc_hd__fill_1
X_1088_ net250 net307 VGND VGND VPWR VPWR Tile_X0Y1_OpenRAM_bot.Inst_OpenRAM_bot_ConfigMem.Inst_frame3_bit6.Q
+ sky130_fd_sc_hd__dlxtp_1
XPHY_EDGE_ROW_158_Right_158 VGND VGND VPWR VPWR sky130_fd_sc_hd__decap_3
XFILLER_20_131 VGND VGND VPWR VPWR sky130_fd_sc_hd__decap_3
XFILLER_32_38 VGND VGND VPWR VPWR sky130_fd_sc_hd__decap_3
XFILLER_165_125 VGND VGND VPWR VPWR sky130_fd_sc_hd__decap_3
XFILLER_148_38 VGND VGND VPWR VPWR sky130_fd_sc_hd__decap_3
XFILLER_148_16 VGND VGND VPWR VPWR sky130_fd_sc_hd__decap_3
XFILLER_20_153 VGND VGND VPWR VPWR sky130_fd_sc_hd__decap_3
XFILLER_165_169 VGND VGND VPWR VPWR sky130_fd_sc_hd__decap_3
XFILLER_165_158 VGND VGND VPWR VPWR sky130_fd_sc_hd__decap_3
XFILLER_20_197 VGND VGND VPWR VPWR sky130_fd_sc_hd__decap_3
XFILLER_20_186 VGND VGND VPWR VPWR sky130_fd_sc_hd__decap_3
XFILLER_180_106 VGND VGND VPWR VPWR sky130_fd_sc_hd__decap_3
XFILLER_106_203 VGND VGND VPWR VPWR sky130_fd_sc_hd__fill_2
XFILLER_180_139 VGND VGND VPWR VPWR sky130_fd_sc_hd__fill_1
XFILLER_164_15 VGND VGND VPWR VPWR sky130_fd_sc_hd__decap_3
XFILLER_106_7 VGND VGND VPWR VPWR sky130_fd_sc_hd__fill_1
XFILLER_121_217 VGND VGND VPWR VPWR sky130_fd_sc_hd__decap_3
XFILLER_87_142 VGND VGND VPWR VPWR sky130_fd_sc_hd__decap_3
XFILLER_57_57 VGND VGND VPWR VPWR sky130_fd_sc_hd__decap_3
XFILLER_180_69 VGND VGND VPWR VPWR sky130_fd_sc_hd__fill_2
XFILLER_180_58 VGND VGND VPWR VPWR sky130_fd_sc_hd__decap_3
XFILLER_113_30 VGND VGND VPWR VPWR sky130_fd_sc_hd__decap_3
XFILLER_113_52 VGND VGND VPWR VPWR sky130_fd_sc_hd__decap_3
XTAP_TAPCELL_ROW_3_385 VGND VPWR sky130_fd_sc_hd__tapvpwrvgnd_1
XFILLER_43_201 VGND VGND VPWR VPWR sky130_fd_sc_hd__decap_3
XFILLER_73_34 VGND VGND VPWR VPWR sky130_fd_sc_hd__decap_3
XPHY_EDGE_ROW_125_Right_125 VGND VGND VPWR VPWR sky130_fd_sc_hd__decap_3
XTAP_TAPCELL_ROW_26_476 VGND VPWR sky130_fd_sc_hd__tapvpwrvgnd_1
XFILLER_11_131 VGND VGND VPWR VPWR sky130_fd_sc_hd__decap_3
XFILLER_156_136 VGND VGND VPWR VPWR sky130_fd_sc_hd__decap_3
XFILLER_156_103 VGND VGND VPWR VPWR sky130_fd_sc_hd__decap_3
XFILLER_11_164 VGND VGND VPWR VPWR sky130_fd_sc_hd__decap_3
XFILLER_7_113 VGND VGND VPWR VPWR sky130_fd_sc_hd__decap_3
XFILLER_7_102 VGND VGND VPWR VPWR sky130_fd_sc_hd__decap_3
XFILLER_156_147 VGND VGND VPWR VPWR sky130_fd_sc_hd__decap_3
XFILLER_7_146 VGND VGND VPWR VPWR sky130_fd_sc_hd__decap_3
XFILLER_171_128 VGND VGND VPWR VPWR sky130_fd_sc_hd__decap_3
XFILLER_22_82 VGND VGND VPWR VPWR sky130_fd_sc_hd__fill_2
XFILLER_112_206 VGND VGND VPWR VPWR sky130_fd_sc_hd__fill_1
XFILLER_98_64 VGND VGND VPWR VPWR sky130_fd_sc_hd__decap_3
XFILLER_112_228 VGND VGND VPWR VPWR sky130_fd_sc_hd__fill_2
XFILLER_98_97 VGND VGND VPWR VPWR sky130_fd_sc_hd__decap_3
XFILLER_78_120 VGND VGND VPWR VPWR sky130_fd_sc_hd__decap_3
X_0390_ net13 net45 Tile_X0Y0_OpenRAM_top.Inst_OpenRAM_top_switch_matrix.J_NS4_BEG12
+ Tile_X0Y0_OpenRAM_top.Inst_OpenRAM_top_switch_matrix.J_NS2_BEG4 Tile_X0Y0_OpenRAM_top.Inst_OpenRAM_top_ConfigMem.Inst_frame4_bit2.Q
+ Tile_X0Y0_OpenRAM_top.Inst_OpenRAM_top_ConfigMem.Inst_frame4_bit3.Q VGND VGND VPWR
+ VPWR Tile_X0Y0_OpenRAM_top.Inst_OpenRAM_top_switch_matrix.WW4BEG3 sky130_fd_sc_hd__mux4_1
XFILLER_78_153 VGND VGND VPWR VPWR sky130_fd_sc_hd__decap_3
XTAP_TAPCELL_ROW_166_1034 VGND VPWR sky130_fd_sc_hd__tapvpwrvgnd_1
XFILLER_78_186 VGND VGND VPWR VPWR sky130_fd_sc_hd__decap_3
XFILLER_93_101 VGND VGND VPWR VPWR sky130_fd_sc_hd__decap_3
XFILLER_19_220 VGND VGND VPWR VPWR sky130_fd_sc_hd__decap_3
XFILLER_93_134 VGND VGND VPWR VPWR sky130_fd_sc_hd__decap_3
X_1011_ net232 net324 VGND VGND VPWR VPWR Tile_X0Y1_OpenRAM_bot.Inst_OpenRAM_bot_ConfigMem.Inst_frame1_bit19.Q
+ sky130_fd_sc_hd__dlxtp_1
XTAP_TAPCELL_ROW_49_568 VGND VPWR sky130_fd_sc_hd__tapvpwrvgnd_1
XFILLER_170_91 VGND VGND VPWR VPWR sky130_fd_sc_hd__decap_3
XFILLER_170_80 VGND VGND VPWR VPWR sky130_fd_sc_hd__decap_3
XFILLER_179_228 VGND VGND VPWR VPWR sky130_fd_sc_hd__fill_2
XFILLER_179_206 VGND VGND VPWR VPWR sky130_fd_sc_hd__decap_3
XFILLER_97_3 VGND VGND VPWR VPWR sky130_fd_sc_hd__decap_3
XFILLER_147_125 VGND VGND VPWR VPWR sky130_fd_sc_hd__decap_3
XFILLER_147_158 VGND VGND VPWR VPWR sky130_fd_sc_hd__decap_3
XFILLER_8_62 VGND VGND VPWR VPWR sky130_fd_sc_hd__decap_3
XFILLER_162_139 VGND VGND VPWR VPWR sky130_fd_sc_hd__fill_1
X_0726_ net134 net326 VGND VGND VPWR VPWR Tile_X0Y0_OpenRAM_top.Inst_OpenRAM_top_ConfigMem.Inst_frame1_bit28.Q
+ sky130_fd_sc_hd__dlxtp_1
XFILLER_170_150 VGND VGND VPWR VPWR sky130_fd_sc_hd__decap_3
XFILLER_170_183 VGND VGND VPWR VPWR sky130_fd_sc_hd__decap_3
XFILLER_103_228 VGND VGND VPWR VPWR sky130_fd_sc_hd__fill_2
XFILLER_103_217 VGND VGND VPWR VPWR sky130_fd_sc_hd__decap_3
X_0657_ _0194_ _0196_ _0197_ Tile_X0Y1_OpenRAM_bot.Inst_OpenRAM_bot_ConfigMem.Inst_frame7_bit30.Q
+ VGND VGND VPWR VPWR Tile_X0Y1_OpenRAM_bot.Inst_OpenRAM_bot_switch_matrix.S4BEG0
+ sky130_fd_sc_hd__o22a_1
XFILLER_69_131 VGND VGND VPWR VPWR sky130_fd_sc_hd__decap_3
X_0588_ net186 Tile_X0Y1_OpenRAM_bot.Inst_OpenRAM_bot_ConfigMem.Inst_frame3_bit20.Q
+ Tile_X0Y1_OpenRAM_bot.Inst_OpenRAM_bot_ConfigMem.Inst_frame3_bit21.Q VGND VGND VPWR
+ VPWR _0157_ sky130_fd_sc_hd__o21ba_1
XFILLER_69_164 VGND VGND VPWR VPWR sky130_fd_sc_hd__decap_3
XFILLER_69_175 VGND VGND VPWR VPWR sky130_fd_sc_hd__decap_3
XFILLER_27_27 VGND VGND VPWR VPWR sky130_fd_sc_hd__decap_3
XFILLER_27_49 VGND VGND VPWR VPWR sky130_fd_sc_hd__decap_3
X_1209_ net226 net270 VGND VGND VPWR VPWR Tile_X0Y1_OpenRAM_bot.Inst_OpenRAM_bot_ConfigMem.Inst_frame7_bit13.Q
+ sky130_fd_sc_hd__dlxtp_1
XFILLER_84_156 VGND VGND VPWR VPWR sky130_fd_sc_hd__decap_3
XFILLER_84_189 VGND VGND VPWR VPWR sky130_fd_sc_hd__decap_3
XTAP_TAPCELL_ROW_0_366 VGND VPWR sky130_fd_sc_hd__tapvpwrvgnd_1
XFILLER_43_37 VGND VGND VPWR VPWR sky130_fd_sc_hd__decap_3
XFILLER_138_125 VGND VGND VPWR VPWR sky130_fd_sc_hd__decap_3
XFILLER_138_103 VGND VGND VPWR VPWR sky130_fd_sc_hd__fill_1
XFILLER_138_147 VGND VGND VPWR VPWR sky130_fd_sc_hd__decap_3
XFILLER_175_36 VGND VGND VPWR VPWR sky130_fd_sc_hd__decap_3
XFILLER_153_139 VGND VGND VPWR VPWR sky130_fd_sc_hd__decap_3
XFILLER_4_127 VGND VGND VPWR VPWR sky130_fd_sc_hd__decap_3
XFILLER_175_69 VGND VGND VPWR VPWR sky130_fd_sc_hd__decap_3
XFILLER_161_172 VGND VGND VPWR VPWR sky130_fd_sc_hd__decap_3
XFILLER_68_23 VGND VGND VPWR VPWR sky130_fd_sc_hd__decap_3
Xinput201 Tile_X0Y1_E6END[5] VGND VGND VPWR VPWR net201 sky130_fd_sc_hd__clkbuf_2
Xinput212 Tile_X0Y1_EE4END[15] VGND VGND VPWR VPWR net212 sky130_fd_sc_hd__buf_1
Xinput223 Tile_X0Y1_FrameData[10] VGND VGND VPWR VPWR net223 sky130_fd_sc_hd__buf_4
Xinput234 Tile_X0Y1_FrameData[20] VGND VGND VPWR VPWR net234 sky130_fd_sc_hd__clkbuf_4
Xinput245 Tile_X0Y1_FrameData[30] VGND VGND VPWR VPWR net245 sky130_fd_sc_hd__clkbuf_4
XFILLER_124_62 VGND VGND VPWR VPWR sky130_fd_sc_hd__decap_3
Xinput278 Tile_X0Y1_N4END[4] VGND VGND VPWR VPWR net361 sky130_fd_sc_hd__clkbuf_4
Xinput267 Tile_X0Y1_N2MID[1] VGND VGND VPWR VPWR net350 sky130_fd_sc_hd__buf_2
Xinput256 Tile_X0Y1_N1END[2] VGND VGND VPWR VPWR net339 sky130_fd_sc_hd__buf_2
XFILLER_75_167 VGND VGND VPWR VPWR sky130_fd_sc_hd__fill_1
XFILLER_16_212 VGND VGND VPWR VPWR sky130_fd_sc_hd__decap_3
XFILLER_84_88 VGND VGND VPWR VPWR sky130_fd_sc_hd__decap_3
XFILLER_17_60 VGND VGND VPWR VPWR sky130_fd_sc_hd__decap_3
XFILLER_90_148 VGND VGND VPWR VPWR sky130_fd_sc_hd__decap_3
XFILLER_17_93 VGND VGND VPWR VPWR sky130_fd_sc_hd__decap_3
XFILLER_176_209 VGND VGND VPWR VPWR sky130_fd_sc_hd__decap_3
XFILLER_83_9 VGND VGND VPWR VPWR sky130_fd_sc_hd__decap_3
XFILLER_129_158 VGND VGND VPWR VPWR sky130_fd_sc_hd__decap_3
XFILLER_33_81 VGND VGND VPWR VPWR sky130_fd_sc_hd__decap_3
XFILLER_149_81 VGND VGND VPWR VPWR sky130_fd_sc_hd__decap_3
XFILLER_129_169 VGND VGND VPWR VPWR sky130_fd_sc_hd__fill_2
XTAP_TAPCELL_ROW_172_1060 VGND VPWR sky130_fd_sc_hd__tapvpwrvgnd_1
X_0511_ net339 net359 _0070_ net172 Tile_X0Y1_OpenRAM_bot.Inst_OpenRAM_bot_ConfigMem.Inst_frame0_bit4.Q
+ Tile_X0Y1_OpenRAM_bot.Inst_OpenRAM_bot_ConfigMem.Inst_frame0_bit5.Q VGND VGND VPWR
+ VPWR Tile_X0Y1_OpenRAM_bot.Inst_OpenRAM_bot_switch_matrix.J_NS4_BEG14 sky130_fd_sc_hd__mux4_2
XFILLER_98_215 VGND VGND VPWR VPWR sky130_fd_sc_hd__decap_3
X_1491_ Tile_X0Y1_OpenRAM_bot.Inst_OpenRAM_bot_switch_matrix.W6BEG9 VGND VGND VPWR
+ VPWR net653 sky130_fd_sc_hd__buf_1
X_0442_ net69 net111 net104 Tile_X0Y0_OpenRAM_top.Inst_OpenRAM_top_switch_matrix.J_NS4_BEG15
+ Tile_X0Y0_OpenRAM_top.Inst_OpenRAM_top_ConfigMem.Inst_frame2_bit18.Q Tile_X0Y0_OpenRAM_top.Inst_OpenRAM_top_ConfigMem.Inst_frame2_bit19.Q
+ VGND VGND VPWR VPWR net410 sky130_fd_sc_hd__mux4_1
XFILLER_3_193 VGND VGND VPWR VPWR sky130_fd_sc_hd__decap_3
X_0373_ net13 net45 Tile_X0Y0_OpenRAM_top.Inst_OpenRAM_top_switch_matrix.J_NS2_BEG3
+ Tile_X0Y0_OpenRAM_top.Inst_OpenRAM_top_switch_matrix.J_NS2_BEG4 Tile_X0Y0_OpenRAM_top.Inst_OpenRAM_top_ConfigMem.Inst_frame5_bit2.Q
+ Tile_X0Y0_OpenRAM_top.Inst_OpenRAM_top_ConfigMem.Inst_frame5_bit3.Q VGND VGND VPWR
+ VPWR Tile_X0Y0_OpenRAM_top.Inst_OpenRAM_top_switch_matrix.W2BEG3 sky130_fd_sc_hd__mux4_1
XFILLER_81_137 VGND VGND VPWR VPWR sky130_fd_sc_hd__decap_3
XTAP_TAPCELL_ROW_104_789 VGND VPWR sky130_fd_sc_hd__tapvpwrvgnd_1
XFILLER_13_18 VGND VGND VPWR VPWR sky130_fd_sc_hd__decap_3
XFILLER_175_220 VGND VGND VPWR VPWR sky130_fd_sc_hd__decap_3
XFILLER_135_128 VGND VGND VPWR VPWR sky130_fd_sc_hd__decap_3
XFILLER_128_180 VGND VGND VPWR VPWR sky130_fd_sc_hd__decap_3
XFILLER_150_109 VGND VGND VPWR VPWR sky130_fd_sc_hd__fill_1
XFILLER_145_39 VGND VGND VPWR VPWR sky130_fd_sc_hd__decap_3
XFILLER_143_172 VGND VGND VPWR VPWR sky130_fd_sc_hd__decap_3
XFILLER_143_161 VGND VGND VPWR VPWR sky130_fd_sc_hd__decap_3
X_0709_ net118 net334 VGND VGND VPWR VPWR Tile_X0Y0_OpenRAM_top.Inst_OpenRAM_top_ConfigMem.Inst_frame0_bit13.Q
+ sky130_fd_sc_hd__dlxtp_1
XFILLER_89_215 VGND VGND VPWR VPWR sky130_fd_sc_hd__decap_3
XFILLER_143_194 VGND VGND VPWR VPWR sky130_fd_sc_hd__decap_3
XFILLER_161_49 VGND VGND VPWR VPWR sky130_fd_sc_hd__decap_3
XFILLER_54_14 VGND VGND VPWR VPWR sky130_fd_sc_hd__decap_3
XFILLER_72_126 VGND VGND VPWR VPWR sky130_fd_sc_hd__decap_3
XFILLER_54_47 VGND VGND VPWR VPWR sky130_fd_sc_hd__decap_3
XFILLER_72_159 VGND VGND VPWR VPWR sky130_fd_sc_hd__decap_3
XFILLER_80_170 VGND VGND VPWR VPWR sky130_fd_sc_hd__decap_3
XFILLER_158_209 VGND VGND VPWR VPWR sky130_fd_sc_hd__decap_3
XFILLER_9_208 VGND VGND VPWR VPWR sky130_fd_sc_hd__decap_3
XFILLER_70_24 VGND VGND VPWR VPWR sky130_fd_sc_hd__decap_3
XTAP_TAPCELL_ROW_11_416 VGND VPWR sky130_fd_sc_hd__tapvpwrvgnd_1
XTAP_TAPCELL_ROW_51_574 VGND VPWR sky130_fd_sc_hd__tapvpwrvgnd_1
XFILLER_70_79 VGND VGND VPWR VPWR sky130_fd_sc_hd__decap_3
XFILLER_119_95 VGND VGND VPWR VPWR sky130_fd_sc_hd__decap_3
XFILLER_79_55 VGND VGND VPWR VPWR sky130_fd_sc_hd__fill_1
XFILLER_135_72 VGND VGND VPWR VPWR sky130_fd_sc_hd__decap_3
XFILLER_48_123 VGND VGND VPWR VPWR sky130_fd_sc_hd__decap_3
XFILLER_95_54 VGND VGND VPWR VPWR sky130_fd_sc_hd__fill_2
XFILLER_48_156 VGND VGND VPWR VPWR sky130_fd_sc_hd__decap_3
XFILLER_28_81 VGND VGND VPWR VPWR sky130_fd_sc_hd__decap_3
XFILLER_48_189 VGND VGND VPWR VPWR sky130_fd_sc_hd__decap_3
XFILLER_151_93 VGND VGND VPWR VPWR sky130_fd_sc_hd__decap_3
XFILLER_63_148 VGND VGND VPWR VPWR sky130_fd_sc_hd__decap_3
XTAP_TAPCELL_ROW_74_666 VGND VPWR sky130_fd_sc_hd__tapvpwrvgnd_1
XPHY_EDGE_ROW_17_Left_200 VGND VGND VPWR VPWR sky130_fd_sc_hd__decap_3
XTAP_TAPCELL_ROW_34_508 VGND VPWR sky130_fd_sc_hd__tapvpwrvgnd_1
X_0991_ net251 net330 VGND VGND VPWR VPWR Tile_X0Y1_OpenRAM_bot.Inst_OpenRAM_bot_ConfigMem.Inst_frame0_bit7.Q
+ sky130_fd_sc_hd__dlxtp_1
XTAP_TAPCELL_ROW_42_541 VGND VPWR sky130_fd_sc_hd__tapvpwrvgnd_1
XFILLER_44_91 VGND VGND VPWR VPWR sky130_fd_sc_hd__decap_3
XFILLER_8_230 VGND VGND VPWR VPWR sky130_fd_sc_hd__fill_1
XFILLER_81_6 VGND VGND VPWR VPWR sky130_fd_sc_hd__decap_3
XFILLER_172_212 VGND VGND VPWR VPWR sky130_fd_sc_hd__decap_3
XFILLER_117_128 VGND VGND VPWR VPWR sky130_fd_sc_hd__decap_3
XFILLER_5_30 VGND VGND VPWR VPWR sky130_fd_sc_hd__decap_3
Xoutput516 net599 VGND VGND VPWR VPWR Tile_X0Y1_S2BEGb[1] sky130_fd_sc_hd__buf_2
Xoutput505 net588 VGND VGND VPWR VPWR Tile_X0Y1_S1BEG[2] sky130_fd_sc_hd__buf_2
Xoutput527 net610 VGND VGND VPWR VPWR Tile_X0Y1_S4BEG[13] sky130_fd_sc_hd__buf_2
XFILLER_125_172 VGND VGND VPWR VPWR sky130_fd_sc_hd__decap_3
Xoutput549 net632 VGND VGND VPWR VPWR Tile_X0Y1_W2BEG[6] sky130_fd_sc_hd__buf_2
XFILLER_5_63 VGND VGND VPWR VPWR sky130_fd_sc_hd__decap_3
Xoutput538 net621 VGND VGND VPWR VPWR Tile_X0Y1_S4BEG[9] sky130_fd_sc_hd__buf_2
XFILLER_5_96 VGND VGND VPWR VPWR sky130_fd_sc_hd__decap_3
X_1474_ Tile_X0Y1_OpenRAM_bot.Inst_OpenRAM_bot_switch_matrix.W2BEGb0 VGND VGND VPWR
+ VPWR net634 sky130_fd_sc_hd__clkbuf_1
XFILLER_140_175 VGND VGND VPWR VPWR sky130_fd_sc_hd__decap_3
X_0425_ net49 Tile_X0Y0_OpenRAM_top.Inst_OpenRAM_top_switch_matrix.J_NS4_BEG1 Tile_X0Y0_OpenRAM_top.Inst_OpenRAM_top_switch_matrix.J_NS4_BEG5
+ Tile_X0Y0_OpenRAM_top.Inst_OpenRAM_top_switch_matrix.J_NS2_BEG6 Tile_X0Y0_OpenRAM_top.Inst_OpenRAM_top_ConfigMem.Inst_frame3_bit16.Q
+ Tile_X0Y0_OpenRAM_top.Inst_OpenRAM_top_ConfigMem.Inst_frame3_bit17.Q VGND VGND VPWR
+ VPWR Tile_X0Y0_OpenRAM_top.Inst_OpenRAM_top_switch_matrix.W6BEG10 sky130_fd_sc_hd__mux4_1
XFILLER_86_218 VGND VGND VPWR VPWR sky130_fd_sc_hd__decap_3
XFILLER_140_197 VGND VGND VPWR VPWR sky130_fd_sc_hd__decap_3
XTAP_TAPCELL_ROW_97_758 VGND VPWR sky130_fd_sc_hd__tapvpwrvgnd_1
X_0356_ Tile_X0Y0_OpenRAM_top.Inst_OpenRAM_top_switch_matrix.N2BEGb7 net165 net356
+ net157 Tile_X0Y0_OpenRAM_top.Inst_OpenRAM_top_ConfigMem.Inst_frame0_bit23.Q Tile_X0Y0_OpenRAM_top.Inst_OpenRAM_top_ConfigMem.Inst_frame0_bit22.Q
+ VGND VGND VPWR VPWR Tile_X0Y0_OpenRAM_top.Inst_OpenRAM_top_switch_matrix.J_NS2_BEG7
+ sky130_fd_sc_hd__mux4_2
XFILLER_39_178 VGND VGND VPWR VPWR sky130_fd_sc_hd__decap_3
XFILLER_54_115 VGND VGND VPWR VPWR sky130_fd_sc_hd__decap_3
X_0287_ _0045_ _0055_ VGND VGND VPWR VPWR _0056_ sky130_fd_sc_hd__nand2_1
XFILLER_54_159 VGND VGND VPWR VPWR sky130_fd_sc_hd__decap_3
XTAP_TAPCELL_ROW_65_633 VGND VPWR sky130_fd_sc_hd__tapvpwrvgnd_1
XTAP_TAPCELL_ROW_179_1088 VGND VPWR sky130_fd_sc_hd__tapvpwrvgnd_1
XFILLER_10_218 VGND VGND VPWR VPWR sky130_fd_sc_hd__decap_3
XFILLER_108_106 VGND VGND VPWR VPWR sky130_fd_sc_hd__decap_3
XTAP_TAPCELL_ROW_100_770 VGND VPWR sky130_fd_sc_hd__tapvpwrvgnd_1
XFILLER_40_16 VGND VGND VPWR VPWR sky130_fd_sc_hd__decap_3
XFILLER_108_139 VGND VGND VPWR VPWR sky130_fd_sc_hd__fill_1
XFILLER_156_38 VGND VGND VPWR VPWR sky130_fd_sc_hd__decap_3
XFILLER_116_150 VGND VGND VPWR VPWR sky130_fd_sc_hd__decap_3
XFILLER_116_194 VGND VGND VPWR VPWR sky130_fd_sc_hd__fill_2
XFILLER_116_183 VGND VGND VPWR VPWR sky130_fd_sc_hd__decap_3
XFILLER_49_25 VGND VGND VPWR VPWR sky130_fd_sc_hd__decap_3
XFILLER_49_36 VGND VGND VPWR VPWR sky130_fd_sc_hd__decap_3
XFILLER_172_15 VGND VGND VPWR VPWR sky130_fd_sc_hd__decap_3
XFILLER_131_142 VGND VGND VPWR VPWR sky130_fd_sc_hd__decap_3
XFILLER_49_69 VGND VGND VPWR VPWR sky130_fd_sc_hd__decap_3
XTAP_TAPCELL_ROW_88_725 VGND VPWR sky130_fd_sc_hd__tapvpwrvgnd_1
XFILLER_172_59 VGND VGND VPWR VPWR sky130_fd_sc_hd__decap_3
XFILLER_105_42 VGND VGND VPWR VPWR sky130_fd_sc_hd__decap_3
XFILLER_105_75 VGND VGND VPWR VPWR sky130_fd_sc_hd__fill_1
XFILLER_65_24 VGND VGND VPWR VPWR sky130_fd_sc_hd__decap_3
XFILLER_65_57 VGND VGND VPWR VPWR sky130_fd_sc_hd__decap_3
XFILLER_121_30 VGND VGND VPWR VPWR sky130_fd_sc_hd__decap_3
XFILLER_60_118 VGND VGND VPWR VPWR sky130_fd_sc_hd__decap_3
XTAP_TAPCELL_ROW_123_862 VGND VPWR sky130_fd_sc_hd__tapvpwrvgnd_1
XFILLER_121_63 VGND VGND VPWR VPWR sky130_fd_sc_hd__decap_3
XFILLER_53_181 VGND VGND VPWR VPWR sky130_fd_sc_hd__decap_3
XFILLER_81_23 VGND VGND VPWR VPWR sky130_fd_sc_hd__decap_3
XFILLER_154_223 VGND VGND VPWR VPWR sky130_fd_sc_hd__decap_3
XFILLER_5_211 VGND VGND VPWR VPWR sky130_fd_sc_hd__decap_3
XFILLER_30_71 VGND VGND VPWR VPWR sky130_fd_sc_hd__decap_3
XFILLER_107_194 VGND VGND VPWR VPWR sky130_fd_sc_hd__decap_3
XFILLER_122_153 VGND VGND VPWR VPWR sky130_fd_sc_hd__decap_3
XFILLER_68_218 VGND VGND VPWR VPWR sky130_fd_sc_hd__decap_3
XFILLER_122_197 VGND VGND VPWR VPWR sky130_fd_sc_hd__decap_3
X_1190_ net222 net281 VGND VGND VPWR VPWR Tile_X0Y1_OpenRAM_bot.Inst_OpenRAM_bot_ConfigMem.Inst_frame6_bit0.Q
+ sky130_fd_sc_hd__dlxtp_1
XTAP_TAPCELL_ROW_146_954 VGND VPWR sky130_fd_sc_hd__tapvpwrvgnd_1
Xinput9 DOUT_A_SRAM15 VGND VGND VPWR VPWR net9 sky130_fd_sc_hd__buf_1
XFILLER_36_115 VGND VGND VPWR VPWR sky130_fd_sc_hd__decap_3
XFILLER_36_159 VGND VGND VPWR VPWR sky130_fd_sc_hd__decap_3
X_0974_ net238 net332 VGND VGND VPWR VPWR Tile_X0Y1_OpenRAM_bot.Inst_OpenRAM_bot_ConfigMem.Inst_frame0_bit24.Q
+ sky130_fd_sc_hd__dlxtp_1
XFILLER_145_201 VGND VGND VPWR VPWR sky130_fd_sc_hd__decap_3
XFILLER_160_215 VGND VGND VPWR VPWR sky130_fd_sc_hd__decap_3
Xoutput335 net418 VGND VGND VPWR VPWR Tile_X0Y0_FrameData_O[10] sky130_fd_sc_hd__buf_2
Xoutput324 net407 VGND VGND VPWR VPWR DIN_A_SRAM29 sky130_fd_sc_hd__buf_2
XFILLER_105_109 VGND VGND VPWR VPWR sky130_fd_sc_hd__decap_3
Xoutput313 net396 VGND VGND VPWR VPWR DIN_A_SRAM19 sky130_fd_sc_hd__buf_2
Xoutput302 net385 VGND VGND VPWR VPWR DIN_A_SRAM0 sky130_fd_sc_hd__buf_2
Xoutput368 net451 VGND VGND VPWR VPWR Tile_X0Y0_FrameStrobe_O[11] sky130_fd_sc_hd__buf_2
Xoutput357 net440 VGND VGND VPWR VPWR Tile_X0Y0_FrameData_O[30] sky130_fd_sc_hd__buf_2
Xoutput346 net429 VGND VGND VPWR VPWR Tile_X0Y0_FrameData_O[20] sky130_fd_sc_hd__buf_2
XFILLER_113_131 VGND VGND VPWR VPWR sky130_fd_sc_hd__decap_3
Xoutput379 net462 VGND VGND VPWR VPWR Tile_X0Y0_FrameStrobe_O[3] sky130_fd_sc_hd__buf_2
XFILLER_59_218 VGND VGND VPWR VPWR sky130_fd_sc_hd__decap_3
X_1457_ Tile_X0Y0_OpenRAM_top.Inst_OpenRAM_top_switch_matrix.S4BEG3 VGND VGND VPWR
+ VPWR net608 sky130_fd_sc_hd__buf_4
XFILLER_113_175 VGND VGND VPWR VPWR sky130_fd_sc_hd__decap_3
XFILLER_19_17 VGND VGND VPWR VPWR sky130_fd_sc_hd__decap_3
XTAP_TAPCELL_ROW_137_921 VGND VPWR sky130_fd_sc_hd__tapvpwrvgnd_1
X_1388_ Tile_X0Y0_OpenRAM_top.Inst_OpenRAM_top_switch_matrix.WW4BEG10 VGND VGND VPWR
+ VPWR net539 sky130_fd_sc_hd__clkbuf_2
X_0408_ net23 net55 _0095_ net256 Tile_X0Y0_OpenRAM_top.Inst_OpenRAM_top_ConfigMem.Inst_frame4_bit20.Q
+ Tile_X0Y0_OpenRAM_top.Inst_OpenRAM_top_ConfigMem.Inst_frame4_bit21.Q VGND VGND VPWR
+ VPWR Tile_X0Y0_OpenRAM_top.Inst_OpenRAM_top_switch_matrix.WW4BEG12 sky130_fd_sc_hd__mux4_1
X_0339_ net353 net345 Tile_X0Y0_OpenRAM_top.Inst_OpenRAM_top_switch_matrix.S2BEG4
+ net162 Tile_X0Y1_OpenRAM_bot.Inst_OpenRAM_bot_ConfigMem.Inst_frame0_bit16.Q Tile_X0Y1_OpenRAM_bot.Inst_OpenRAM_bot_ConfigMem.Inst_frame0_bit17.Q
+ VGND VGND VPWR VPWR _0084_ sky130_fd_sc_hd__mux4_2
XFILLER_27_137 VGND VGND VPWR VPWR sky130_fd_sc_hd__decap_3
XTAP_TAPCELL_ROW_152_979 VGND VPWR sky130_fd_sc_hd__tapvpwrvgnd_1
XFILLER_35_27 VGND VGND VPWR VPWR sky130_fd_sc_hd__decap_3
XFILLER_35_181 VGND VGND VPWR VPWR sky130_fd_sc_hd__decap_3
XFILLER_167_15 VGND VGND VPWR VPWR sky130_fd_sc_hd__decap_3
XFILLER_167_48 VGND VGND VPWR VPWR sky130_fd_sc_hd__decap_3
XFILLER_151_215 VGND VGND VPWR VPWR sky130_fd_sc_hd__decap_3
XFILLER_2_203 VGND VGND VPWR VPWR sky130_fd_sc_hd__decap_3
XFILLER_116_41 VGND VGND VPWR VPWR sky130_fd_sc_hd__decap_3
XFILLER_116_85 VGND VGND VPWR VPWR sky130_fd_sc_hd__decap_3
XFILLER_116_74 VGND VGND VPWR VPWR sky130_fd_sc_hd__decap_3
XFILLER_76_12 VGND VGND VPWR VPWR sky130_fd_sc_hd__decap_3
XFILLER_76_56 VGND VGND VPWR VPWR sky130_fd_sc_hd__decap_3
XFILLER_132_62 VGND VGND VPWR VPWR sky130_fd_sc_hd__decap_3
XFILLER_18_126 VGND VGND VPWR VPWR sky130_fd_sc_hd__fill_2
XFILLER_73_221 VGND VGND VPWR VPWR sky130_fd_sc_hd__decap_3
XFILLER_92_44 VGND VGND VPWR VPWR sky130_fd_sc_hd__decap_3
XFILLER_92_55 VGND VGND VPWR VPWR sky130_fd_sc_hd__decap_3
XFILLER_25_60 VGND VGND VPWR VPWR sky130_fd_sc_hd__decap_3
XFILLER_26_192 VGND VGND VPWR VPWR sky130_fd_sc_hd__decap_3
XFILLER_41_140 VGND VGND VPWR VPWR sky130_fd_sc_hd__decap_3
XFILLER_41_184 VGND VGND VPWR VPWR sky130_fd_sc_hd__decap_3
X_0690_ Tile_X0Y1_OpenRAM_bot.Inst_OpenRAM_bot_ConfigMem.Inst_frame3_bit15.Q _0225_
+ _0226_ _0216_ VGND VGND VPWR VPWR net670 sky130_fd_sc_hd__o22a_1
XFILLER_157_81 VGND VGND VPWR VPWR sky130_fd_sc_hd__decap_3
X_1311_ Tile_X0Y0_OpenRAM_top.Inst_OpenRAM_top_switch_matrix.N1BEG2 VGND VGND VPWR
+ VPWR net471 sky130_fd_sc_hd__clkbuf_2
XPHY_EDGE_ROW_10_Right_10 VGND VGND VPWR VPWR sky130_fd_sc_hd__decap_3
X_1242_ net225 net264 VGND VGND VPWR VPWR Tile_X0Y1_OpenRAM_bot.Inst_OpenRAM_bot_ConfigMem.Inst_frame8_bit12.Q
+ sky130_fd_sc_hd__dlxtp_1
XFILLER_2_64 VGND VGND VPWR VPWR sky130_fd_sc_hd__decap_3
XPHY_EDGE_ROW_139_Right_139 VGND VGND VPWR VPWR sky130_fd_sc_hd__decap_3
XFILLER_2_97 VGND VGND VPWR VPWR sky130_fd_sc_hd__decap_3
X_1173_ net230 net278 VGND VGND VPWR VPWR Tile_X0Y1_OpenRAM_bot.Inst_OpenRAM_bot_ConfigMem.Inst_frame6_bit17.Q
+ sky130_fd_sc_hd__dlxtp_1
XFILLER_64_221 VGND VGND VPWR VPWR sky130_fd_sc_hd__decap_3
XFILLER_24_129 VGND VGND VPWR VPWR sky130_fd_sc_hd__fill_2
XTAP_TAPCELL_ROW_90_731 VGND VPWR sky130_fd_sc_hd__tapvpwrvgnd_1
XFILLER_177_134 VGND VGND VPWR VPWR sky130_fd_sc_hd__decap_3
XFILLER_32_162 VGND VGND VPWR VPWR sky130_fd_sc_hd__decap_3
XFILLER_177_178 VGND VGND VPWR VPWR sky130_fd_sc_hd__decap_3
XFILLER_177_167 VGND VGND VPWR VPWR sky130_fd_sc_hd__fill_1
XFILLER_32_195 VGND VGND VPWR VPWR sky130_fd_sc_hd__fill_1
X_0957_ net127 net268 VGND VGND VPWR VPWR Tile_X0Y0_OpenRAM_top.Inst_OpenRAM_top_ConfigMem.Inst_frame8_bit21.Q
+ sky130_fd_sc_hd__dlxtp_1
X_0888_ net132 net283 VGND VGND VPWR VPWR Tile_X0Y0_OpenRAM_top.Inst_OpenRAM_top_ConfigMem.Inst_frame6_bit26.Q
+ sky130_fd_sc_hd__dlxtp_1
XFILLER_99_162 VGND VGND VPWR VPWR sky130_fd_sc_hd__decap_3
XFILLER_101_123 VGND VGND VPWR VPWR sky130_fd_sc_hd__decap_3
XFILLER_99_184 VGND VGND VPWR VPWR sky130_fd_sc_hd__decap_3
X_1509_ Tile_X0Y1_OpenRAM_bot.Inst_OpenRAM_bot_switch_matrix.WW4BEG15 VGND VGND VPWR
+ VPWR net660 sky130_fd_sc_hd__buf_1
XPHY_EDGE_ROW_106_Right_106 VGND VGND VPWR VPWR sky130_fd_sc_hd__decap_3
XFILLER_55_210 VGND VGND VPWR VPWR sky130_fd_sc_hd__decap_3
XFILLER_102_32 VGND VGND VPWR VPWR sky130_fd_sc_hd__decap_3
XFILLER_168_112 VGND VGND VPWR VPWR sky130_fd_sc_hd__decap_3
XFILLER_62_47 VGND VGND VPWR VPWR sky130_fd_sc_hd__decap_3
XFILLER_62_69 VGND VGND VPWR VPWR sky130_fd_sc_hd__decap_3
XFILLER_178_47 VGND VGND VPWR VPWR sky130_fd_sc_hd__decap_3
XFILLER_168_167 VGND VGND VPWR VPWR sky130_fd_sc_hd__decap_3
XFILLER_127_3 VGND VGND VPWR VPWR sky130_fd_sc_hd__decap_3
XFILLER_11_40 VGND VGND VPWR VPWR sky130_fd_sc_hd__decap_3
XFILLER_127_40 VGND VGND VPWR VPWR sky130_fd_sc_hd__decap_3
XFILLER_11_84 VGND VGND VPWR VPWR sky130_fd_sc_hd__decap_3
XFILLER_87_33 VGND VGND VPWR VPWR sky130_fd_sc_hd__decap_3
XFILLER_87_66 VGND VGND VPWR VPWR sky130_fd_sc_hd__decap_3
XFILLER_87_99 VGND VGND VPWR VPWR sky130_fd_sc_hd__decap_3
XFILLER_143_72 VGND VGND VPWR VPWR sky130_fd_sc_hd__decap_3
XTAP_TAPCELL_ROW_6_394 VGND VPWR sky130_fd_sc_hd__tapvpwrvgnd_1
XFILLER_46_232 VGND VGND VPWR VPWR sky130_fd_sc_hd__fill_2
XFILLER_159_134 VGND VGND VPWR VPWR sky130_fd_sc_hd__decap_3
XFILLER_14_162 VGND VGND VPWR VPWR sky130_fd_sc_hd__decap_3
XFILLER_159_167 VGND VGND VPWR VPWR sky130_fd_sc_hd__fill_1
XFILLER_14_195 VGND VGND VPWR VPWR sky130_fd_sc_hd__fill_1
XFILLER_174_115 VGND VGND VPWR VPWR sky130_fd_sc_hd__decap_3
X_0811_ net143 net308 VGND VGND VPWR VPWR Tile_X0Y0_OpenRAM_top.Inst_OpenRAM_top_ConfigMem.Inst_frame3_bit7.Q
+ sky130_fd_sc_hd__dlxtp_1
Xinput12 DOUT_A_SRAM18 VGND VGND VPWR VPWR net12 sky130_fd_sc_hd__clkbuf_4
XFILLER_52_80 VGND VGND VPWR VPWR sky130_fd_sc_hd__decap_3
XFILLER_174_159 VGND VGND VPWR VPWR sky130_fd_sc_hd__decap_3
XFILLER_168_91 VGND VGND VPWR VPWR sky130_fd_sc_hd__decap_3
XFILLER_168_80 VGND VGND VPWR VPWR sky130_fd_sc_hd__decap_3
X_0742_ net117 net326 VGND VGND VPWR VPWR Tile_X0Y0_OpenRAM_top.Inst_OpenRAM_top_ConfigMem.Inst_frame1_bit12.Q
+ sky130_fd_sc_hd__dlxtp_1
Xinput23 DOUT_A_SRAM28 VGND VGND VPWR VPWR net23 sky130_fd_sc_hd__clkbuf_2
Xinput34 DOUT_B_SRAM0 VGND VGND VPWR VPWR net34 sky130_fd_sc_hd__dlymetal6s2s_1
Xinput45 DOUT_B_SRAM19 VGND VGND VPWR VPWR net45 sky130_fd_sc_hd__clkbuf_2
Xinput89 Tile_X0Y0_E6END[1] VGND VGND VPWR VPWR net89 sky130_fd_sc_hd__clkbuf_2
Xinput67 Tile_X0Y0_E1END[1] VGND VGND VPWR VPWR net67 sky130_fd_sc_hd__buf_2
Xinput78 Tile_X0Y0_E2MID[0] VGND VGND VPWR VPWR net78 sky130_fd_sc_hd__buf_1
Xinput56 DOUT_B_SRAM29 VGND VGND VPWR VPWR net56 sky130_fd_sc_hd__clkbuf_2
X_0673_ Tile_X0Y1_OpenRAM_bot.Inst_OpenRAM_bot_ConfigMem.Inst_frame6_bit6.Q _0210_
+ Tile_X0Y1_OpenRAM_bot.Inst_OpenRAM_bot_ConfigMem.Inst_frame6_bit7.Q VGND VGND VPWR
+ VPWR _0211_ sky130_fd_sc_hd__a21bo_1
XFILLER_96_187 VGND VGND VPWR VPWR sky130_fd_sc_hd__decap_3
X_1225_ net243 net266 VGND VGND VPWR VPWR Tile_X0Y1_OpenRAM_bot.Inst_OpenRAM_bot_ConfigMem.Inst_frame8_bit29.Q
+ sky130_fd_sc_hd__dlxtp_1
X_1156_ net244 net288 VGND VGND VPWR VPWR Tile_X0Y1_OpenRAM_bot.Inst_OpenRAM_bot_ConfigMem.Inst_frame5_bit2.Q
+ sky130_fd_sc_hd__dlxtp_1
X_1087_ net251 net307 VGND VGND VPWR VPWR Tile_X0Y1_OpenRAM_bot.Inst_OpenRAM_bot_ConfigMem.Inst_frame3_bit7.Q
+ sky130_fd_sc_hd__dlxtp_1
XFILLER_165_104 VGND VGND VPWR VPWR sky130_fd_sc_hd__decap_3
XFILLER_20_165 VGND VGND VPWR VPWR sky130_fd_sc_hd__decap_3
XFILLER_165_137 VGND VGND VPWR VPWR sky130_fd_sc_hd__decap_3
XFILLER_173_181 VGND VGND VPWR VPWR sky130_fd_sc_hd__decap_3
XFILLER_164_27 VGND VGND VPWR VPWR sky130_fd_sc_hd__fill_1
XFILLER_57_25 VGND VGND VPWR VPWR sky130_fd_sc_hd__decap_3
XFILLER_87_154 VGND VGND VPWR VPWR sky130_fd_sc_hd__decap_3
XFILLER_180_15 VGND VGND VPWR VPWR sky130_fd_sc_hd__decap_3
XFILLER_113_97 VGND VGND VPWR VPWR sky130_fd_sc_hd__decap_3
XTAP_TAPCELL_ROW_26_477 VGND VPWR sky130_fd_sc_hd__tapvpwrvgnd_1
XFILLER_156_115 VGND VGND VPWR VPWR sky130_fd_sc_hd__decap_3
XFILLER_11_143 VGND VGND VPWR VPWR sky130_fd_sc_hd__decap_3
XFILLER_7_125 VGND VGND VPWR VPWR sky130_fd_sc_hd__decap_3
XFILLER_7_169 VGND VGND VPWR VPWR sky130_fd_sc_hd__decap_3
XFILLER_7_158 VGND VGND VPWR VPWR sky130_fd_sc_hd__decap_3
XFILLER_22_94 VGND VGND VPWR VPWR sky130_fd_sc_hd__decap_3
XFILLER_164_192 VGND VGND VPWR VPWR sky130_fd_sc_hd__decap_3
XFILLER_138_94 VGND VGND VPWR VPWR sky130_fd_sc_hd__decap_3
XFILLER_98_32 VGND VGND VPWR VPWR sky130_fd_sc_hd__decap_3
XFILLER_98_21 VGND VGND VPWR VPWR sky130_fd_sc_hd__decap_3
XFILLER_78_132 VGND VGND VPWR VPWR sky130_fd_sc_hd__decap_3
XTAP_TAPCELL_ROW_166_1035 VGND VPWR sky130_fd_sc_hd__tapvpwrvgnd_1
XFILLER_14_7 VGND VGND VPWR VPWR sky130_fd_sc_hd__fill_1
XFILLER_93_146 VGND VGND VPWR VPWR sky130_fd_sc_hd__fill_1
X_1010_ net234 net322 VGND VGND VPWR VPWR Tile_X0Y1_OpenRAM_bot.Inst_OpenRAM_bot_ConfigMem.Inst_frame1_bit20.Q
+ sky130_fd_sc_hd__dlxtp_1
XTAP_TAPCELL_ROW_49_569 VGND VPWR sky130_fd_sc_hd__tapvpwrvgnd_1
XFILLER_179_218 VGND VGND VPWR VPWR sky130_fd_sc_hd__decap_3
XFILLER_179_90 VGND VGND VPWR VPWR sky130_fd_sc_hd__decap_3
XFILLER_8_41 VGND VGND VPWR VPWR sky130_fd_sc_hd__decap_3
XFILLER_8_85 VGND VGND VPWR VPWR sky130_fd_sc_hd__decap_3
XFILLER_8_74 VGND VGND VPWR VPWR sky130_fd_sc_hd__decap_3
XFILLER_162_107 VGND VGND VPWR VPWR sky130_fd_sc_hd__fill_2
X_0725_ net135 net326 VGND VGND VPWR VPWR Tile_X0Y0_OpenRAM_top.Inst_OpenRAM_top_ConfigMem.Inst_frame1_bit29.Q
+ sky130_fd_sc_hd__dlxtp_1
XFILLER_6_180 VGND VGND VPWR VPWR sky130_fd_sc_hd__decap_3
X_0656_ net174 net209 net200 _0156_ Tile_X0Y1_OpenRAM_bot.Inst_OpenRAM_bot_ConfigMem.Inst_frame7_bit28.Q
+ Tile_X0Y1_OpenRAM_bot.Inst_OpenRAM_bot_ConfigMem.Inst_frame7_bit29.Q VGND VGND VPWR
+ VPWR _0197_ sky130_fd_sc_hd__mux4_1
XFILLER_170_162 VGND VGND VPWR VPWR sky130_fd_sc_hd__decap_3
XFILLER_170_195 VGND VGND VPWR VPWR sky130_fd_sc_hd__fill_1
XFILLER_69_143 VGND VGND VPWR VPWR sky130_fd_sc_hd__decap_3
X_0587_ net213 net221 net197 _0155_ Tile_X0Y1_OpenRAM_bot.Inst_OpenRAM_bot_ConfigMem.Inst_frame3_bit18.Q
+ Tile_X0Y1_OpenRAM_bot.Inst_OpenRAM_bot_ConfigMem.Inst_frame3_bit19.Q VGND VGND VPWR
+ VPWR net672 sky130_fd_sc_hd__mux4_1
XFILLER_69_187 VGND VGND VPWR VPWR sky130_fd_sc_hd__decap_3
XFILLER_84_124 VGND VGND VPWR VPWR sky130_fd_sc_hd__decap_3
XFILLER_84_168 VGND VGND VPWR VPWR sky130_fd_sc_hd__decap_3
X_1208_ net227 net272 VGND VGND VPWR VPWR Tile_X0Y1_OpenRAM_bot.Inst_OpenRAM_bot_ConfigMem.Inst_frame7_bit14.Q
+ sky130_fd_sc_hd__dlxtp_1
XFILLER_25_202 VGND VGND VPWR VPWR sky130_fd_sc_hd__fill_2
XTAP_TAPCELL_ROW_107_798 VGND VPWR sky130_fd_sc_hd__tapvpwrvgnd_1
XTAP_TAPCELL_ROW_0_367 VGND VPWR sky130_fd_sc_hd__tapvpwrvgnd_1
X_1139_ net232 net288 VGND VGND VPWR VPWR Tile_X0Y1_OpenRAM_bot.Inst_OpenRAM_bot_ConfigMem.Inst_frame5_bit19.Q
+ sky130_fd_sc_hd__dlxtp_1
XFILLER_138_159 VGND VGND VPWR VPWR sky130_fd_sc_hd__decap_3
XFILLER_138_137 VGND VGND VPWR VPWR sky130_fd_sc_hd__decap_3
XFILLER_175_15 VGND VGND VPWR VPWR sky130_fd_sc_hd__decap_3
XFILLER_4_106 VGND VGND VPWR VPWR sky130_fd_sc_hd__decap_3
XFILLER_175_48 VGND VGND VPWR VPWR sky130_fd_sc_hd__decap_3
XFILLER_4_139 VGND VGND VPWR VPWR sky130_fd_sc_hd__fill_1
XFILLER_161_140 VGND VGND VPWR VPWR sky130_fd_sc_hd__decap_3
XFILLER_161_184 VGND VGND VPWR VPWR sky130_fd_sc_hd__decap_3
XFILLER_161_162 VGND VGND VPWR VPWR sky130_fd_sc_hd__decap_3
XFILLER_108_97 VGND VGND VPWR VPWR sky130_fd_sc_hd__decap_3
Xinput202 Tile_X0Y1_E6END[6] VGND VGND VPWR VPWR net202 sky130_fd_sc_hd__clkbuf_2
XFILLER_68_68 VGND VGND VPWR VPWR sky130_fd_sc_hd__decap_3
Xinput213 Tile_X0Y1_EE4END[1] VGND VGND VPWR VPWR net213 sky130_fd_sc_hd__clkbuf_2
Xinput224 Tile_X0Y1_FrameData[11] VGND VGND VPWR VPWR net224 sky130_fd_sc_hd__buf_4
Xinput235 Tile_X0Y1_FrameData[21] VGND VGND VPWR VPWR net235 sky130_fd_sc_hd__clkbuf_4
XFILLER_124_74 VGND VGND VPWR VPWR sky130_fd_sc_hd__decap_3
Xinput279 Tile_X0Y1_N4END[5] VGND VGND VPWR VPWR net362 sky130_fd_sc_hd__clkbuf_4
Xinput268 Tile_X0Y1_N2MID[2] VGND VGND VPWR VPWR net351 sky130_fd_sc_hd__buf_2
Xinput257 Tile_X0Y1_N1END[3] VGND VGND VPWR VPWR net340 sky130_fd_sc_hd__clkbuf_2
Xinput246 Tile_X0Y1_FrameData[31] VGND VGND VPWR VPWR net246 sky130_fd_sc_hd__clkbuf_4
XFILLER_84_12 VGND VGND VPWR VPWR sky130_fd_sc_hd__fill_2
XFILLER_124_85 VGND VGND VPWR VPWR sky130_fd_sc_hd__decap_3
XFILLER_17_50 VGND VGND VPWR VPWR sky130_fd_sc_hd__decap_3
XFILLER_16_224 VGND VGND VPWR VPWR sky130_fd_sc_hd__decap_3
XFILLER_84_67 VGND VGND VPWR VPWR sky130_fd_sc_hd__fill_1
XFILLER_90_127 VGND VGND VPWR VPWR sky130_fd_sc_hd__fill_1
XFILLER_17_72 VGND VGND VPWR VPWR sky130_fd_sc_hd__decap_3
XFILLER_83_190 VGND VGND VPWR VPWR sky130_fd_sc_hd__fill_2
XFILLER_140_62 VGND VGND VPWR VPWR sky130_fd_sc_hd__decap_3
XFILLER_33_60 VGND VGND VPWR VPWR sky130_fd_sc_hd__decap_3
XFILLER_149_60 VGND VGND VPWR VPWR sky130_fd_sc_hd__decap_3
XFILLER_129_137 VGND VGND VPWR VPWR sky130_fd_sc_hd__decap_3
XFILLER_76_9 VGND VGND VPWR VPWR sky130_fd_sc_hd__decap_3
XFILLER_149_93 VGND VGND VPWR VPWR sky130_fd_sc_hd__fill_1
XTAP_TAPCELL_ROW_172_1061 VGND VPWR sky130_fd_sc_hd__tapvpwrvgnd_1
XFILLER_144_129 VGND VGND VPWR VPWR sky130_fd_sc_hd__decap_3
XFILLER_137_181 VGND VGND VPWR VPWR sky130_fd_sc_hd__decap_3
X_0510_ net255 net358 _0063_ net171 Tile_X0Y1_OpenRAM_bot.Inst_OpenRAM_bot_ConfigMem.Inst_frame0_bit2.Q
+ Tile_X0Y1_OpenRAM_bot.Inst_OpenRAM_bot_ConfigMem.Inst_frame0_bit3.Q VGND VGND VPWR
+ VPWR Tile_X0Y1_OpenRAM_bot.Inst_OpenRAM_bot_switch_matrix.J_NS4_BEG13 sky130_fd_sc_hd__mux4_2
XFILLER_98_227 VGND VGND VPWR VPWR sky130_fd_sc_hd__decap_3
X_1490_ Tile_X0Y1_OpenRAM_bot.Inst_OpenRAM_bot_switch_matrix.W6BEG8 VGND VGND VPWR
+ VPWR net652 sky130_fd_sc_hd__buf_1
XFILLER_3_172 VGND VGND VPWR VPWR sky130_fd_sc_hd__decap_3
XFILLER_165_92 VGND VGND VPWR VPWR sky130_fd_sc_hd__decap_3
X_0441_ net68 net110 net103 Tile_X0Y0_OpenRAM_top.Inst_OpenRAM_top_switch_matrix.J_NS4_BEG14
+ Tile_X0Y0_OpenRAM_top.Inst_OpenRAM_top_ConfigMem.Inst_frame2_bit16.Q Tile_X0Y0_OpenRAM_top.Inst_OpenRAM_top_ConfigMem.Inst_frame2_bit17.Q
+ VGND VGND VPWR VPWR net409 sky130_fd_sc_hd__mux4_2
X_0372_ net12 net44 net257 Tile_X0Y0_OpenRAM_top.Inst_OpenRAM_top_switch_matrix.J_NS2_BEG5
+ Tile_X0Y0_OpenRAM_top.Inst_OpenRAM_top_ConfigMem.Inst_frame5_bit0.Q Tile_X0Y0_OpenRAM_top.Inst_OpenRAM_top_ConfigMem.Inst_frame5_bit1.Q
+ VGND VGND VPWR VPWR Tile_X0Y0_OpenRAM_top.Inst_OpenRAM_top_switch_matrix.W2BEG2
+ sky130_fd_sc_hd__mux4_1
XFILLER_81_105 VGND VGND VPWR VPWR sky130_fd_sc_hd__decap_3
XFILLER_74_190 VGND VGND VPWR VPWR sky130_fd_sc_hd__decap_3
XFILLER_81_149 VGND VGND VPWR VPWR sky130_fd_sc_hd__fill_1
XPHY_EDGE_ROW_8_Right_8 VGND VGND VPWR VPWR sky130_fd_sc_hd__decap_3
XTAP_TAPCELL_ROW_45_550 VGND VPWR sky130_fd_sc_hd__tapvpwrvgnd_1
XFILLER_135_107 VGND VGND VPWR VPWR sky130_fd_sc_hd__decap_3
XFILLER_143_140 VGND VGND VPWR VPWR sky130_fd_sc_hd__decap_3
XFILLER_128_192 VGND VGND VPWR VPWR sky130_fd_sc_hd__decap_3
X_0708_ net119 net334 VGND VGND VPWR VPWR Tile_X0Y0_OpenRAM_top.Inst_OpenRAM_top_ConfigMem.Inst_frame0_bit14.Q
+ sky130_fd_sc_hd__dlxtp_1
XPHY_EDGE_ROW_39_Right_39 VGND VGND VPWR VPWR sky130_fd_sc_hd__decap_3
X_0639_ _0179_ _0181_ _0182_ Tile_X0Y1_OpenRAM_bot.Inst_OpenRAM_bot_ConfigMem.Inst_frame8_bit29.Q
+ VGND VGND VPWR VPWR Tile_X0Y0_OpenRAM_top.N4BEG_outbuf_9.A sky130_fd_sc_hd__o22a_1
XFILLER_161_28 VGND VGND VPWR VPWR sky130_fd_sc_hd__decap_3
XFILLER_57_113 VGND VGND VPWR VPWR sky130_fd_sc_hd__decap_3
XFILLER_180_9 VGND VGND VPWR VPWR sky130_fd_sc_hd__decap_3
XTAP_TAPCELL_ROW_68_642 VGND VPWR sky130_fd_sc_hd__tapvpwrvgnd_1
XFILLER_72_105 VGND VGND VPWR VPWR sky130_fd_sc_hd__decap_3
XFILLER_54_26 VGND VGND VPWR VPWR sky130_fd_sc_hd__fill_2
XFILLER_72_138 VGND VGND VPWR VPWR sky130_fd_sc_hd__fill_2
XFILLER_13_205 VGND VGND VPWR VPWR sky130_fd_sc_hd__decap_3
XFILLER_54_59 VGND VGND VPWR VPWR sky130_fd_sc_hd__decap_3
XFILLER_110_32 VGND VGND VPWR VPWR sky130_fd_sc_hd__decap_3
XFILLER_110_21 VGND VGND VPWR VPWR sky130_fd_sc_hd__decap_3
XPHY_EDGE_ROW_48_Right_48 VGND VGND VPWR VPWR sky130_fd_sc_hd__decap_3
XFILLER_166_221 VGND VGND VPWR VPWR sky130_fd_sc_hd__decap_3
XTAP_TAPCELL_ROW_11_417 VGND VPWR sky130_fd_sc_hd__tapvpwrvgnd_1
XTAP_TAPCELL_ROW_51_575 VGND VPWR sky130_fd_sc_hd__tapvpwrvgnd_1
XFILLER_119_63 VGND VGND VPWR VPWR sky130_fd_sc_hd__fill_2
XFILLER_119_41 VGND VGND VPWR VPWR sky130_fd_sc_hd__fill_1
XFILLER_119_192 VGND VGND VPWR VPWR sky130_fd_sc_hd__fill_2
XFILLER_79_12 VGND VGND VPWR VPWR sky130_fd_sc_hd__decap_3
XFILLER_134_162 VGND VGND VPWR VPWR sky130_fd_sc_hd__decap_3
XPHY_EDGE_ROW_57_Right_57 VGND VGND VPWR VPWR sky130_fd_sc_hd__decap_3
XFILLER_79_78 VGND VGND VPWR VPWR sky130_fd_sc_hd__decap_3
XFILLER_134_184 VGND VGND VPWR VPWR sky130_fd_sc_hd__decap_3
XFILLER_135_51 VGND VGND VPWR VPWR sky130_fd_sc_hd__decap_3
XFILLER_135_95 VGND VGND VPWR VPWR sky130_fd_sc_hd__decap_3
XFILLER_0_197 VGND VGND VPWR VPWR sky130_fd_sc_hd__decap_3
XFILLER_48_135 VGND VGND VPWR VPWR sky130_fd_sc_hd__decap_3
XFILLER_48_168 VGND VGND VPWR VPWR sky130_fd_sc_hd__decap_3
XFILLER_95_77 VGND VGND VPWR VPWR sky130_fd_sc_hd__decap_3
XFILLER_63_127 VGND VGND VPWR VPWR sky130_fd_sc_hd__decap_3
XFILLER_151_72 VGND VGND VPWR VPWR sky130_fd_sc_hd__decap_3
XTAP_TAPCELL_ROW_34_509 VGND VPWR sky130_fd_sc_hd__tapvpwrvgnd_1
XPHY_EDGE_ROW_66_Right_66 VGND VGND VPWR VPWR sky130_fd_sc_hd__decap_3
XTAP_TAPCELL_ROW_74_667 VGND VPWR sky130_fd_sc_hd__tapvpwrvgnd_1
XFILLER_44_81 VGND VGND VPWR VPWR sky130_fd_sc_hd__decap_3
X_0990_ net252 net333 VGND VGND VPWR VPWR Tile_X0Y1_OpenRAM_bot.Inst_OpenRAM_bot_ConfigMem.Inst_frame0_bit8.Q
+ sky130_fd_sc_hd__dlxtp_1
XFILLER_117_107 VGND VGND VPWR VPWR sky130_fd_sc_hd__decap_3
XFILLER_172_224 VGND VGND VPWR VPWR sky130_fd_sc_hd__decap_3
XFILLER_176_91 VGND VGND VPWR VPWR sky130_fd_sc_hd__decap_3
XFILLER_176_80 VGND VGND VPWR VPWR sky130_fd_sc_hd__decap_3
XFILLER_125_140 VGND VGND VPWR VPWR sky130_fd_sc_hd__decap_3
Xoutput517 net600 VGND VGND VPWR VPWR Tile_X0Y1_S2BEGb[2] sky130_fd_sc_hd__buf_2
Xoutput506 net589 VGND VGND VPWR VPWR Tile_X0Y1_S1BEG[3] sky130_fd_sc_hd__buf_2
XPHY_EDGE_ROW_75_Right_75 VGND VGND VPWR VPWR sky130_fd_sc_hd__decap_3
XFILLER_125_162 VGND VGND VPWR VPWR sky130_fd_sc_hd__decap_3
Xoutput539 net622 VGND VGND VPWR VPWR Tile_X0Y1_W1BEG[0] sky130_fd_sc_hd__buf_2
XFILLER_5_42 VGND VGND VPWR VPWR sky130_fd_sc_hd__decap_3
Xoutput528 net611 VGND VGND VPWR VPWR Tile_X0Y1_S4BEG[14] sky130_fd_sc_hd__buf_2
XFILLER_125_184 VGND VGND VPWR VPWR sky130_fd_sc_hd__decap_3
XFILLER_5_75 VGND VGND VPWR VPWR sky130_fd_sc_hd__decap_3
X_1473_ Tile_X0Y1_OpenRAM_bot.Inst_OpenRAM_bot_switch_matrix.W2BEG7 VGND VGND VPWR
+ VPWR net633 sky130_fd_sc_hd__buf_1
X_0424_ net48 Tile_X0Y0_OpenRAM_top.Inst_OpenRAM_top_switch_matrix.J_NS4_BEG6 _0096_
+ Tile_X0Y0_OpenRAM_top.Inst_OpenRAM_top_switch_matrix.J_NS2_BEG5 Tile_X0Y0_OpenRAM_top.Inst_OpenRAM_top_ConfigMem.Inst_frame3_bit15.Q
+ Tile_X0Y0_OpenRAM_top.Inst_OpenRAM_top_ConfigMem.Inst_frame3_bit14.Q VGND VGND VPWR
+ VPWR Tile_X0Y0_OpenRAM_top.Inst_OpenRAM_top_switch_matrix.W6BEG9 sky130_fd_sc_hd__mux4_1
XFILLER_140_187 VGND VGND VPWR VPWR sky130_fd_sc_hd__decap_3
XTAP_TAPCELL_ROW_97_759 VGND VPWR sky130_fd_sc_hd__tapvpwrvgnd_1
XFILLER_39_102 VGND VGND VPWR VPWR sky130_fd_sc_hd__decap_3
XFILLER_39_113 VGND VGND VPWR VPWR sky130_fd_sc_hd__decap_3
X_0355_ net186 net178 net194 _0087_ Tile_X0Y1_OpenRAM_bot.Inst_OpenRAM_bot_ConfigMem.Inst_frame8_bit22.Q
+ Tile_X0Y1_OpenRAM_bot.Inst_OpenRAM_bot_ConfigMem.Inst_frame8_bit23.Q VGND VGND VPWR
+ VPWR Tile_X0Y0_OpenRAM_top.Inst_OpenRAM_top_switch_matrix.N2BEGb7 sky130_fd_sc_hd__mux4_1
XFILLER_54_127 VGND VGND VPWR VPWR sky130_fd_sc_hd__decap_3
X_0286_ net355 net343 Tile_X0Y1_OpenRAM_bot.Inst_OpenRAM_bot_ConfigMem.Inst_frame2_bit28.Q
+ VGND VGND VPWR VPWR _0055_ sky130_fd_sc_hd__mux2_1
XPHY_EDGE_ROW_84_Right_84 VGND VGND VPWR VPWR sky130_fd_sc_hd__decap_3
XFILLER_47_190 VGND VGND VPWR VPWR sky130_fd_sc_hd__decap_3
XFILLER_24_18 VGND VGND VPWR VPWR sky130_fd_sc_hd__decap_3
XFILLER_24_29 VGND VGND VPWR VPWR sky130_fd_sc_hd__decap_3
XFILLER_62_171 VGND VGND VPWR VPWR sky130_fd_sc_hd__decap_3
XTAP_TAPCELL_ROW_179_1089 VGND VPWR sky130_fd_sc_hd__tapvpwrvgnd_1
XTAP_TAPCELL_ROW_100_771 VGND VPWR sky130_fd_sc_hd__tapvpwrvgnd_1
XFILLER_163_202 VGND VGND VPWR VPWR sky130_fd_sc_hd__decap_3
XFILLER_108_118 VGND VGND VPWR VPWR sky130_fd_sc_hd__decap_3
XPHY_EDGE_ROW_93_Right_93 VGND VGND VPWR VPWR sky130_fd_sc_hd__decap_3
XFILLER_116_162 VGND VGND VPWR VPWR sky130_fd_sc_hd__decap_3
XFILLER_6_9 VGND VGND VPWR VPWR sky130_fd_sc_hd__decap_3
XFILLER_172_38 VGND VGND VPWR VPWR sky130_fd_sc_hd__decap_3
XFILLER_172_27 VGND VGND VPWR VPWR sky130_fd_sc_hd__fill_1
XFILLER_131_154 VGND VGND VPWR VPWR sky130_fd_sc_hd__fill_2
XFILLER_49_48 VGND VGND VPWR VPWR sky130_fd_sc_hd__decap_3
XFILLER_105_21 VGND VGND VPWR VPWR sky130_fd_sc_hd__decap_3
XFILLER_105_54 VGND VGND VPWR VPWR sky130_fd_sc_hd__fill_2
XPHY_EDGE_ROW_0_Left_183 VGND VGND VPWR VPWR sky130_fd_sc_hd__decap_3
XFILLER_45_138 VGND VGND VPWR VPWR sky130_fd_sc_hd__decap_3
XFILLER_65_69 VGND VGND VPWR VPWR sky130_fd_sc_hd__decap_3
XFILLER_121_42 VGND VGND VPWR VPWR sky130_fd_sc_hd__decap_3
XTAP_TAPCELL_ROW_123_863 VGND VPWR sky130_fd_sc_hd__tapvpwrvgnd_1
XFILLER_121_75 VGND VGND VPWR VPWR sky130_fd_sc_hd__decap_3
XFILLER_53_193 VGND VGND VPWR VPWR sky130_fd_sc_hd__decap_3
XFILLER_81_57 VGND VGND VPWR VPWR sky130_fd_sc_hd__decap_3
XFILLER_139_210 VGND VGND VPWR VPWR sky130_fd_sc_hd__decap_3
XFILLER_14_51 VGND VGND VPWR VPWR sky130_fd_sc_hd__decap_3
XFILLER_5_223 VGND VGND VPWR VPWR sky130_fd_sc_hd__fill_1
XFILLER_30_50 VGND VGND VPWR VPWR sky130_fd_sc_hd__decap_3
XFILLER_107_140 VGND VGND VPWR VPWR sky130_fd_sc_hd__decap_3
XFILLER_30_83 VGND VGND VPWR VPWR sky130_fd_sc_hd__fill_1
XFILLER_146_83 VGND VGND VPWR VPWR sky130_fd_sc_hd__fill_1
XFILLER_122_121 VGND VGND VPWR VPWR sky130_fd_sc_hd__decap_3
XFILLER_30_94 VGND VGND VPWR VPWR sky130_fd_sc_hd__fill_2
XFILLER_146_94 VGND VGND VPWR VPWR sky130_fd_sc_hd__decap_3
XFILLER_122_165 VGND VGND VPWR VPWR sky130_fd_sc_hd__decap_3
XFILLER_122_187 VGND VGND VPWR VPWR sky130_fd_sc_hd__decap_3
XFILLER_162_71 VGND VGND VPWR VPWR sky130_fd_sc_hd__decap_3
XFILLER_39_81 VGND VGND VPWR VPWR sky130_fd_sc_hd__decap_3
XTAP_TAPCELL_ROW_146_955 VGND VPWR sky130_fd_sc_hd__tapvpwrvgnd_1
XFILLER_91_211 VGND VGND VPWR VPWR sky130_fd_sc_hd__decap_3
XFILLER_36_127 VGND VGND VPWR VPWR sky130_fd_sc_hd__decap_3
XFILLER_51_108 VGND VGND VPWR VPWR sky130_fd_sc_hd__decap_3
XFILLER_51_119 VGND VGND VPWR VPWR sky130_fd_sc_hd__decap_3
X_0973_ net239 net332 VGND VGND VPWR VPWR Tile_X0Y1_OpenRAM_bot.Inst_OpenRAM_bot_ConfigMem.Inst_frame0_bit25.Q
+ sky130_fd_sc_hd__dlxtp_1
XFILLER_145_213 VGND VGND VPWR VPWR sky130_fd_sc_hd__decap_3
XFILLER_160_227 VGND VGND VPWR VPWR sky130_fd_sc_hd__decap_3
Xoutput303 net386 VGND VGND VPWR VPWR DIN_A_SRAM1 sky130_fd_sc_hd__buf_2
Xoutput314 net397 VGND VGND VPWR VPWR DIN_A_SRAM2 sky130_fd_sc_hd__buf_2
Xoutput325 net408 VGND VGND VPWR VPWR DIN_A_SRAM3 sky130_fd_sc_hd__buf_2
Xoutput369 net452 VGND VGND VPWR VPWR Tile_X0Y0_FrameStrobe_O[12] sky130_fd_sc_hd__buf_2
Xoutput358 net441 VGND VGND VPWR VPWR Tile_X0Y0_FrameData_O[31] sky130_fd_sc_hd__buf_2
Xoutput347 net430 VGND VGND VPWR VPWR Tile_X0Y0_FrameData_O[21] sky130_fd_sc_hd__buf_2
Xoutput336 net419 VGND VGND VPWR VPWR Tile_X0Y0_FrameData_O[11] sky130_fd_sc_hd__buf_2
X_1456_ Tile_X0Y0_OpenRAM_top.Inst_OpenRAM_top_switch_matrix.S4BEG2 VGND VGND VPWR
+ VPWR net607 sky130_fd_sc_hd__buf_4
XFILLER_113_187 VGND VGND VPWR VPWR sky130_fd_sc_hd__decap_3
XFILLER_19_29 VGND VGND VPWR VPWR sky130_fd_sc_hd__decap_3
X_0407_ Tile_X0Y0_OpenRAM_top.Inst_OpenRAM_top_switch_matrix.N1END3 net364 net149
+ net169 Tile_X0Y0_OpenRAM_top.Inst_OpenRAM_top_ConfigMem.Inst_frame1_bit14.Q Tile_X0Y0_OpenRAM_top.Inst_OpenRAM_top_ConfigMem.Inst_frame1_bit15.Q
+ VGND VGND VPWR VPWR _0095_ sky130_fd_sc_hd__mux4_2
X_1387_ Tile_X0Y0_OpenRAM_top.Inst_OpenRAM_top_switch_matrix.WW4BEG9 VGND VGND VPWR
+ VPWR net553 sky130_fd_sc_hd__buf_1
X_0338_ net66 net73 net81 Tile_X0Y0_OpenRAM_top.Inst_OpenRAM_top_switch_matrix.J_NS2_BEG4
+ Tile_X0Y0_OpenRAM_top.Inst_OpenRAM_top_ConfigMem.Inst_frame6_bit1.Q Tile_X0Y0_OpenRAM_top.Inst_OpenRAM_top_ConfigMem.Inst_frame6_bit0.Q
+ VGND VGND VPWR VPWR Tile_X0Y0_OpenRAM_top.Inst_OpenRAM_top_switch_matrix.S2BEG4
+ sky130_fd_sc_hd__mux4_2
XFILLER_27_105 VGND VGND VPWR VPWR sky130_fd_sc_hd__decap_3
XFILLER_27_116 VGND VGND VPWR VPWR sky130_fd_sc_hd__decap_3
XFILLER_35_39 VGND VGND VPWR VPWR sky130_fd_sc_hd__decap_3
X_0269_ net355 net343 Tile_X0Y1_OpenRAM_bot.Inst_OpenRAM_bot_ConfigMem.Inst_frame3_bit8.Q
+ VGND VGND VPWR VPWR _0039_ sky130_fd_sc_hd__mux2_1
XFILLER_35_193 VGND VGND VPWR VPWR sky130_fd_sc_hd__decap_3
XFILLER_50_141 VGND VGND VPWR VPWR sky130_fd_sc_hd__decap_3
XFILLER_50_174 VGND VGND VPWR VPWR sky130_fd_sc_hd__decap_3
XFILLER_167_27 VGND VGND VPWR VPWR sky130_fd_sc_hd__decap_3
XFILLER_136_224 VGND VGND VPWR VPWR sky130_fd_sc_hd__decap_3
XPHY_EDGE_ROW_36_Left_219 VGND VGND VPWR VPWR sky130_fd_sc_hd__decap_3
XFILLER_104_110 VGND VGND VPWR VPWR sky130_fd_sc_hd__decap_3
XFILLER_4_6 VGND VGND VPWR VPWR sky130_fd_sc_hd__decap_3
XFILLER_76_24 VGND VGND VPWR VPWR sky130_fd_sc_hd__decap_3
XPHY_EDGE_ROW_45_Left_228 VGND VGND VPWR VPWR sky130_fd_sc_hd__decap_3
XFILLER_58_230 VGND VGND VPWR VPWR sky130_fd_sc_hd__fill_1
XFILLER_76_35 VGND VGND VPWR VPWR sky130_fd_sc_hd__decap_3
XFILLER_73_200 VGND VGND VPWR VPWR sky130_fd_sc_hd__decap_3
XFILLER_76_68 VGND VGND VPWR VPWR sky130_fd_sc_hd__decap_3
XFILLER_132_41 VGND VGND VPWR VPWR sky130_fd_sc_hd__decap_3
XFILLER_92_12 VGND VGND VPWR VPWR sky130_fd_sc_hd__decap_3
XFILLER_132_85 VGND VGND VPWR VPWR sky130_fd_sc_hd__fill_2
XFILLER_33_108 VGND VGND VPWR VPWR sky130_fd_sc_hd__decap_3
XFILLER_33_119 VGND VGND VPWR VPWR sky130_fd_sc_hd__decap_3
XFILLER_41_152 VGND VGND VPWR VPWR sky130_fd_sc_hd__decap_3
XFILLER_41_196 VGND VGND VPWR VPWR sky130_fd_sc_hd__decap_3
XPHY_EDGE_ROW_54_Left_237 VGND VGND VPWR VPWR sky130_fd_sc_hd__decap_3
XFILLER_157_60 VGND VGND VPWR VPWR sky130_fd_sc_hd__decap_3
XFILLER_41_60 VGND VGND VPWR VPWR sky130_fd_sc_hd__decap_3
XFILLER_157_93 VGND VGND VPWR VPWR sky130_fd_sc_hd__decap_3
X_1310_ Tile_X0Y0_OpenRAM_top.Inst_OpenRAM_top_switch_matrix.N1BEG1 VGND VGND VPWR
+ VPWR net470 sky130_fd_sc_hd__buf_1
XPHY_EDGE_ROW_63_Left_246 VGND VGND VPWR VPWR sky130_fd_sc_hd__decap_3
XFILLER_173_81 VGND VGND VPWR VPWR sky130_fd_sc_hd__decap_3
XFILLER_2_21 VGND VGND VPWR VPWR sky130_fd_sc_hd__decap_3
X_1241_ net226 net264 VGND VGND VPWR VPWR Tile_X0Y1_OpenRAM_bot.Inst_OpenRAM_bot_ConfigMem.Inst_frame8_bit13.Q
+ sky130_fd_sc_hd__dlxtp_1
X_1172_ net231 net279 VGND VGND VPWR VPWR Tile_X0Y1_OpenRAM_bot.Inst_OpenRAM_bot_ConfigMem.Inst_frame6_bit18.Q
+ sky130_fd_sc_hd__dlxtp_1
XFILLER_64_200 VGND VGND VPWR VPWR sky130_fd_sc_hd__decap_3
XTAP_TAPCELL_ROW_90_732 VGND VPWR sky130_fd_sc_hd__tapvpwrvgnd_1
XFILLER_32_130 VGND VGND VPWR VPWR sky130_fd_sc_hd__decap_3
XFILLER_32_141 VGND VGND VPWR VPWR sky130_fd_sc_hd__decap_3
XFILLER_177_113 VGND VGND VPWR VPWR sky130_fd_sc_hd__decap_3
XFILLER_32_174 VGND VGND VPWR VPWR sky130_fd_sc_hd__decap_3
XPHY_EDGE_ROW_72_Left_255 VGND VGND VPWR VPWR sky130_fd_sc_hd__decap_3
XFILLER_177_146 VGND VGND VPWR VPWR sky130_fd_sc_hd__decap_3
X_0956_ net128 net269 VGND VGND VPWR VPWR Tile_X0Y0_OpenRAM_top.Inst_OpenRAM_top_ConfigMem.Inst_frame8_bit22.Q
+ sky130_fd_sc_hd__dlxtp_1
X_0887_ net133 net283 VGND VGND VPWR VPWR Tile_X0Y0_OpenRAM_top.Inst_OpenRAM_top_ConfigMem.Inst_frame6_bit27.Q
+ sky130_fd_sc_hd__dlxtp_1
XPHY_EDGE_ROW_81_Left_264 VGND VGND VPWR VPWR sky130_fd_sc_hd__decap_3
XFILLER_153_29 VGND VGND VPWR VPWR sky130_fd_sc_hd__decap_3
X_1508_ Tile_X0Y1_OpenRAM_bot.Inst_OpenRAM_bot_switch_matrix.WW4BEG14 VGND VGND VPWR
+ VPWR net659 sky130_fd_sc_hd__clkbuf_2
XFILLER_101_135 VGND VGND VPWR VPWR sky130_fd_sc_hd__decap_3
X_1439_ Tile_X0Y0_OpenRAM_top.Inst_OpenRAM_top_switch_matrix.S2BEG1 VGND VGND VPWR
+ VPWR net599 sky130_fd_sc_hd__buf_2
XFILLER_46_16 VGND VGND VPWR VPWR sky130_fd_sc_hd__decap_3
XFILLER_55_222 VGND VGND VPWR VPWR sky130_fd_sc_hd__fill_2
XFILLER_70_203 VGND VGND VPWR VPWR sky130_fd_sc_hd__decap_3
XPHY_EDGE_ROW_90_Left_273 VGND VGND VPWR VPWR sky130_fd_sc_hd__decap_3
XFILLER_102_88 VGND VGND VPWR VPWR sky130_fd_sc_hd__decap_3
XFILLER_102_77 VGND VGND VPWR VPWR sky130_fd_sc_hd__decap_3
XFILLER_62_26 VGND VGND VPWR VPWR sky130_fd_sc_hd__fill_2
XFILLER_178_15 VGND VGND VPWR VPWR sky130_fd_sc_hd__decap_3
XFILLER_168_124 VGND VGND VPWR VPWR sky130_fd_sc_hd__decap_3
XFILLER_178_59 VGND VGND VPWR VPWR sky130_fd_sc_hd__decap_3
XFILLER_168_179 VGND VGND VPWR VPWR sky130_fd_sc_hd__decap_3
XFILLER_109_202 VGND VGND VPWR VPWR sky130_fd_sc_hd__decap_3
XFILLER_127_52 VGND VGND VPWR VPWR sky130_fd_sc_hd__decap_3
XFILLER_11_63 VGND VGND VPWR VPWR sky130_fd_sc_hd__decap_3
XFILLER_11_52 VGND VGND VPWR VPWR sky130_fd_sc_hd__decap_3
XFILLER_127_63 VGND VGND VPWR VPWR sky130_fd_sc_hd__decap_3
XFILLER_11_96 VGND VGND VPWR VPWR sky130_fd_sc_hd__decap_3
XFILLER_2_3 VGND VGND VPWR VPWR sky130_fd_sc_hd__decap_3
XFILLER_87_12 VGND VGND VPWR VPWR sky130_fd_sc_hd__decap_3
XFILLER_87_45 VGND VGND VPWR VPWR sky130_fd_sc_hd__decap_3
XFILLER_143_51 VGND VGND VPWR VPWR sky130_fd_sc_hd__decap_3
XTAP_TAPCELL_ROW_6_395 VGND VPWR sky130_fd_sc_hd__tapvpwrvgnd_1
XFILLER_46_200 VGND VGND VPWR VPWR sky130_fd_sc_hd__decap_3
XFILLER_143_84 VGND VGND VPWR VPWR sky130_fd_sc_hd__fill_1
XFILLER_100_190 VGND VGND VPWR VPWR sky130_fd_sc_hd__decap_3
XTAP_TAPCELL_ROW_29_486 VGND VPWR sky130_fd_sc_hd__tapvpwrvgnd_1
XFILLER_36_82 VGND VGND VPWR VPWR sky130_fd_sc_hd__fill_2
XFILLER_14_141 VGND VGND VPWR VPWR sky130_fd_sc_hd__decap_3
XFILLER_159_146 VGND VGND VPWR VPWR sky130_fd_sc_hd__decap_3
XFILLER_14_174 VGND VGND VPWR VPWR sky130_fd_sc_hd__decap_3
XFILLER_174_127 VGND VGND VPWR VPWR sky130_fd_sc_hd__decap_3
X_0810_ net144 net311 VGND VGND VPWR VPWR Tile_X0Y0_OpenRAM_top.Inst_OpenRAM_top_ConfigMem.Inst_frame3_bit8.Q
+ sky130_fd_sc_hd__dlxtp_1
Xinput13 DOUT_A_SRAM19 VGND VGND VPWR VPWR net13 sky130_fd_sc_hd__buf_2
XTAP_TAPCELL_ROW_175_1070 VGND VPWR sky130_fd_sc_hd__tapvpwrvgnd_1
XFILLER_167_190 VGND VGND VPWR VPWR sky130_fd_sc_hd__decap_3
X_0741_ net118 net326 VGND VGND VPWR VPWR Tile_X0Y0_OpenRAM_top.Inst_OpenRAM_top_ConfigMem.Inst_frame1_bit13.Q
+ sky130_fd_sc_hd__dlxtp_1
Xinput24 DOUT_A_SRAM29 VGND VGND VPWR VPWR net24 sky130_fd_sc_hd__clkbuf_2
Xinput35 DOUT_B_SRAM1 VGND VGND VPWR VPWR net35 sky130_fd_sc_hd__buf_1
Xinput46 DOUT_B_SRAM2 VGND VGND VPWR VPWR net46 sky130_fd_sc_hd__buf_1
Xinput68 Tile_X0Y0_E1END[2] VGND VGND VPWR VPWR net68 sky130_fd_sc_hd__clkbuf_2
Xinput79 Tile_X0Y0_E2MID[1] VGND VGND VPWR VPWR net79 sky130_fd_sc_hd__clkbuf_2
Xinput57 DOUT_B_SRAM3 VGND VGND VPWR VPWR net57 sky130_fd_sc_hd__buf_1
XFILLER_182_193 VGND VGND VPWR VPWR sky130_fd_sc_hd__decap_3
XPHY_EDGE_ROW_172_Right_172 VGND VGND VPWR VPWR sky130_fd_sc_hd__decap_3
X_0672_ Tile_X0Y1_OpenRAM_bot.Inst_OpenRAM_bot_switch_matrix.J_NS4_BEG15 _0087_ Tile_X0Y1_OpenRAM_bot.Inst_OpenRAM_bot_ConfigMem.Inst_frame6_bit5.Q
+ VGND VGND VPWR VPWR _0210_ sky130_fd_sc_hd__mux2_1
XFILLER_35_3 VGND VGND VPWR VPWR sky130_fd_sc_hd__fill_2
XFILLER_96_111 VGND VGND VPWR VPWR sky130_fd_sc_hd__decap_3
XFILLER_96_144 VGND VGND VPWR VPWR sky130_fd_sc_hd__fill_2
XFILLER_37_211 VGND VGND VPWR VPWR sky130_fd_sc_hd__decap_3
X_1224_ net245 net266 VGND VGND VPWR VPWR Tile_X0Y1_OpenRAM_bot.Inst_OpenRAM_bot_ConfigMem.Inst_frame8_bit30.Q
+ sky130_fd_sc_hd__dlxtp_1
X_1155_ net247 net288 VGND VGND VPWR VPWR Tile_X0Y1_OpenRAM_bot.Inst_OpenRAM_bot_ConfigMem.Inst_frame5_bit3.Q
+ sky130_fd_sc_hd__dlxtp_1
X_1086_ net252 net306 VGND VGND VPWR VPWR Tile_X0Y1_OpenRAM_bot.Inst_OpenRAM_bot_ConfigMem.Inst_frame3_bit8.Q
+ sky130_fd_sc_hd__dlxtp_1
XFILLER_20_122 VGND VGND VPWR VPWR sky130_fd_sc_hd__decap_3
XFILLER_20_100 VGND VGND VPWR VPWR sky130_fd_sc_hd__fill_1
XFILLER_165_116 VGND VGND VPWR VPWR sky130_fd_sc_hd__decap_3
XFILLER_20_144 VGND VGND VPWR VPWR sky130_fd_sc_hd__decap_3
XFILLER_165_149 VGND VGND VPWR VPWR sky130_fd_sc_hd__decap_3
XFILLER_20_177 VGND VGND VPWR VPWR sky130_fd_sc_hd__decap_3
X_0939_ net143 net276 VGND VGND VPWR VPWR Tile_X0Y0_OpenRAM_top.Inst_OpenRAM_top_ConfigMem.Inst_frame7_bit7.Q
+ sky130_fd_sc_hd__dlxtp_1
XFILLER_173_193 VGND VGND VPWR VPWR sky130_fd_sc_hd__decap_3
XFILLER_87_111 VGND VGND VPWR VPWR sky130_fd_sc_hd__fill_1
XFILLER_87_122 VGND VGND VPWR VPWR sky130_fd_sc_hd__fill_1
XFILLER_180_27 VGND VGND VPWR VPWR sky130_fd_sc_hd__fill_1
XFILLER_57_37 VGND VGND VPWR VPWR sky130_fd_sc_hd__decap_3
XFILLER_87_166 VGND VGND VPWR VPWR sky130_fd_sc_hd__fill_2
XFILLER_180_49 VGND VGND VPWR VPWR sky130_fd_sc_hd__decap_3
XFILLER_180_38 VGND VGND VPWR VPWR sky130_fd_sc_hd__fill_1
XFILLER_113_21 VGND VGND VPWR VPWR sky130_fd_sc_hd__decap_3
XPHY_EDGE_ROW_119_Left_302 VGND VGND VPWR VPWR sky130_fd_sc_hd__decap_3
XFILLER_28_233 VGND VGND VPWR VPWR sky130_fd_sc_hd__fill_1
XFILLER_73_69 VGND VGND VPWR VPWR sky130_fd_sc_hd__decap_3
XFILLER_11_122 VGND VGND VPWR VPWR sky130_fd_sc_hd__decap_3
XFILLER_11_111 VGND VGND VPWR VPWR sky130_fd_sc_hd__fill_1
XFILLER_11_155 VGND VGND VPWR VPWR sky130_fd_sc_hd__decap_3
XPHY_EDGE_ROW_128_Left_311 VGND VGND VPWR VPWR sky130_fd_sc_hd__decap_3
XFILLER_7_137 VGND VGND VPWR VPWR sky130_fd_sc_hd__decap_3
XFILLER_22_40 VGND VGND VPWR VPWR sky130_fd_sc_hd__decap_3
XFILLER_171_119 VGND VGND VPWR VPWR sky130_fd_sc_hd__decap_3
XFILLER_171_108 VGND VGND VPWR VPWR sky130_fd_sc_hd__decap_3
XFILLER_22_73 VGND VGND VPWR VPWR sky130_fd_sc_hd__decap_3
XFILLER_98_44 VGND VGND VPWR VPWR sky130_fd_sc_hd__fill_2
XFILLER_78_111 VGND VGND VPWR VPWR sky130_fd_sc_hd__decap_3
XFILLER_78_144 VGND VGND VPWR VPWR sky130_fd_sc_hd__decap_3
XTAP_TAPCELL_ROW_166_1036 VGND VPWR sky130_fd_sc_hd__tapvpwrvgnd_1
XFILLER_154_83 VGND VGND VPWR VPWR sky130_fd_sc_hd__fill_1
XFILLER_78_177 VGND VGND VPWR VPWR sky130_fd_sc_hd__decap_3
XPHY_EDGE_ROW_137_Left_320 VGND VGND VPWR VPWR sky130_fd_sc_hd__decap_3
XFILLER_19_211 VGND VGND VPWR VPWR sky130_fd_sc_hd__decap_3
XFILLER_47_81 VGND VGND VPWR VPWR sky130_fd_sc_hd__fill_1
XFILLER_170_71 VGND VGND VPWR VPWR sky130_fd_sc_hd__decap_3
XFILLER_63_91 VGND VGND VPWR VPWR sky130_fd_sc_hd__decap_3
XFILLER_147_116 VGND VGND VPWR VPWR sky130_fd_sc_hd__decap_3
XFILLER_147_105 VGND VGND VPWR VPWR sky130_fd_sc_hd__decap_3
XFILLER_8_53 VGND VGND VPWR VPWR sky130_fd_sc_hd__decap_3
XFILLER_8_97 VGND VGND VPWR VPWR sky130_fd_sc_hd__decap_3
X_0724_ net137 net328 VGND VGND VPWR VPWR Tile_X0Y0_OpenRAM_top.Inst_OpenRAM_top_ConfigMem.Inst_frame1_bit30.Q
+ sky130_fd_sc_hd__dlxtp_1
XFILLER_170_141 VGND VGND VPWR VPWR sky130_fd_sc_hd__decap_3
XFILLER_170_130 VGND VGND VPWR VPWR sky130_fd_sc_hd__decap_3
XFILLER_155_193 VGND VGND VPWR VPWR sky130_fd_sc_hd__decap_3
XFILLER_6_192 VGND VGND VPWR VPWR sky130_fd_sc_hd__decap_3
X_0655_ Tile_X0Y1_OpenRAM_bot.Inst_OpenRAM_bot_ConfigMem.Inst_frame7_bit29.Q _0195_
+ Tile_X0Y1_OpenRAM_bot.Inst_OpenRAM_bot_ConfigMem.Inst_frame7_bit30.Q VGND VGND VPWR
+ VPWR _0196_ sky130_fd_sc_hd__a21bo_1
XFILLER_170_174 VGND VGND VPWR VPWR sky130_fd_sc_hd__decap_3
XFILLER_103_208 VGND VGND VPWR VPWR sky130_fd_sc_hd__decap_3
XFILLER_69_100 VGND VGND VPWR VPWR sky130_fd_sc_hd__decap_3
X_0586_ net206 net220 net194 _0156_ Tile_X0Y1_OpenRAM_bot.Inst_OpenRAM_bot_ConfigMem.Inst_frame3_bit16.Q
+ Tile_X0Y1_OpenRAM_bot.Inst_OpenRAM_bot_ConfigMem.Inst_frame3_bit17.Q VGND VGND VPWR
+ VPWR net671 sky130_fd_sc_hd__mux4_1
XFILLER_69_155 VGND VGND VPWR VPWR sky130_fd_sc_hd__decap_3
XFILLER_27_18 VGND VGND VPWR VPWR sky130_fd_sc_hd__decap_3
XFILLER_69_199 VGND VGND VPWR VPWR sky130_fd_sc_hd__decap_3
X_1207_ net228 net272 VGND VGND VPWR VPWR Tile_X0Y1_OpenRAM_bot.Inst_OpenRAM_bot_ConfigMem.Inst_frame7_bit15.Q
+ sky130_fd_sc_hd__dlxtp_1
XTAP_TAPCELL_ROW_107_799 VGND VPWR sky130_fd_sc_hd__tapvpwrvgnd_1
XTAP_TAPCELL_ROW_0_368 VGND VPWR sky130_fd_sc_hd__tapvpwrvgnd_1
X_1138_ net234 net289 VGND VGND VPWR VPWR Tile_X0Y1_OpenRAM_bot.Inst_OpenRAM_bot_ConfigMem.Inst_frame5_bit20.Q
+ sky130_fd_sc_hd__dlxtp_1
XFILLER_92_180 VGND VGND VPWR VPWR sky130_fd_sc_hd__decap_3
X_1069_ net239 net304 VGND VGND VPWR VPWR Tile_X0Y1_OpenRAM_bot.Inst_OpenRAM_bot_ConfigMem.Inst_frame3_bit25.Q
+ sky130_fd_sc_hd__dlxtp_1
XFILLER_153_119 VGND VGND VPWR VPWR sky130_fd_sc_hd__decap_3
XFILLER_175_27 VGND VGND VPWR VPWR sky130_fd_sc_hd__decap_3
XFILLER_146_171 VGND VGND VPWR VPWR sky130_fd_sc_hd__decap_3
XFILLER_4_118 VGND VGND VPWR VPWR sky130_fd_sc_hd__decap_3
XFILLER_104_6 VGND VGND VPWR VPWR sky130_fd_sc_hd__fill_2
XTAP_TAPCELL_ROW_8_402 VGND VPWR sky130_fd_sc_hd__tapvpwrvgnd_1
Xinput214 Tile_X0Y1_EE4END[2] VGND VGND VPWR VPWR net214 sky130_fd_sc_hd__buf_1
Xinput203 Tile_X0Y1_E6END[7] VGND VGND VPWR VPWR net203 sky130_fd_sc_hd__dlymetal6s2s_1
Xinput225 Tile_X0Y1_FrameData[12] VGND VGND VPWR VPWR net225 sky130_fd_sc_hd__clkbuf_4
Xinput236 Tile_X0Y1_FrameData[22] VGND VGND VPWR VPWR net236 sky130_fd_sc_hd__clkbuf_4
XFILLER_75_103 VGND VGND VPWR VPWR sky130_fd_sc_hd__decap_3
XFILLER_124_53 VGND VGND VPWR VPWR sky130_fd_sc_hd__decap_3
Xinput258 Tile_X0Y1_N2END[0] VGND VGND VPWR VPWR net341 sky130_fd_sc_hd__clkbuf_2
Xinput269 Tile_X0Y1_N2MID[3] VGND VGND VPWR VPWR net352 sky130_fd_sc_hd__buf_2
Xinput247 Tile_X0Y1_FrameData[3] VGND VGND VPWR VPWR net247 sky130_fd_sc_hd__clkbuf_4
XFILLER_124_97 VGND VGND VPWR VPWR sky130_fd_sc_hd__decap_3
XFILLER_84_79 VGND VGND VPWR VPWR sky130_fd_sc_hd__decap_3
XFILLER_17_84 VGND VGND VPWR VPWR sky130_fd_sc_hd__decap_3
XTAP_TAPCELL_ROW_14_426 VGND VPWR sky130_fd_sc_hd__tapvpwrvgnd_1
XFILLER_31_228 VGND VGND VPWR VPWR sky130_fd_sc_hd__decap_3
XFILLER_33_50 VGND VGND VPWR VPWR sky130_fd_sc_hd__decap_3
XFILLER_129_149 VGND VGND VPWR VPWR sky130_fd_sc_hd__decap_3
XFILLER_33_72 VGND VGND VPWR VPWR sky130_fd_sc_hd__decap_3
XFILLER_152_141 VGND VGND VPWR VPWR sky130_fd_sc_hd__decap_3
XFILLER_165_71 VGND VGND VPWR VPWR sky130_fd_sc_hd__decap_3
XFILLER_3_140 VGND VGND VPWR VPWR sky130_fd_sc_hd__decap_3
X_0440_ net67 net109 net102 Tile_X0Y0_OpenRAM_top.Inst_OpenRAM_top_switch_matrix.J_NS4_BEG13
+ Tile_X0Y0_OpenRAM_top.Inst_OpenRAM_top_ConfigMem.Inst_frame2_bit14.Q Tile_X0Y0_OpenRAM_top.Inst_OpenRAM_top_ConfigMem.Inst_frame2_bit15.Q
+ VGND VGND VPWR VPWR net407 sky130_fd_sc_hd__mux4_2
XFILLER_3_184 VGND VGND VPWR VPWR sky130_fd_sc_hd__decap_3
X_0371_ net11 net43 net258 Tile_X0Y0_OpenRAM_top.Inst_OpenRAM_top_switch_matrix.J_NS2_BEG6
+ Tile_X0Y0_OpenRAM_top.Inst_OpenRAM_top_ConfigMem.Inst_frame6_bit30.Q Tile_X0Y0_OpenRAM_top.Inst_OpenRAM_top_ConfigMem.Inst_frame6_bit31.Q
+ VGND VGND VPWR VPWR Tile_X0Y0_OpenRAM_top.Inst_OpenRAM_top_switch_matrix.W2BEG1
+ sky130_fd_sc_hd__mux4_1
XFILLER_66_147 VGND VGND VPWR VPWR sky130_fd_sc_hd__fill_1
XTAP_TAPCELL_ROW_37_518 VGND VPWR sky130_fd_sc_hd__tapvpwrvgnd_1
XFILLER_81_128 VGND VGND VPWR VPWR sky130_fd_sc_hd__decap_3
XTAP_TAPCELL_ROW_45_551 VGND VPWR sky130_fd_sc_hd__tapvpwrvgnd_1
XFILLER_175_211 VGND VGND VPWR VPWR sky130_fd_sc_hd__decap_3
XFILLER_135_119 VGND VGND VPWR VPWR sky130_fd_sc_hd__decap_3
XFILLER_128_171 VGND VGND VPWR VPWR sky130_fd_sc_hd__decap_3
X_0707_ net120 net334 VGND VGND VPWR VPWR Tile_X0Y0_OpenRAM_top.Inst_OpenRAM_top_ConfigMem.Inst_frame0_bit15.Q
+ sky130_fd_sc_hd__dlxtp_1
XFILLER_145_19 VGND VGND VPWR VPWR sky130_fd_sc_hd__decap_3
XFILLER_143_152 VGND VGND VPWR VPWR sky130_fd_sc_hd__decap_3
XFILLER_89_206 VGND VGND VPWR VPWR sky130_fd_sc_hd__decap_3
XFILLER_89_228 VGND VGND VPWR VPWR sky130_fd_sc_hd__fill_2
X_0638_ net175 net205 net213 _0155_ Tile_X0Y1_OpenRAM_bot.Inst_OpenRAM_bot_ConfigMem.Inst_frame8_bit28.Q
+ Tile_X0Y1_OpenRAM_bot.Inst_OpenRAM_bot_ConfigMem.Inst_frame8_bit27.Q VGND VGND VPWR
+ VPWR _0182_ sky130_fd_sc_hd__mux4_1
X_0569_ net7 net39 _0154_ net261 Tile_X0Y1_OpenRAM_bot.Inst_OpenRAM_bot_ConfigMem.Inst_frame4_bit10.Q
+ Tile_X0Y1_OpenRAM_bot.Inst_OpenRAM_bot_ConfigMem.Inst_frame4_bit11.Q VGND VGND VPWR
+ VPWR Tile_X0Y1_OpenRAM_bot.Inst_OpenRAM_bot_switch_matrix.WW4BEG13 sky130_fd_sc_hd__mux4_1
XTAP_TAPCELL_ROW_68_643 VGND VPWR sky130_fd_sc_hd__tapvpwrvgnd_1
XFILLER_173_9 VGND VGND VPWR VPWR sky130_fd_sc_hd__decap_3
XFILLER_72_117 VGND VGND VPWR VPWR sky130_fd_sc_hd__decap_3
XFILLER_54_38 VGND VGND VPWR VPWR sky130_fd_sc_hd__decap_3
XFILLER_65_191 VGND VGND VPWR VPWR sky130_fd_sc_hd__decap_3
XFILLER_80_161 VGND VGND VPWR VPWR sky130_fd_sc_hd__decap_3
XFILLER_110_44 VGND VGND VPWR VPWR sky130_fd_sc_hd__decap_3
XFILLER_13_228 VGND VGND VPWR VPWR sky130_fd_sc_hd__decap_3
XFILLER_13_217 VGND VGND VPWR VPWR sky130_fd_sc_hd__decap_3
XFILLER_80_194 VGND VGND VPWR VPWR sky130_fd_sc_hd__fill_2
XFILLER_166_200 VGND VGND VPWR VPWR sky130_fd_sc_hd__decap_3
XFILLER_110_77 VGND VGND VPWR VPWR sky130_fd_sc_hd__decap_3
XFILLER_70_15 VGND VGND VPWR VPWR sky130_fd_sc_hd__decap_3
XFILLER_110_88 VGND VGND VPWR VPWR sky130_fd_sc_hd__decap_3
XTAP_TAPCELL_ROW_51_576 VGND VPWR sky130_fd_sc_hd__tapvpwrvgnd_1
XFILLER_70_59 VGND VGND VPWR VPWR sky130_fd_sc_hd__decap_3
XFILLER_181_225 VGND VGND VPWR VPWR sky130_fd_sc_hd__fill_1
XFILLER_126_119 VGND VGND VPWR VPWR sky130_fd_sc_hd__decap_3
XFILLER_119_86 VGND VGND VPWR VPWR sky130_fd_sc_hd__decap_3
XFILLER_102_3 VGND VGND VPWR VPWR sky130_fd_sc_hd__decap_3
XFILLER_135_63 VGND VGND VPWR VPWR sky130_fd_sc_hd__decap_3
XFILLER_0_165 VGND VGND VPWR VPWR sky130_fd_sc_hd__decap_3
XFILLER_48_114 VGND VGND VPWR VPWR sky130_fd_sc_hd__decap_3
XFILLER_95_45 VGND VGND VPWR VPWR sky130_fd_sc_hd__decap_3
XFILLER_48_147 VGND VGND VPWR VPWR sky130_fd_sc_hd__decap_3
XFILLER_95_89 VGND VGND VPWR VPWR sky130_fd_sc_hd__decap_3
XFILLER_28_72 VGND VGND VPWR VPWR sky130_fd_sc_hd__decap_3
XFILLER_151_84 VGND VGND VPWR VPWR sky130_fd_sc_hd__decap_3
XTAP_TAPCELL_ROW_74_668 VGND VPWR sky130_fd_sc_hd__tapvpwrvgnd_1
XFILLER_157_211 VGND VGND VPWR VPWR sky130_fd_sc_hd__fill_1
XFILLER_8_221 VGND VGND VPWR VPWR sky130_fd_sc_hd__decap_3
XFILLER_172_203 VGND VGND VPWR VPWR sky130_fd_sc_hd__decap_3
XFILLER_117_119 VGND VGND VPWR VPWR sky130_fd_sc_hd__decap_3
XFILLER_60_70 VGND VGND VPWR VPWR sky130_fd_sc_hd__decap_3
XFILLER_60_81 VGND VGND VPWR VPWR sky130_fd_sc_hd__decap_3
Xoutput518 net601 VGND VGND VPWR VPWR Tile_X0Y1_S2BEGb[3] sky130_fd_sc_hd__buf_2
Xoutput507 net590 VGND VGND VPWR VPWR Tile_X0Y1_S2BEG[0] sky130_fd_sc_hd__buf_2
XFILLER_5_21 VGND VGND VPWR VPWR sky130_fd_sc_hd__decap_3
XFILLER_5_54 VGND VGND VPWR VPWR sky130_fd_sc_hd__fill_2
Xoutput529 net612 VGND VGND VPWR VPWR Tile_X0Y1_S4BEG[15] sky130_fd_sc_hd__buf_2
XFILLER_5_87 VGND VGND VPWR VPWR sky130_fd_sc_hd__decap_3
X_1472_ Tile_X0Y1_OpenRAM_bot.Inst_OpenRAM_bot_switch_matrix.W2BEG6 VGND VGND VPWR
+ VPWR net632 sky130_fd_sc_hd__buf_1
X_0423_ net47 Tile_X0Y0_OpenRAM_top.Inst_OpenRAM_top_switch_matrix.J_NS4_BEG7 _0095_
+ Tile_X0Y0_OpenRAM_top.Inst_OpenRAM_top_switch_matrix.J_NS2_BEG4 Tile_X0Y0_OpenRAM_top.Inst_OpenRAM_top_ConfigMem.Inst_frame3_bit13.Q
+ Tile_X0Y0_OpenRAM_top.Inst_OpenRAM_top_ConfigMem.Inst_frame3_bit12.Q VGND VGND VPWR
+ VPWR Tile_X0Y0_OpenRAM_top.Inst_OpenRAM_top_switch_matrix.W6BEG8 sky130_fd_sc_hd__mux4_1
XFILLER_86_209 VGND VGND VPWR VPWR sky130_fd_sc_hd__decap_3
XTAP_TAPCELL_ROW_109_806 VGND VPWR sky130_fd_sc_hd__tapvpwrvgnd_1
X_0354_ net356 net348 Tile_X0Y0_OpenRAM_top.Inst_OpenRAM_top_switch_matrix.S2BEG7
+ net165 Tile_X0Y1_OpenRAM_bot.Inst_OpenRAM_bot_ConfigMem.Inst_frame0_bit22.Q Tile_X0Y1_OpenRAM_bot.Inst_OpenRAM_bot_ConfigMem.Inst_frame0_bit23.Q
+ VGND VGND VPWR VPWR _0087_ sky130_fd_sc_hd__mux4_2
XFILLER_39_169 VGND VGND VPWR VPWR sky130_fd_sc_hd__decap_3
XFILLER_54_106 VGND VGND VPWR VPWR sky130_fd_sc_hd__decap_3
X_0285_ net189 net192 net179 net180 Tile_X0Y1_OpenRAM_bot.Inst_OpenRAM_bot_ConfigMem.Inst_frame2_bit28.Q
+ Tile_X0Y1_OpenRAM_bot.Inst_OpenRAM_bot_ConfigMem.Inst_frame2_bit29.Q VGND VGND VPWR
+ VPWR _0054_ sky130_fd_sc_hd__mux4_1
XFILLER_54_139 VGND VGND VPWR VPWR sky130_fd_sc_hd__fill_1
XFILLER_62_183 VGND VGND VPWR VPWR sky130_fd_sc_hd__fill_1
XFILLER_10_209 VGND VGND VPWR VPWR sky130_fd_sc_hd__decap_3
XTAP_TAPCELL_ROW_100_772 VGND VPWR sky130_fd_sc_hd__tapvpwrvgnd_1
XFILLER_163_225 VGND VGND VPWR VPWR sky130_fd_sc_hd__decap_3
XFILLER_163_214 VGND VGND VPWR VPWR sky130_fd_sc_hd__fill_2
XFILLER_40_29 VGND VGND VPWR VPWR sky130_fd_sc_hd__decap_3
XFILLER_156_29 VGND VGND VPWR VPWR sky130_fd_sc_hd__decap_3
XFILLER_116_141 VGND VGND VPWR VPWR sky130_fd_sc_hd__decap_3
XFILLER_131_111 VGND VGND VPWR VPWR sky130_fd_sc_hd__fill_1
XFILLER_49_16 VGND VGND VPWR VPWR sky130_fd_sc_hd__decap_3
XFILLER_105_33 VGND VGND VPWR VPWR sky130_fd_sc_hd__decap_3
XFILLER_105_66 VGND VGND VPWR VPWR sky130_fd_sc_hd__decap_3
XFILLER_85_220 VGND VGND VPWR VPWR sky130_fd_sc_hd__decap_3
XFILLER_45_106 VGND VGND VPWR VPWR sky130_fd_sc_hd__decap_3
XFILLER_65_48 VGND VGND VPWR VPWR sky130_fd_sc_hd__decap_3
XFILLER_60_109 VGND VGND VPWR VPWR sky130_fd_sc_hd__decap_3
XTAP_TAPCELL_ROW_123_864 VGND VPWR sky130_fd_sc_hd__tapvpwrvgnd_1
XFILLER_121_87 VGND VGND VPWR VPWR sky130_fd_sc_hd__decap_3
XFILLER_121_54 VGND VGND VPWR VPWR sky130_fd_sc_hd__fill_2
XFILLER_53_172 VGND VGND VPWR VPWR sky130_fd_sc_hd__decap_3
XFILLER_81_69 VGND VGND VPWR VPWR sky130_fd_sc_hd__decap_3
XFILLER_139_222 VGND VGND VPWR VPWR sky130_fd_sc_hd__fill_2
XFILLER_154_203 VGND VGND VPWR VPWR sky130_fd_sc_hd__fill_2
XPHY_EDGE_ROW_101_Left_284 VGND VGND VPWR VPWR sky130_fd_sc_hd__decap_3
XFILLER_5_202 VGND VGND VPWR VPWR sky130_fd_sc_hd__decap_3
XFILLER_107_163 VGND VGND VPWR VPWR sky130_fd_sc_hd__decap_3
XFILLER_30_62 VGND VGND VPWR VPWR sky130_fd_sc_hd__decap_3
XFILLER_146_73 VGND VGND VPWR VPWR sky130_fd_sc_hd__fill_1
XFILLER_122_100 VGND VGND VPWR VPWR sky130_fd_sc_hd__decap_3
XFILLER_107_185 VGND VGND VPWR VPWR sky130_fd_sc_hd__decap_3
XFILLER_122_144 VGND VGND VPWR VPWR sky130_fd_sc_hd__decap_3
XFILLER_122_133 VGND VGND VPWR VPWR sky130_fd_sc_hd__decap_3
XFILLER_68_209 VGND VGND VPWR VPWR sky130_fd_sc_hd__decap_3
XFILLER_162_50 VGND VGND VPWR VPWR sky130_fd_sc_hd__decap_3
XFILLER_39_93 VGND VGND VPWR VPWR sky130_fd_sc_hd__decap_3
XFILLER_162_83 VGND VGND VPWR VPWR sky130_fd_sc_hd__fill_1
XTAP_TAPCELL_ROW_146_956 VGND VPWR sky130_fd_sc_hd__tapvpwrvgnd_1
XPHY_EDGE_ROW_110_Left_293 VGND VGND VPWR VPWR sky130_fd_sc_hd__decap_3
XFILLER_36_139 VGND VGND VPWR VPWR sky130_fd_sc_hd__fill_1
XFILLER_91_223 VGND VGND VPWR VPWR sky130_fd_sc_hd__fill_1
XFILLER_44_172 VGND VGND VPWR VPWR sky130_fd_sc_hd__decap_3
XFILLER_55_92 VGND VGND VPWR VPWR sky130_fd_sc_hd__decap_3
XFILLER_44_194 VGND VGND VPWR VPWR sky130_fd_sc_hd__fill_2
X_0972_ net240 net330 VGND VGND VPWR VPWR Tile_X0Y1_OpenRAM_bot.Inst_OpenRAM_bot_ConfigMem.Inst_frame0_bit26.Q
+ sky130_fd_sc_hd__dlxtp_1
XFILLER_71_91 VGND VGND VPWR VPWR sky130_fd_sc_hd__decap_3
XFILLER_145_225 VGND VGND VPWR VPWR sky130_fd_sc_hd__decap_3
Xoutput326 net409 VGND VGND VPWR VPWR DIN_A_SRAM30 sky130_fd_sc_hd__buf_2
Xoutput315 net398 VGND VGND VPWR VPWR DIN_A_SRAM20 sky130_fd_sc_hd__buf_2
Xoutput304 net387 VGND VGND VPWR VPWR DIN_A_SRAM10 sky130_fd_sc_hd__buf_2
Xoutput348 net431 VGND VGND VPWR VPWR Tile_X0Y0_FrameData_O[22] sky130_fd_sc_hd__buf_2
Xoutput337 net420 VGND VGND VPWR VPWR Tile_X0Y0_FrameData_O[12] sky130_fd_sc_hd__buf_2
Xoutput359 net442 VGND VGND VPWR VPWR Tile_X0Y0_FrameData_O[3] sky130_fd_sc_hd__buf_2
XFILLER_113_122 VGND VGND VPWR VPWR sky130_fd_sc_hd__decap_3
XFILLER_113_100 VGND VGND VPWR VPWR sky130_fd_sc_hd__decap_3
XFILLER_113_155 VGND VGND VPWR VPWR sky130_fd_sc_hd__fill_2
X_1455_ Tile_X0Y0_OpenRAM_top.Inst_OpenRAM_top_switch_matrix.S4BEG1 VGND VGND VPWR
+ VPWR net621 sky130_fd_sc_hd__buf_6
XFILLER_113_199 VGND VGND VPWR VPWR sky130_fd_sc_hd__decap_3
XFILLER_113_166 VGND VGND VPWR VPWR sky130_fd_sc_hd__fill_2
X_0406_ net22 net54 Tile_X0Y0_OpenRAM_top.Inst_OpenRAM_top_switch_matrix.J_NS4_BEG4
+ Tile_X0Y0_OpenRAM_top.Inst_OpenRAM_top_switch_matrix.J_NS2_BEG4 Tile_X0Y0_OpenRAM_top.Inst_OpenRAM_top_ConfigMem.Inst_frame4_bit18.Q
+ Tile_X0Y0_OpenRAM_top.Inst_OpenRAM_top_ConfigMem.Inst_frame4_bit19.Q VGND VGND VPWR
+ VPWR Tile_X0Y0_OpenRAM_top.Inst_OpenRAM_top_switch_matrix.WW4BEG11 sky130_fd_sc_hd__mux4_1
X_1386_ Tile_X0Y0_OpenRAM_top.Inst_OpenRAM_top_switch_matrix.WW4BEG8 VGND VGND VPWR
+ VPWR net552 sky130_fd_sc_hd__clkbuf_1
X_0337_ net82 net74 net92 net256 Tile_X0Y0_OpenRAM_top.Inst_OpenRAM_top_ConfigMem.Inst_frame8_bit26.Q
+ Tile_X0Y0_OpenRAM_top.Inst_OpenRAM_top_ConfigMem.Inst_frame8_bit27.Q VGND VGND VPWR
+ VPWR Tile_X0Y0_OpenRAM_top.Inst_OpenRAM_top_switch_matrix.N2BEG3 sky130_fd_sc_hd__mux4_1
XFILLER_27_128 VGND VGND VPWR VPWR sky130_fd_sc_hd__decap_3
XFILLER_82_223 VGND VGND VPWR VPWR sky130_fd_sc_hd__fill_1
X_0268_ net189 net192 net179 net180 Tile_X0Y1_OpenRAM_bot.Inst_OpenRAM_bot_ConfigMem.Inst_frame3_bit8.Q
+ Tile_X0Y1_OpenRAM_bot.Inst_OpenRAM_bot_ConfigMem.Inst_frame3_bit9.Q VGND VGND VPWR
+ VPWR _0038_ sky130_fd_sc_hd__mux4_1
XFILLER_35_161 VGND VGND VPWR VPWR sky130_fd_sc_hd__decap_3
XFILLER_50_153 VGND VGND VPWR VPWR sky130_fd_sc_hd__decap_3
XFILLER_50_197 VGND VGND VPWR VPWR sky130_fd_sc_hd__fill_2
XFILLER_51_39 VGND VGND VPWR VPWR sky130_fd_sc_hd__fill_2
XFILLER_167_39 VGND VGND VPWR VPWR sky130_fd_sc_hd__decap_3
XFILLER_151_206 VGND VGND VPWR VPWR sky130_fd_sc_hd__decap_3
XFILLER_151_228 VGND VGND VPWR VPWR sky130_fd_sc_hd__fill_2
XFILLER_104_100 VGND VGND VPWR VPWR sky130_fd_sc_hd__decap_3
XFILLER_116_32 VGND VGND VPWR VPWR sky130_fd_sc_hd__decap_3
XFILLER_104_144 VGND VGND VPWR VPWR sky130_fd_sc_hd__decap_3
XFILLER_116_65 VGND VGND VPWR VPWR sky130_fd_sc_hd__decap_3
XFILLER_76_47 VGND VGND VPWR VPWR sky130_fd_sc_hd__decap_3
XFILLER_132_53 VGND VGND VPWR VPWR sky130_fd_sc_hd__decap_3
XFILLER_73_212 VGND VGND VPWR VPWR sky130_fd_sc_hd__decap_3
XFILLER_92_24 VGND VGND VPWR VPWR sky130_fd_sc_hd__decap_3
XFILLER_92_35 VGND VGND VPWR VPWR sky130_fd_sc_hd__decap_3
XFILLER_26_150 VGND VGND VPWR VPWR sky130_fd_sc_hd__decap_3
XFILLER_26_183 VGND VGND VPWR VPWR sky130_fd_sc_hd__decap_3
XPHY_EDGE_ROW_153_Right_153 VGND VGND VPWR VPWR sky130_fd_sc_hd__decap_3
XFILLER_41_164 VGND VGND VPWR VPWR sky130_fd_sc_hd__decap_3
XFILLER_41_175 VGND VGND VPWR VPWR sky130_fd_sc_hd__decap_3
XFILLER_41_50 VGND VGND VPWR VPWR sky130_fd_sc_hd__decap_3
XFILLER_41_72 VGND VGND VPWR VPWR sky130_fd_sc_hd__decap_3
XFILLER_157_72 VGND VGND VPWR VPWR sky130_fd_sc_hd__decap_3
XFILLER_142_206 VGND VGND VPWR VPWR sky130_fd_sc_hd__fill_1
XFILLER_173_60 VGND VGND VPWR VPWR sky130_fd_sc_hd__decap_3
XFILLER_110_114 VGND VGND VPWR VPWR sky130_fd_sc_hd__decap_3
XFILLER_173_93 VGND VGND VPWR VPWR sky130_fd_sc_hd__decap_3
X_1240_ net227 net267 VGND VGND VPWR VPWR Tile_X0Y1_OpenRAM_bot.Inst_OpenRAM_bot_ConfigMem.Inst_frame8_bit14.Q
+ sky130_fd_sc_hd__dlxtp_1
XFILLER_110_158 VGND VGND VPWR VPWR sky130_fd_sc_hd__fill_2
X_1171_ net232 net279 VGND VGND VPWR VPWR Tile_X0Y1_OpenRAM_bot.Inst_OpenRAM_bot_ConfigMem.Inst_frame6_bit19.Q
+ sky130_fd_sc_hd__dlxtp_1
XFILLER_2_88 VGND VGND VPWR VPWR sky130_fd_sc_hd__decap_3
XFILLER_64_212 VGND VGND VPWR VPWR sky130_fd_sc_hd__decap_3
XFILLER_17_161 VGND VGND VPWR VPWR sky130_fd_sc_hd__decap_3
XTAP_TAPCELL_ROW_90_733 VGND VPWR sky130_fd_sc_hd__tapvpwrvgnd_1
XFILLER_177_125 VGND VGND VPWR VPWR sky130_fd_sc_hd__decap_3
XFILLER_32_153 VGND VGND VPWR VPWR sky130_fd_sc_hd__decap_3
XFILLER_177_169 VGND VGND VPWR VPWR sky130_fd_sc_hd__decap_3
XFILLER_177_158 VGND VGND VPWR VPWR sky130_fd_sc_hd__decap_3
XPHY_EDGE_ROW_120_Right_120 VGND VGND VPWR VPWR sky130_fd_sc_hd__decap_3
XFILLER_32_186 VGND VGND VPWR VPWR sky130_fd_sc_hd__decap_3
X_0955_ net129 net269 VGND VGND VPWR VPWR Tile_X0Y0_OpenRAM_top.Inst_OpenRAM_top_ConfigMem.Inst_frame8_bit23.Q
+ sky130_fd_sc_hd__dlxtp_1
X_0886_ net134 net282 VGND VGND VPWR VPWR Tile_X0Y0_OpenRAM_top.Inst_OpenRAM_top_ConfigMem.Inst_frame6_bit28.Q
+ sky130_fd_sc_hd__dlxtp_1
XFILLER_133_228 VGND VGND VPWR VPWR sky130_fd_sc_hd__fill_2
XFILLER_99_153 VGND VGND VPWR VPWR sky130_fd_sc_hd__decap_3
XFILLER_99_175 VGND VGND VPWR VPWR sky130_fd_sc_hd__decap_3
X_1507_ Tile_X0Y1_OpenRAM_bot.Inst_OpenRAM_bot_switch_matrix.WW4BEG13 VGND VGND VPWR
+ VPWR net658 sky130_fd_sc_hd__buf_1
X_1438_ Tile_X0Y0_OpenRAM_top.Inst_OpenRAM_top_switch_matrix.S2BEG0 VGND VGND VPWR
+ VPWR net598 sky130_fd_sc_hd__buf_6
XFILLER_101_169 VGND VGND VPWR VPWR sky130_fd_sc_hd__decap_3
X_1369_ Tile_X0Y0_OpenRAM_top.Inst_OpenRAM_top_switch_matrix.W6BEG3 VGND VGND VPWR
+ VPWR net531 sky130_fd_sc_hd__clkbuf_1
XFILLER_15_109 VGND VGND VPWR VPWR sky130_fd_sc_hd__decap_3
XFILLER_178_27 VGND VGND VPWR VPWR sky130_fd_sc_hd__fill_1
XFILLER_168_103 VGND VGND VPWR VPWR sky130_fd_sc_hd__decap_3
XFILLER_62_38 VGND VGND VPWR VPWR sky130_fd_sc_hd__decap_3
XFILLER_178_38 VGND VGND VPWR VPWR sky130_fd_sc_hd__decap_3
XFILLER_176_180 VGND VGND VPWR VPWR sky130_fd_sc_hd__decap_3
XFILLER_124_206 VGND VGND VPWR VPWR sky130_fd_sc_hd__decap_3
XFILLER_11_31 VGND VGND VPWR VPWR sky130_fd_sc_hd__decap_3
XFILLER_127_31 VGND VGND VPWR VPWR sky130_fd_sc_hd__decap_3
XFILLER_11_75 VGND VGND VPWR VPWR sky130_fd_sc_hd__decap_3
XFILLER_87_24 VGND VGND VPWR VPWR sky130_fd_sc_hd__decap_3
XFILLER_127_86 VGND VGND VPWR VPWR sky130_fd_sc_hd__fill_1
XFILLER_87_57 VGND VGND VPWR VPWR sky130_fd_sc_hd__decap_3
XTAP_TAPCELL_ROW_6_396 VGND VPWR sky130_fd_sc_hd__tapvpwrvgnd_1
XTAP_TAPCELL_ROW_29_487 VGND VPWR sky130_fd_sc_hd__tapvpwrvgnd_1
XFILLER_36_50 VGND VGND VPWR VPWR sky130_fd_sc_hd__decap_3
XFILLER_36_94 VGND VGND VPWR VPWR sky130_fd_sc_hd__decap_3
XFILLER_159_125 VGND VGND VPWR VPWR sky130_fd_sc_hd__decap_3
XFILLER_99_9 VGND VGND VPWR VPWR sky130_fd_sc_hd__decap_3
XFILLER_14_153 VGND VGND VPWR VPWR sky130_fd_sc_hd__decap_3
XFILLER_159_169 VGND VGND VPWR VPWR sky130_fd_sc_hd__decap_3
XFILLER_159_158 VGND VGND VPWR VPWR sky130_fd_sc_hd__decap_3
XFILLER_14_197 VGND VGND VPWR VPWR sky130_fd_sc_hd__decap_3
XFILLER_14_186 VGND VGND VPWR VPWR sky130_fd_sc_hd__decap_3
XFILLER_174_106 VGND VGND VPWR VPWR sky130_fd_sc_hd__decap_3
XTAP_TAPCELL_ROW_175_1071 VGND VPWR sky130_fd_sc_hd__tapvpwrvgnd_1
XFILLER_174_139 VGND VGND VPWR VPWR sky130_fd_sc_hd__fill_1
XFILLER_168_71 VGND VGND VPWR VPWR sky130_fd_sc_hd__decap_3
X_0740_ net119 net328 VGND VGND VPWR VPWR Tile_X0Y0_OpenRAM_top.Inst_OpenRAM_top_ConfigMem.Inst_frame1_bit14.Q
+ sky130_fd_sc_hd__dlxtp_1
Xinput14 DOUT_A_SRAM2 VGND VGND VPWR VPWR net14 sky130_fd_sc_hd__buf_1
Xinput25 DOUT_A_SRAM3 VGND VGND VPWR VPWR net25 sky130_fd_sc_hd__clkbuf_2
Xinput36 DOUT_B_SRAM10 VGND VGND VPWR VPWR net36 sky130_fd_sc_hd__clkbuf_1
Xinput69 Tile_X0Y0_E1END[3] VGND VGND VPWR VPWR net69 sky130_fd_sc_hd__clkbuf_2
Xinput47 DOUT_B_SRAM20 VGND VGND VPWR VPWR net47 sky130_fd_sc_hd__clkbuf_2
Xinput58 DOUT_B_SRAM30 VGND VGND VPWR VPWR net58 sky130_fd_sc_hd__dlymetal6s2s_1
XFILLER_115_228 VGND VGND VPWR VPWR sky130_fd_sc_hd__fill_2
X_0671_ Tile_X0Y1_OpenRAM_bot.Inst_OpenRAM_bot_ConfigMem.Inst_frame6_bit6.Q _0208_
+ VGND VGND VPWR VPWR _0209_ sky130_fd_sc_hd__and2b_1
XFILLER_130_209 VGND VGND VPWR VPWR sky130_fd_sc_hd__decap_3
XFILLER_96_156 VGND VGND VPWR VPWR sky130_fd_sc_hd__decap_3
X_1223_ net246 net266 VGND VGND VPWR VPWR Tile_X0Y1_OpenRAM_bot.Inst_OpenRAM_bot_ConfigMem.Inst_frame8_bit31.Q
+ sky130_fd_sc_hd__dlxtp_1
XFILLER_37_223 VGND VGND VPWR VPWR sky130_fd_sc_hd__fill_1
X_1154_ net248 net289 VGND VGND VPWR VPWR Tile_X0Y1_OpenRAM_bot.Inst_OpenRAM_bot_ConfigMem.Inst_frame5_bit4.Q
+ sky130_fd_sc_hd__dlxtp_1
X_1085_ net253 net306 VGND VGND VPWR VPWR Tile_X0Y1_OpenRAM_bot.Inst_OpenRAM_bot_ConfigMem.Inst_frame3_bit9.Q
+ sky130_fd_sc_hd__dlxtp_1
XFILLER_148_19 VGND VGND VPWR VPWR sky130_fd_sc_hd__decap_3
XFILLER_20_156 VGND VGND VPWR VPWR sky130_fd_sc_hd__decap_3
XFILLER_20_134 VGND VGND VPWR VPWR sky130_fd_sc_hd__decap_3
XFILLER_165_128 VGND VGND VPWR VPWR sky130_fd_sc_hd__decap_3
X_0938_ net144 net276 VGND VGND VPWR VPWR Tile_X0Y0_OpenRAM_top.Inst_OpenRAM_top_ConfigMem.Inst_frame7_bit8.Q
+ sky130_fd_sc_hd__dlxtp_1
XFILLER_20_189 VGND VGND VPWR VPWR sky130_fd_sc_hd__decap_3
XFILLER_180_109 VGND VGND VPWR VPWR sky130_fd_sc_hd__decap_3
XFILLER_9_190 VGND VGND VPWR VPWR sky130_fd_sc_hd__decap_3
XFILLER_173_172 VGND VGND VPWR VPWR sky130_fd_sc_hd__decap_3
XFILLER_173_161 VGND VGND VPWR VPWR sky130_fd_sc_hd__decap_3
X_0869_ net118 net295 VGND VGND VPWR VPWR Tile_X0Y0_OpenRAM_top.Inst_OpenRAM_top_ConfigMem.Inst_frame5_bit13.Q
+ sky130_fd_sc_hd__dlxtp_1
XFILLER_164_29 VGND VGND VPWR VPWR sky130_fd_sc_hd__decap_3
XFILLER_164_18 VGND VGND VPWR VPWR sky130_fd_sc_hd__decap_3
XFILLER_57_16 VGND VGND VPWR VPWR sky130_fd_sc_hd__decap_3
XFILLER_87_145 VGND VGND VPWR VPWR sky130_fd_sc_hd__decap_3
XFILLER_113_55 VGND VGND VPWR VPWR sky130_fd_sc_hd__fill_1
XFILLER_113_33 VGND VGND VPWR VPWR sky130_fd_sc_hd__fill_1
XFILLER_43_204 VGND VGND VPWR VPWR sky130_fd_sc_hd__fill_2
XFILLER_73_15 VGND VGND VPWR VPWR sky130_fd_sc_hd__fill_1
XFILLER_73_37 VGND VGND VPWR VPWR sky130_fd_sc_hd__decap_3
XFILLER_156_106 VGND VGND VPWR VPWR sky130_fd_sc_hd__decap_3
XFILLER_11_134 VGND VGND VPWR VPWR sky130_fd_sc_hd__decap_3
XFILLER_7_105 VGND VGND VPWR VPWR sky130_fd_sc_hd__decap_3
XFILLER_156_139 VGND VGND VPWR VPWR sky130_fd_sc_hd__fill_1
XFILLER_11_167 VGND VGND VPWR VPWR sky130_fd_sc_hd__fill_1
XFILLER_7_116 VGND VGND VPWR VPWR sky130_fd_sc_hd__decap_3
XFILLER_138_41 VGND VGND VPWR VPWR sky130_fd_sc_hd__decap_3
XFILLER_7_149 VGND VGND VPWR VPWR sky130_fd_sc_hd__decap_3
XFILLER_22_85 VGND VGND VPWR VPWR sky130_fd_sc_hd__decap_3
XFILLER_164_183 VGND VGND VPWR VPWR sky130_fd_sc_hd__decap_3
XFILLER_138_85 VGND VGND VPWR VPWR sky130_fd_sc_hd__decap_3
XFILLER_98_12 VGND VGND VPWR VPWR sky130_fd_sc_hd__decap_3
XFILLER_98_67 VGND VGND VPWR VPWR sky130_fd_sc_hd__decap_3
XFILLER_120_231 VGND VGND VPWR VPWR sky130_fd_sc_hd__decap_3
XFILLER_78_123 VGND VGND VPWR VPWR sky130_fd_sc_hd__decap_3
XTAP_TAPCELL_ROW_166_1037 VGND VPWR sky130_fd_sc_hd__tapvpwrvgnd_1
XFILLER_78_156 VGND VGND VPWR VPWR sky130_fd_sc_hd__decap_3
XFILLER_93_104 VGND VGND VPWR VPWR sky130_fd_sc_hd__decap_3
XFILLER_19_223 VGND VGND VPWR VPWR sky130_fd_sc_hd__fill_1
XFILLER_78_189 VGND VGND VPWR VPWR sky130_fd_sc_hd__decap_3
XFILLER_93_137 VGND VGND VPWR VPWR sky130_fd_sc_hd__decap_3
XFILLER_170_50 VGND VGND VPWR VPWR sky130_fd_sc_hd__decap_3
XFILLER_93_159 VGND VGND VPWR VPWR sky130_fd_sc_hd__decap_3
XFILLER_170_83 VGND VGND VPWR VPWR sky130_fd_sc_hd__fill_1
XFILLER_179_209 VGND VGND VPWR VPWR sky130_fd_sc_hd__decap_3
XFILLER_170_94 VGND VGND VPWR VPWR sky130_fd_sc_hd__decap_3
XFILLER_179_81 VGND VGND VPWR VPWR sky130_fd_sc_hd__decap_3
XFILLER_8_32 VGND VGND VPWR VPWR sky130_fd_sc_hd__decap_3
XFILLER_8_21 VGND VGND VPWR VPWR sky130_fd_sc_hd__decap_3
XFILLER_8_65 VGND VGND VPWR VPWR sky130_fd_sc_hd__decap_3
XFILLER_155_161 VGND VGND VPWR VPWR sky130_fd_sc_hd__decap_3
X_0723_ net138 net328 VGND VGND VPWR VPWR Tile_X0Y0_OpenRAM_top.Inst_OpenRAM_top_ConfigMem.Inst_frame1_bit31.Q
+ sky130_fd_sc_hd__dlxtp_1
XFILLER_6_171 VGND VGND VPWR VPWR sky130_fd_sc_hd__decap_3
X_0654_ Tile_X0Y1_OpenRAM_bot.Inst_OpenRAM_bot_switch_matrix.J_NS4_BEG12 _0084_ Tile_X0Y1_OpenRAM_bot.Inst_OpenRAM_bot_ConfigMem.Inst_frame7_bit28.Q
+ VGND VGND VPWR VPWR _0195_ sky130_fd_sc_hd__mux2_1
XFILLER_170_153 VGND VGND VPWR VPWR sky130_fd_sc_hd__decap_3
XFILLER_170_197 VGND VGND VPWR VPWR sky130_fd_sc_hd__decap_3
XFILLER_170_186 VGND VGND VPWR VPWR sky130_fd_sc_hd__decap_3
XFILLER_111_220 VGND VGND VPWR VPWR sky130_fd_sc_hd__decap_3
X_0585_ net63 _0152_ _0156_ _0087_ Tile_X0Y1_OpenRAM_bot.Inst_OpenRAM_bot_ConfigMem.Inst_frame3_bit7.Q
+ Tile_X0Y1_OpenRAM_bot.Inst_OpenRAM_bot_ConfigMem.Inst_frame3_bit6.Q VGND VGND VPWR
+ VPWR Tile_X0Y1_OpenRAM_bot.Inst_OpenRAM_bot_switch_matrix.W6BEG11 sky130_fd_sc_hd__mux4_1
XFILLER_69_134 VGND VGND VPWR VPWR sky130_fd_sc_hd__decap_3
XFILLER_69_167 VGND VGND VPWR VPWR sky130_fd_sc_hd__fill_1
XFILLER_69_178 VGND VGND VPWR VPWR sky130_fd_sc_hd__decap_3
X_1206_ net229 net271 VGND VGND VPWR VPWR Tile_X0Y1_OpenRAM_bot.Inst_OpenRAM_bot_ConfigMem.Inst_frame7_bit16.Q
+ sky130_fd_sc_hd__dlxtp_1
XFILLER_84_159 VGND VGND VPWR VPWR sky130_fd_sc_hd__decap_3
X_1137_ net235 net289 VGND VGND VPWR VPWR Tile_X0Y1_OpenRAM_bot.Inst_OpenRAM_bot_ConfigMem.Inst_frame5_bit21.Q
+ sky130_fd_sc_hd__dlxtp_1
XTAP_TAPCELL_ROW_0_369 VGND VPWR sky130_fd_sc_hd__tapvpwrvgnd_1
XFILLER_92_192 VGND VGND VPWR VPWR sky130_fd_sc_hd__decap_3
X_1068_ net240 net304 VGND VGND VPWR VPWR Tile_X0Y1_OpenRAM_bot.Inst_OpenRAM_bot_ConfigMem.Inst_frame3_bit26.Q
+ sky130_fd_sc_hd__dlxtp_1
XFILLER_138_128 VGND VGND VPWR VPWR sky130_fd_sc_hd__decap_3
XFILLER_175_39 VGND VGND VPWR VPWR sky130_fd_sc_hd__decap_3
XFILLER_161_131 VGND VGND VPWR VPWR sky130_fd_sc_hd__decap_3
XTAP_TAPCELL_ROW_8_403 VGND VPWR sky130_fd_sc_hd__tapvpwrvgnd_1
XFILLER_161_175 VGND VGND VPWR VPWR sky130_fd_sc_hd__decap_3
XFILLER_68_26 VGND VGND VPWR VPWR sky130_fd_sc_hd__fill_2
XFILLER_124_21 VGND VGND VPWR VPWR sky130_fd_sc_hd__decap_3
Xinput215 Tile_X0Y1_EE4END[3] VGND VGND VPWR VPWR net215 sky130_fd_sc_hd__buf_1
Xinput204 Tile_X0Y1_E6END[8] VGND VGND VPWR VPWR net204 sky130_fd_sc_hd__buf_1
Xinput226 Tile_X0Y1_FrameData[13] VGND VGND VPWR VPWR net226 sky130_fd_sc_hd__clkbuf_4
XFILLER_124_65 VGND VGND VPWR VPWR sky130_fd_sc_hd__decap_3
XFILLER_124_32 VGND VGND VPWR VPWR sky130_fd_sc_hd__decap_3
Xinput259 Tile_X0Y1_N2END[1] VGND VGND VPWR VPWR net342 sky130_fd_sc_hd__clkbuf_2
Xinput248 Tile_X0Y1_FrameData[4] VGND VGND VPWR VPWR net248 sky130_fd_sc_hd__clkbuf_4
Xinput237 Tile_X0Y1_FrameData[23] VGND VGND VPWR VPWR net237 sky130_fd_sc_hd__clkbuf_4
XFILLER_75_137 VGND VGND VPWR VPWR sky130_fd_sc_hd__decap_3
XFILLER_17_41 VGND VGND VPWR VPWR sky130_fd_sc_hd__decap_3
XFILLER_16_215 VGND VGND VPWR VPWR sky130_fd_sc_hd__decap_3
XFILLER_17_63 VGND VGND VPWR VPWR sky130_fd_sc_hd__decap_3
XFILLER_140_53 VGND VGND VPWR VPWR sky130_fd_sc_hd__decap_3
XFILLER_169_220 VGND VGND VPWR VPWR sky130_fd_sc_hd__decap_3
XTAP_TAPCELL_ROW_14_427 VGND VPWR sky130_fd_sc_hd__tapvpwrvgnd_1
XFILLER_149_40 VGND VGND VPWR VPWR sky130_fd_sc_hd__decap_3
XTAP_TAPCELL_ROW_22_460 VGND VPWR sky130_fd_sc_hd__tapvpwrvgnd_1
XFILLER_33_84 VGND VGND VPWR VPWR sky130_fd_sc_hd__decap_3
XFILLER_149_84 VGND VGND VPWR VPWR sky130_fd_sc_hd__decap_3
XFILLER_137_172 VGND VGND VPWR VPWR sky130_fd_sc_hd__decap_3
XFILLER_137_150 VGND VGND VPWR VPWR sky130_fd_sc_hd__decap_3
XFILLER_152_164 VGND VGND VPWR VPWR sky130_fd_sc_hd__decap_3
XFILLER_98_218 VGND VGND VPWR VPWR sky130_fd_sc_hd__decap_3
XFILLER_3_152 VGND VGND VPWR VPWR sky130_fd_sc_hd__fill_2
XFILLER_3_163 VGND VGND VPWR VPWR sky130_fd_sc_hd__decap_3
XFILLER_165_83 VGND VGND VPWR VPWR sky130_fd_sc_hd__decap_3
XFILLER_152_197 VGND VGND VPWR VPWR sky130_fd_sc_hd__decap_3
XFILLER_3_196 VGND VGND VPWR VPWR sky130_fd_sc_hd__decap_3
X_0370_ net10 net42 net259 Tile_X0Y0_OpenRAM_top.Inst_OpenRAM_top_switch_matrix.J_NS2_BEG7
+ Tile_X0Y0_OpenRAM_top.Inst_OpenRAM_top_ConfigMem.Inst_frame6_bit28.Q Tile_X0Y0_OpenRAM_top.Inst_OpenRAM_top_ConfigMem.Inst_frame6_bit29.Q
+ VGND VGND VPWR VPWR Tile_X0Y0_OpenRAM_top.Inst_OpenRAM_top_switch_matrix.W2BEG0
+ sky130_fd_sc_hd__mux4_1
XTAP_TAPCELL_ROW_37_519 VGND VPWR sky130_fd_sc_hd__tapvpwrvgnd_1
XFILLER_74_181 VGND VGND VPWR VPWR sky130_fd_sc_hd__decap_3
XTAP_TAPCELL_ROW_45_552 VGND VPWR sky130_fd_sc_hd__tapvpwrvgnd_1
XFILLER_74_80 VGND VGND VPWR VPWR sky130_fd_sc_hd__decap_3
XFILLER_95_3 VGND VGND VPWR VPWR sky130_fd_sc_hd__fill_2
XFILLER_175_223 VGND VGND VPWR VPWR sky130_fd_sc_hd__fill_1
XFILLER_128_150 VGND VGND VPWR VPWR sky130_fd_sc_hd__decap_3
XFILLER_143_131 VGND VGND VPWR VPWR sky130_fd_sc_hd__decap_3
XFILLER_128_183 VGND VGND VPWR VPWR sky130_fd_sc_hd__decap_3
X_0706_ net121 net335 VGND VGND VPWR VPWR Tile_X0Y0_OpenRAM_top.Inst_OpenRAM_top_ConfigMem.Inst_frame0_bit16.Q
+ sky130_fd_sc_hd__dlxtp_1
XFILLER_143_175 VGND VGND VPWR VPWR sky130_fd_sc_hd__decap_3
XFILLER_143_164 VGND VGND VPWR VPWR sky130_fd_sc_hd__decap_3
XFILLER_89_218 VGND VGND VPWR VPWR sky130_fd_sc_hd__decap_3
XFILLER_143_197 VGND VGND VPWR VPWR sky130_fd_sc_hd__decap_3
X_0637_ Tile_X0Y1_OpenRAM_bot.Inst_OpenRAM_bot_ConfigMem.Inst_frame8_bit28.Q _0180_
+ Tile_X0Y1_OpenRAM_bot.Inst_OpenRAM_bot_ConfigMem.Inst_frame8_bit29.Q VGND VGND VPWR
+ VPWR _0181_ sky130_fd_sc_hd__a21bo_1
X_0568_ net339 net359 _0070_ net172 Tile_X0Y1_OpenRAM_bot.Inst_OpenRAM_bot_ConfigMem.Inst_frame1_bit12.Q
+ Tile_X0Y1_OpenRAM_bot.Inst_OpenRAM_bot_ConfigMem.Inst_frame1_bit13.Q VGND VGND VPWR
+ VPWR _0154_ sky130_fd_sc_hd__mux4_2
XFILLER_161_19 VGND VGND VPWR VPWR sky130_fd_sc_hd__decap_3
X_0499_ net67 Tile_X0Y0_OpenRAM_top.Inst_OpenRAM_top_ConfigMem.Inst_frame6_bit11.Q
+ Tile_X0Y0_OpenRAM_top.Inst_OpenRAM_top_ConfigMem.Inst_frame6_bit12.Q VGND VGND VPWR
+ VPWR _0138_ sky130_fd_sc_hd__o21ba_1
XTAP_TAPCELL_ROW_68_644 VGND VPWR sky130_fd_sc_hd__tapvpwrvgnd_1
XFILLER_54_17 VGND VGND VPWR VPWR sky130_fd_sc_hd__decap_3
XFILLER_72_129 VGND VGND VPWR VPWR sky130_fd_sc_hd__decap_3
XPHY_EDGE_ROW_156_Left_339 VGND VGND VPWR VPWR sky130_fd_sc_hd__decap_3
XFILLER_80_173 VGND VGND VPWR VPWR sky130_fd_sc_hd__decap_3
XFILLER_166_212 VGND VGND VPWR VPWR sky130_fd_sc_hd__decap_3
XTAP_TAPCELL_ROW_51_577 VGND VPWR sky130_fd_sc_hd__tapvpwrvgnd_1
XFILLER_70_27 VGND VGND VPWR VPWR sky130_fd_sc_hd__fill_1
XFILLER_119_54 VGND VGND VPWR VPWR sky130_fd_sc_hd__fill_2
XFILLER_119_183 VGND VGND VPWR VPWR sky130_fd_sc_hd__decap_3
XPHY_EDGE_ROW_165_Left_348 VGND VGND VPWR VPWR sky130_fd_sc_hd__decap_3
XFILLER_119_98 VGND VGND VPWR VPWR sky130_fd_sc_hd__fill_2
XFILLER_79_69 VGND VGND VPWR VPWR sky130_fd_sc_hd__decap_3
XFILLER_134_197 VGND VGND VPWR VPWR sky130_fd_sc_hd__decap_3
XFILLER_135_75 VGND VGND VPWR VPWR sky130_fd_sc_hd__decap_3
XFILLER_48_126 VGND VGND VPWR VPWR sky130_fd_sc_hd__decap_3
XFILLER_95_57 VGND VGND VPWR VPWR sky130_fd_sc_hd__decap_3
XFILLER_48_159 VGND VGND VPWR VPWR sky130_fd_sc_hd__decap_3
XPHY_EDGE_ROW_174_Left_357 VGND VGND VPWR VPWR sky130_fd_sc_hd__decap_3
XFILLER_151_96 VGND VGND VPWR VPWR sky130_fd_sc_hd__decap_3
XFILLER_71_151 VGND VGND VPWR VPWR sky130_fd_sc_hd__fill_1
XTAP_TAPCELL_ROW_74_669 VGND VPWR sky130_fd_sc_hd__tapvpwrvgnd_1
XFILLER_44_72 VGND VGND VPWR VPWR sky130_fd_sc_hd__decap_3
XFILLER_44_94 VGND VGND VPWR VPWR sky130_fd_sc_hd__decap_3
XFILLER_8_200 VGND VGND VPWR VPWR sky130_fd_sc_hd__decap_3
XFILLER_81_9 VGND VGND VPWR VPWR sky130_fd_sc_hd__fill_2
XFILLER_172_215 VGND VGND VPWR VPWR sky130_fd_sc_hd__decap_3
XFILLER_176_71 VGND VGND VPWR VPWR sky130_fd_sc_hd__decap_3
Xoutput508 net591 VGND VGND VPWR VPWR Tile_X0Y1_S2BEG[1] sky130_fd_sc_hd__buf_2
XFILLER_5_33 VGND VGND VPWR VPWR sky130_fd_sc_hd__decap_3
Xoutput519 net602 VGND VGND VPWR VPWR Tile_X0Y1_S2BEGb[4] sky130_fd_sc_hd__buf_2
XFILLER_125_175 VGND VGND VPWR VPWR sky130_fd_sc_hd__decap_3
X_1471_ Tile_X0Y1_OpenRAM_bot.Inst_OpenRAM_bot_switch_matrix.W2BEG5 VGND VGND VPWR
+ VPWR net631 sky130_fd_sc_hd__buf_1
XFILLER_5_66 VGND VGND VPWR VPWR sky130_fd_sc_hd__decap_3
X_0422_ net18 Tile_X0Y0_OpenRAM_top.Inst_OpenRAM_top_switch_matrix.J_NS4_BEG4 Tile_X0Y0_OpenRAM_top.Inst_OpenRAM_top_switch_matrix.J_NS4_BEG8
+ net256 Tile_X0Y0_OpenRAM_top.Inst_OpenRAM_top_ConfigMem.Inst_frame3_bit10.Q Tile_X0Y0_OpenRAM_top.Inst_OpenRAM_top_ConfigMem.Inst_frame3_bit11.Q
+ VGND VGND VPWR VPWR Tile_X0Y0_OpenRAM_top.Inst_OpenRAM_top_switch_matrix.W6BEG7
+ sky130_fd_sc_hd__mux4_1
XFILLER_5_99 VGND VGND VPWR VPWR sky130_fd_sc_hd__decap_3
XFILLER_140_178 VGND VGND VPWR VPWR sky130_fd_sc_hd__decap_3
X_0353_ net69 net78 net70 Tile_X0Y0_OpenRAM_top.Inst_OpenRAM_top_switch_matrix.J_NS2_BEG7
+ Tile_X0Y0_OpenRAM_top.Inst_OpenRAM_top_ConfigMem.Inst_frame6_bit6.Q Tile_X0Y0_OpenRAM_top.Inst_OpenRAM_top_ConfigMem.Inst_frame6_bit7.Q
+ VGND VGND VPWR VPWR Tile_X0Y0_OpenRAM_top.Inst_OpenRAM_top_switch_matrix.S2BEG7
+ sky130_fd_sc_hd__mux4_2
XTAP_TAPCELL_ROW_109_807 VGND VPWR sky130_fd_sc_hd__tapvpwrvgnd_1
XFILLER_10_3 VGND VGND VPWR VPWR sky130_fd_sc_hd__decap_3
XFILLER_39_148 VGND VGND VPWR VPWR sky130_fd_sc_hd__decap_3
XFILLER_94_221 VGND VGND VPWR VPWR sky130_fd_sc_hd__decap_3
XPHY_EDGE_ROW_167_Right_167 VGND VGND VPWR VPWR sky130_fd_sc_hd__decap_3
XTAP_TAPCELL_ROW_117_840 VGND VPWR sky130_fd_sc_hd__tapvpwrvgnd_1
XFILLER_54_118 VGND VGND VPWR VPWR sky130_fd_sc_hd__decap_3
X_0284_ net344 net186 Tile_X0Y1_OpenRAM_bot.Inst_OpenRAM_bot_ConfigMem.Inst_frame2_bit28.Q
+ VGND VGND VPWR VPWR _0053_ sky130_fd_sc_hd__mux2_1
XFILLER_47_181 VGND VGND VPWR VPWR sky130_fd_sc_hd__decap_3
XFILLER_62_162 VGND VGND VPWR VPWR sky130_fd_sc_hd__decap_3
XTAP_TAPCELL_ROW_132_898 VGND VPWR sky130_fd_sc_hd__tapvpwrvgnd_1
XFILLER_148_212 VGND VGND VPWR VPWR sky130_fd_sc_hd__fill_2
XTAP_TAPCELL_ROW_100_773 VGND VPWR sky130_fd_sc_hd__tapvpwrvgnd_1
XFILLER_108_109 VGND VGND VPWR VPWR sky130_fd_sc_hd__decap_3
XFILLER_40_19 VGND VGND VPWR VPWR sky130_fd_sc_hd__decap_3
XFILLER_116_131 VGND VGND VPWR VPWR sky130_fd_sc_hd__decap_3
XFILLER_116_153 VGND VGND VPWR VPWR sky130_fd_sc_hd__decap_3
XFILLER_116_186 VGND VGND VPWR VPWR sky130_fd_sc_hd__fill_2
XFILLER_49_28 VGND VGND VPWR VPWR sky130_fd_sc_hd__decap_3
XFILLER_172_29 VGND VGND VPWR VPWR sky130_fd_sc_hd__decap_3
XFILLER_172_18 VGND VGND VPWR VPWR sky130_fd_sc_hd__decap_3
XFILLER_131_145 VGND VGND VPWR VPWR sky130_fd_sc_hd__decap_3
XFILLER_49_39 VGND VGND VPWR VPWR sky130_fd_sc_hd__decap_3
XFILLER_105_12 VGND VGND VPWR VPWR sky130_fd_sc_hd__decap_3
XFILLER_105_45 VGND VGND VPWR VPWR sky130_fd_sc_hd__decap_3
XFILLER_65_27 VGND VGND VPWR VPWR sky130_fd_sc_hd__decap_3
XPHY_EDGE_ROW_134_Right_134 VGND VGND VPWR VPWR sky130_fd_sc_hd__decap_3
XFILLER_121_33 VGND VGND VPWR VPWR sky130_fd_sc_hd__decap_3
XTAP_TAPCELL_ROW_123_865 VGND VPWR sky130_fd_sc_hd__tapvpwrvgnd_1
XFILLER_121_66 VGND VGND VPWR VPWR sky130_fd_sc_hd__decap_3
XFILLER_53_184 VGND VGND VPWR VPWR sky130_fd_sc_hd__decap_3
XFILLER_81_26 VGND VGND VPWR VPWR sky130_fd_sc_hd__decap_3
XFILLER_139_201 VGND VGND VPWR VPWR sky130_fd_sc_hd__decap_3
XFILLER_154_226 VGND VGND VPWR VPWR sky130_fd_sc_hd__decap_3
XFILLER_5_225 VGND VGND VPWR VPWR sky130_fd_sc_hd__decap_3
XFILLER_5_214 VGND VGND VPWR VPWR sky130_fd_sc_hd__decap_3
XFILLER_30_41 VGND VGND VPWR VPWR sky130_fd_sc_hd__decap_3
XFILLER_146_41 VGND VGND VPWR VPWR sky130_fd_sc_hd__decap_3
XFILLER_107_131 VGND VGND VPWR VPWR sky130_fd_sc_hd__decap_3
XFILLER_30_74 VGND VGND VPWR VPWR sky130_fd_sc_hd__decap_3
XFILLER_122_112 VGND VGND VPWR VPWR sky130_fd_sc_hd__decap_3
XFILLER_107_197 VGND VGND VPWR VPWR sky130_fd_sc_hd__decap_3
XFILLER_30_85 VGND VGND VPWR VPWR sky130_fd_sc_hd__decap_3
XFILLER_122_156 VGND VGND VPWR VPWR sky130_fd_sc_hd__decap_3
XFILLER_162_62 VGND VGND VPWR VPWR sky130_fd_sc_hd__decap_3
XFILLER_162_95 VGND VGND VPWR VPWR sky130_fd_sc_hd__decap_3
XTAP_TAPCELL_ROW_146_957 VGND VPWR sky130_fd_sc_hd__tapvpwrvgnd_1
XPHY_EDGE_ROW_101_Right_101 VGND VGND VPWR VPWR sky130_fd_sc_hd__decap_3
XFILLER_36_118 VGND VGND VPWR VPWR sky130_fd_sc_hd__decap_3
XFILLER_55_60 VGND VGND VPWR VPWR sky130_fd_sc_hd__decap_3
X_0971_ net241 net332 VGND VGND VPWR VPWR Tile_X0Y1_OpenRAM_bot.Inst_OpenRAM_bot_ConfigMem.Inst_frame0_bit27.Q
+ sky130_fd_sc_hd__dlxtp_1
XTAP_TAPCELL_ROW_70_650 VGND VPWR sky130_fd_sc_hd__tapvpwrvgnd_1
XFILLER_160_218 VGND VGND VPWR VPWR sky130_fd_sc_hd__decap_3
Xoutput316 net399 VGND VGND VPWR VPWR DIN_A_SRAM21 sky130_fd_sc_hd__buf_2
Xoutput305 net388 VGND VGND VPWR VPWR DIN_A_SRAM11 sky130_fd_sc_hd__buf_2
Xoutput349 net432 VGND VGND VPWR VPWR Tile_X0Y0_FrameData_O[23] sky130_fd_sc_hd__buf_2
Xoutput338 net421 VGND VGND VPWR VPWR Tile_X0Y0_FrameData_O[13] sky130_fd_sc_hd__buf_2
Xoutput327 net410 VGND VGND VPWR VPWR DIN_A_SRAM31 sky130_fd_sc_hd__buf_2
X_1454_ Tile_X0Y0_OpenRAM_top.Inst_OpenRAM_top_switch_matrix.S4BEG0 VGND VGND VPWR
+ VPWR net620 sky130_fd_sc_hd__buf_6
XFILLER_113_134 VGND VGND VPWR VPWR sky130_fd_sc_hd__decap_3
X_0405_ Tile_X0Y0_OpenRAM_top.Inst_OpenRAM_top_switch_matrix.N1END0 net361 net146
+ net166 Tile_X0Y0_OpenRAM_top.Inst_OpenRAM_top_ConfigMem.Inst_frame1_bit16.Q Tile_X0Y0_OpenRAM_top.Inst_OpenRAM_top_ConfigMem.Inst_frame1_bit17.Q
+ VGND VGND VPWR VPWR Tile_X0Y0_OpenRAM_top.Inst_OpenRAM_top_switch_matrix.J_NS4_BEG4
+ sky130_fd_sc_hd__mux4_2
XFILLER_113_178 VGND VGND VPWR VPWR sky130_fd_sc_hd__decap_3
X_1385_ Tile_X0Y0_OpenRAM_top.Inst_OpenRAM_top_switch_matrix.WW4BEG7 VGND VGND VPWR
+ VPWR net551 sky130_fd_sc_hd__clkbuf_2
X_0336_ Tile_X0Y0_OpenRAM_top.Inst_OpenRAM_top_switch_matrix.N2BEGb3 net352 net161
+ net153 Tile_X0Y0_OpenRAM_top.Inst_OpenRAM_top_ConfigMem.Inst_frame0_bit14.Q Tile_X0Y0_OpenRAM_top.Inst_OpenRAM_top_ConfigMem.Inst_frame0_bit15.Q
+ VGND VGND VPWR VPWR Tile_X0Y0_OpenRAM_top.Inst_OpenRAM_top_switch_matrix.J_NS2_BEG3
+ sky130_fd_sc_hd__mux4_2
X_0267_ _0036_ _0033_ Tile_X0Y1_OpenRAM_bot.Inst_OpenRAM_bot_ConfigMem.Inst_frame3_bit8.Q
+ VGND VGND VPWR VPWR _0037_ sky130_fd_sc_hd__mux2_1
XFILLER_35_140 VGND VGND VPWR VPWR sky130_fd_sc_hd__decap_3
XTAP_TAPCELL_ROW_93_742 VGND VPWR sky130_fd_sc_hd__tapvpwrvgnd_1
XFILLER_35_184 VGND VGND VPWR VPWR sky130_fd_sc_hd__decap_3
XFILLER_50_121 VGND VGND VPWR VPWR sky130_fd_sc_hd__decap_3
XFILLER_167_18 VGND VGND VPWR VPWR sky130_fd_sc_hd__decap_3
XFILLER_151_218 VGND VGND VPWR VPWR sky130_fd_sc_hd__decap_3
XFILLER_2_206 VGND VGND VPWR VPWR sky130_fd_sc_hd__decap_3
XFILLER_116_22 VGND VGND VPWR VPWR sky130_fd_sc_hd__decap_3
XFILLER_104_134 VGND VGND VPWR VPWR sky130_fd_sc_hd__decap_3
XFILLER_76_15 VGND VGND VPWR VPWR sky130_fd_sc_hd__decap_3
XFILLER_116_88 VGND VGND VPWR VPWR sky130_fd_sc_hd__decap_3
XFILLER_116_77 VGND VGND VPWR VPWR sky130_fd_sc_hd__decap_3
XFILLER_58_221 VGND VGND VPWR VPWR sky130_fd_sc_hd__decap_3
XFILLER_76_59 VGND VGND VPWR VPWR sky130_fd_sc_hd__decap_3
XFILLER_132_32 VGND VGND VPWR VPWR sky130_fd_sc_hd__decap_3
XFILLER_132_65 VGND VGND VPWR VPWR sky130_fd_sc_hd__fill_1
XFILLER_25_30 VGND VGND VPWR VPWR sky130_fd_sc_hd__decap_3
XFILLER_92_47 VGND VGND VPWR VPWR sky130_fd_sc_hd__decap_3
XFILLER_92_58 VGND VGND VPWR VPWR sky130_fd_sc_hd__decap_3
XFILLER_25_52 VGND VGND VPWR VPWR sky130_fd_sc_hd__decap_3
XFILLER_25_63 VGND VGND VPWR VPWR sky130_fd_sc_hd__decap_3
XFILLER_26_195 VGND VGND VPWR VPWR sky130_fd_sc_hd__fill_1
XFILLER_41_110 VGND VGND VPWR VPWR sky130_fd_sc_hd__fill_2
XFILLER_41_143 VGND VGND VPWR VPWR sky130_fd_sc_hd__decap_3
XFILLER_41_187 VGND VGND VPWR VPWR sky130_fd_sc_hd__decap_3
XFILLER_157_40 VGND VGND VPWR VPWR sky130_fd_sc_hd__fill_1
XFILLER_157_84 VGND VGND VPWR VPWR sky130_fd_sc_hd__decap_3
XTAP_TAPCELL_ROW_169_1046 VGND VPWR sky130_fd_sc_hd__tapvpwrvgnd_1
XFILLER_173_72 VGND VGND VPWR VPWR sky130_fd_sc_hd__decap_3
XFILLER_2_12 VGND VGND VPWR VPWR sky130_fd_sc_hd__decap_3
XFILLER_2_67 VGND VGND VPWR VPWR sky130_fd_sc_hd__decap_3
X_1170_ net234 net280 VGND VGND VPWR VPWR Tile_X0Y1_OpenRAM_bot.Inst_OpenRAM_bot_ConfigMem.Inst_frame6_bit20.Q
+ sky130_fd_sc_hd__dlxtp_1
XFILLER_66_81 VGND VGND VPWR VPWR sky130_fd_sc_hd__decap_3
XFILLER_66_92 VGND VGND VPWR VPWR sky130_fd_sc_hd__fill_2
XFILLER_32_121 VGND VGND VPWR VPWR sky130_fd_sc_hd__decap_3
XFILLER_32_165 VGND VGND VPWR VPWR sky130_fd_sc_hd__decap_3
XFILLER_177_137 VGND VGND VPWR VPWR sky130_fd_sc_hd__decap_3
X_0954_ net130 net268 VGND VGND VPWR VPWR Tile_X0Y0_OpenRAM_top.Inst_OpenRAM_top_ConfigMem.Inst_frame8_bit24.Q
+ sky130_fd_sc_hd__dlxtp_1
X_0885_ net135 net282 VGND VGND VPWR VPWR Tile_X0Y0_OpenRAM_top.Inst_OpenRAM_top_ConfigMem.Inst_frame6_bit29.Q
+ sky130_fd_sc_hd__dlxtp_1
XFILLER_99_187 VGND VGND VPWR VPWR sky130_fd_sc_hd__decap_3
XFILLER_99_165 VGND VGND VPWR VPWR sky130_fd_sc_hd__decap_3
X_1506_ Tile_X0Y1_OpenRAM_bot.Inst_OpenRAM_bot_switch_matrix.WW4BEG12 VGND VGND VPWR
+ VPWR net657 sky130_fd_sc_hd__buf_1
XFILLER_101_126 VGND VGND VPWR VPWR sky130_fd_sc_hd__decap_3
X_1437_ Tile_X0Y1_OpenRAM_bot.Inst_OpenRAM_bot_switch_matrix.S2BEG7 VGND VGND VPWR
+ VPWR net597 sky130_fd_sc_hd__clkbuf_2
X_1368_ Tile_X0Y0_OpenRAM_top.Inst_OpenRAM_top_switch_matrix.W6BEG2 VGND VGND VPWR
+ VPWR net530 sky130_fd_sc_hd__clkbuf_1
X_0319_ net177 Tile_X0Y1_OpenRAM_bot.Inst_OpenRAM_bot_switch_matrix.J_NS4_BEG15 net203
+ _0080_ Tile_X0Y1_OpenRAM_bot.Inst_OpenRAM_bot_ConfigMem.Inst_frame8_bit7.Q Tile_X0Y1_OpenRAM_bot.Inst_OpenRAM_bot_ConfigMem.Inst_frame8_bit6.Q
+ VGND VGND VPWR VPWR Tile_X0Y0_OpenRAM_top.Inst_OpenRAM_top_switch_matrix.N1END3
+ sky130_fd_sc_hd__mux4_2
XFILLER_55_213 VGND VGND VPWR VPWR sky130_fd_sc_hd__decap_3
X_1299_ Tile_X0Y1_FrameStrobe[10] VGND VGND VPWR VPWR net450 sky130_fd_sc_hd__buf_6
XFILLER_102_35 VGND VGND VPWR VPWR sky130_fd_sc_hd__fill_2
XFILLER_23_110 VGND VGND VPWR VPWR sky130_fd_sc_hd__fill_2
XFILLER_168_115 VGND VGND VPWR VPWR sky130_fd_sc_hd__decap_3
XFILLER_176_192 VGND VGND VPWR VPWR sky130_fd_sc_hd__decap_3
XFILLER_11_10 VGND VGND VPWR VPWR sky130_fd_sc_hd__decap_3
XFILLER_127_43 VGND VGND VPWR VPWR sky130_fd_sc_hd__decap_3
XFILLER_11_43 VGND VGND VPWR VPWR sky130_fd_sc_hd__decap_3
XFILLER_11_87 VGND VGND VPWR VPWR sky130_fd_sc_hd__decap_3
XFILLER_87_36 VGND VGND VPWR VPWR sky130_fd_sc_hd__decap_3
XFILLER_87_69 VGND VGND VPWR VPWR sky130_fd_sc_hd__decap_3
XFILLER_143_42 VGND VGND VPWR VPWR sky130_fd_sc_hd__decap_3
XFILLER_143_75 VGND VGND VPWR VPWR sky130_fd_sc_hd__decap_3
XTAP_TAPCELL_ROW_6_397 VGND VPWR sky130_fd_sc_hd__tapvpwrvgnd_1
XFILLER_100_181 VGND VGND VPWR VPWR sky130_fd_sc_hd__fill_2
XTAP_TAPCELL_ROW_29_488 VGND VPWR sky130_fd_sc_hd__tapvpwrvgnd_1
XFILLER_36_62 VGND VGND VPWR VPWR sky130_fd_sc_hd__decap_3
XFILLER_159_137 VGND VGND VPWR VPWR sky130_fd_sc_hd__decap_3
XFILLER_14_165 VGND VGND VPWR VPWR sky130_fd_sc_hd__decap_3
XFILLER_174_118 VGND VGND VPWR VPWR sky130_fd_sc_hd__decap_3
XFILLER_168_50 VGND VGND VPWR VPWR sky130_fd_sc_hd__decap_3
XFILLER_52_83 VGND VGND VPWR VPWR sky130_fd_sc_hd__fill_1
XTAP_TAPCELL_ROW_175_1072 VGND VPWR sky130_fd_sc_hd__tapvpwrvgnd_1
XFILLER_168_94 VGND VGND VPWR VPWR sky130_fd_sc_hd__decap_3
XFILLER_168_83 VGND VGND VPWR VPWR sky130_fd_sc_hd__fill_1
XFILLER_167_181 VGND VGND VPWR VPWR sky130_fd_sc_hd__decap_3
Xinput15 DOUT_A_SRAM20 VGND VGND VPWR VPWR net15 sky130_fd_sc_hd__buf_2
Xinput26 DOUT_A_SRAM30 VGND VGND VPWR VPWR net26 sky130_fd_sc_hd__clkbuf_2
Xinput37 DOUT_B_SRAM11 VGND VGND VPWR VPWR net37 sky130_fd_sc_hd__buf_1
X_0670_ _0149_ _0145_ Tile_X0Y1_OpenRAM_bot.Inst_OpenRAM_bot_ConfigMem.Inst_frame6_bit5.Q
+ VGND VGND VPWR VPWR _0208_ sky130_fd_sc_hd__mux2_1
Xinput48 DOUT_B_SRAM21 VGND VGND VPWR VPWR net48 sky130_fd_sc_hd__buf_2
Xinput59 DOUT_B_SRAM31 VGND VGND VPWR VPWR net59 sky130_fd_sc_hd__buf_1
XFILLER_96_135 VGND VGND VPWR VPWR sky130_fd_sc_hd__decap_3
X_1222_ net222 net273 VGND VGND VPWR VPWR Tile_X0Y1_OpenRAM_bot.Inst_OpenRAM_bot_ConfigMem.Inst_frame7_bit0.Q
+ sky130_fd_sc_hd__dlxtp_1
XFILLER_77_91 VGND VGND VPWR VPWR sky130_fd_sc_hd__decap_3
XFILLER_37_202 VGND VGND VPWR VPWR sky130_fd_sc_hd__decap_3
X_1153_ net249 net289 VGND VGND VPWR VPWR Tile_X0Y1_OpenRAM_bot.Inst_OpenRAM_bot_ConfigMem.Inst_frame5_bit5.Q
+ sky130_fd_sc_hd__dlxtp_1
XTAP_TAPCELL_ROW_182_1098 VGND VPWR sky130_fd_sc_hd__tapvpwrvgnd_1
X_1084_ net223 net306 VGND VGND VPWR VPWR Tile_X0Y1_OpenRAM_bot.Inst_OpenRAM_bot_ConfigMem.Inst_frame3_bit10.Q
+ sky130_fd_sc_hd__dlxtp_1
XFILLER_165_107 VGND VGND VPWR VPWR sky130_fd_sc_hd__decap_3
X_0937_ net145 net276 VGND VGND VPWR VPWR Tile_X0Y0_OpenRAM_top.Inst_OpenRAM_top_ConfigMem.Inst_frame7_bit9.Q
+ sky130_fd_sc_hd__dlxtp_1
XFILLER_158_192 VGND VGND VPWR VPWR sky130_fd_sc_hd__decap_3
XFILLER_158_170 VGND VGND VPWR VPWR sky130_fd_sc_hd__fill_1
XFILLER_20_168 VGND VGND VPWR VPWR sky130_fd_sc_hd__decap_3
XFILLER_173_140 VGND VGND VPWR VPWR sky130_fd_sc_hd__decap_3
XFILLER_173_184 VGND VGND VPWR VPWR sky130_fd_sc_hd__decap_3
X_0868_ net119 net291 VGND VGND VPWR VPWR Tile_X0Y0_OpenRAM_top.Inst_OpenRAM_top_ConfigMem.Inst_frame5_bit14.Q
+ sky130_fd_sc_hd__dlxtp_1
X_0799_ net124 net310 VGND VGND VPWR VPWR Tile_X0Y0_OpenRAM_top.Inst_OpenRAM_top_ConfigMem.Inst_frame3_bit19.Q
+ sky130_fd_sc_hd__dlxtp_1
XFILLER_87_102 VGND VGND VPWR VPWR sky130_fd_sc_hd__decap_3
XFILLER_180_18 VGND VGND VPWR VPWR sky130_fd_sc_hd__decap_3
XFILLER_57_28 VGND VGND VPWR VPWR sky130_fd_sc_hd__decap_3
XFILLER_87_157 VGND VGND VPWR VPWR sky130_fd_sc_hd__decap_3
XFILLER_180_29 VGND VGND VPWR VPWR sky130_fd_sc_hd__decap_3
XFILLER_11_113 VGND VGND VPWR VPWR sky130_fd_sc_hd__decap_3
XFILLER_11_102 VGND VGND VPWR VPWR sky130_fd_sc_hd__decap_3
XFILLER_156_118 VGND VGND VPWR VPWR sky130_fd_sc_hd__decap_3
XFILLER_11_146 VGND VGND VPWR VPWR sky130_fd_sc_hd__decap_3
XFILLER_149_181 VGND VGND VPWR VPWR sky130_fd_sc_hd__decap_3
XFILLER_7_128 VGND VGND VPWR VPWR sky130_fd_sc_hd__decap_3
XFILLER_125_3 VGND VGND VPWR VPWR sky130_fd_sc_hd__fill_2
XFILLER_98_35 VGND VGND VPWR VPWR sky130_fd_sc_hd__decap_3
XFILLER_98_24 VGND VGND VPWR VPWR sky130_fd_sc_hd__decap_3
XFILLER_22_97 VGND VGND VPWR VPWR sky130_fd_sc_hd__decap_3
XFILLER_164_195 VGND VGND VPWR VPWR sky130_fd_sc_hd__fill_1
XFILLER_138_97 VGND VGND VPWR VPWR sky130_fd_sc_hd__decap_3
XFILLER_154_41 VGND VGND VPWR VPWR sky130_fd_sc_hd__decap_3
XFILLER_78_135 VGND VGND VPWR VPWR sky130_fd_sc_hd__decap_3
XFILLER_154_85 VGND VGND VPWR VPWR sky130_fd_sc_hd__decap_3
XFILLER_19_202 VGND VGND VPWR VPWR sky130_fd_sc_hd__decap_3
XFILLER_170_62 VGND VGND VPWR VPWR sky130_fd_sc_hd__decap_3
XFILLER_63_60 VGND VGND VPWR VPWR sky130_fd_sc_hd__decap_3
XFILLER_179_60 VGND VGND VPWR VPWR sky130_fd_sc_hd__decap_3
XFILLER_63_82 VGND VGND VPWR VPWR sky130_fd_sc_hd__decap_3
XFILLER_179_93 VGND VGND VPWR VPWR sky130_fd_sc_hd__decap_3
XFILLER_8_44 VGND VGND VPWR VPWR sky130_fd_sc_hd__decap_3
XFILLER_8_88 VGND VGND VPWR VPWR sky130_fd_sc_hd__decap_3
XFILLER_8_77 VGND VGND VPWR VPWR sky130_fd_sc_hd__decap_3
X_0722_ net114 net337 VGND VGND VPWR VPWR Tile_X0Y0_OpenRAM_top.Inst_OpenRAM_top_ConfigMem.Inst_frame0_bit0.Q
+ sky130_fd_sc_hd__dlxtp_1
XFILLER_6_150 VGND VGND VPWR VPWR sky130_fd_sc_hd__decap_3
XFILLER_170_121 VGND VGND VPWR VPWR sky130_fd_sc_hd__decap_3
XFILLER_6_183 VGND VGND VPWR VPWR sky130_fd_sc_hd__decap_3
X_0653_ Tile_X0Y1_OpenRAM_bot.Inst_OpenRAM_bot_ConfigMem.Inst_frame7_bit29.Q _0193_
+ VGND VGND VPWR VPWR _0194_ sky130_fd_sc_hd__and2b_1
XFILLER_170_165 VGND VGND VPWR VPWR sky130_fd_sc_hd__decap_3
X_0584_ net62 _0151_ _0155_ _0086_ Tile_X0Y1_OpenRAM_bot.Inst_OpenRAM_bot_ConfigMem.Inst_frame3_bit5.Q
+ Tile_X0Y1_OpenRAM_bot.Inst_OpenRAM_bot_ConfigMem.Inst_frame3_bit4.Q VGND VGND VPWR
+ VPWR Tile_X0Y1_OpenRAM_bot.Inst_OpenRAM_bot_switch_matrix.W6BEG10 sky130_fd_sc_hd__mux4_1
XFILLER_69_146 VGND VGND VPWR VPWR sky130_fd_sc_hd__decap_3
XFILLER_84_127 VGND VGND VPWR VPWR sky130_fd_sc_hd__fill_1
XPHY_EDGE_ROW_69_Left_252 VGND VGND VPWR VPWR sky130_fd_sc_hd__decap_3
X_1205_ net230 net271 VGND VGND VPWR VPWR Tile_X0Y1_OpenRAM_bot.Inst_OpenRAM_bot_ConfigMem.Inst_frame7_bit17.Q
+ sky130_fd_sc_hd__dlxtp_1
X_1136_ net236 net287 VGND VGND VPWR VPWR Tile_X0Y1_OpenRAM_bot.Inst_OpenRAM_bot_ConfigMem.Inst_frame5_bit22.Q
+ sky130_fd_sc_hd__dlxtp_1
XFILLER_25_216 VGND VGND VPWR VPWR sky130_fd_sc_hd__decap_3
X_1067_ net241 net304 VGND VGND VPWR VPWR Tile_X0Y1_OpenRAM_bot.Inst_OpenRAM_bot_ConfigMem.Inst_frame3_bit27.Q
+ sky130_fd_sc_hd__dlxtp_1
XFILLER_178_221 VGND VGND VPWR VPWR sky130_fd_sc_hd__decap_3
XFILLER_159_19 VGND VGND VPWR VPWR sky130_fd_sc_hd__decap_3
XTAP_TAPCELL_ROW_31_494 VGND VPWR sky130_fd_sc_hd__tapvpwrvgnd_1
XPHY_EDGE_ROW_78_Left_261 VGND VGND VPWR VPWR sky130_fd_sc_hd__decap_3
XFILLER_175_18 VGND VGND VPWR VPWR sky130_fd_sc_hd__decap_3
XFILLER_4_109 VGND VGND VPWR VPWR sky130_fd_sc_hd__decap_3
XFILLER_161_110 VGND VGND VPWR VPWR sky130_fd_sc_hd__fill_2
XFILLER_161_165 VGND VGND VPWR VPWR sky130_fd_sc_hd__decap_3
XFILLER_161_143 VGND VGND VPWR VPWR sky130_fd_sc_hd__decap_3
XTAP_TAPCELL_ROW_8_404 VGND VPWR sky130_fd_sc_hd__tapvpwrvgnd_1
XFILLER_161_187 VGND VGND VPWR VPWR sky130_fd_sc_hd__decap_3
XFILLER_102_221 VGND VGND VPWR VPWR sky130_fd_sc_hd__decap_3
Xinput216 Tile_X0Y1_EE4END[4] VGND VGND VPWR VPWR net216 sky130_fd_sc_hd__buf_1
Xinput205 Tile_X0Y1_E6END[9] VGND VGND VPWR VPWR net205 sky130_fd_sc_hd__clkbuf_2
Xinput227 Tile_X0Y1_FrameData[14] VGND VGND VPWR VPWR net227 sky130_fd_sc_hd__buf_4
Xinput249 Tile_X0Y1_FrameData[5] VGND VGND VPWR VPWR net249 sky130_fd_sc_hd__clkbuf_4
Xinput238 Tile_X0Y1_FrameData[24] VGND VGND VPWR VPWR net238 sky130_fd_sc_hd__clkbuf_4
XPHY_EDGE_ROW_87_Left_270 VGND VGND VPWR VPWR sky130_fd_sc_hd__decap_3
XFILLER_124_88 VGND VGND VPWR VPWR sky130_fd_sc_hd__decap_3
XFILLER_124_77 VGND VGND VPWR VPWR sky130_fd_sc_hd__decap_3
XFILLER_84_26 VGND VGND VPWR VPWR sky130_fd_sc_hd__fill_2
XFILLER_84_48 VGND VGND VPWR VPWR sky130_fd_sc_hd__decap_3
XFILLER_140_21 VGND VGND VPWR VPWR sky130_fd_sc_hd__decap_3
XFILLER_17_53 VGND VGND VPWR VPWR sky130_fd_sc_hd__decap_3
XFILLER_16_227 VGND VGND VPWR VPWR sky130_fd_sc_hd__decap_3
XFILLER_140_65 VGND VGND VPWR VPWR sky130_fd_sc_hd__decap_3
XFILLER_17_75 VGND VGND VPWR VPWR sky130_fd_sc_hd__decap_3
XTAP_TAPCELL_ROW_14_428 VGND VPWR sky130_fd_sc_hd__tapvpwrvgnd_1
XTAP_TAPCELL_ROW_54_586 VGND VPWR sky130_fd_sc_hd__tapvpwrvgnd_1
XFILLER_149_52 VGND VGND VPWR VPWR sky130_fd_sc_hd__fill_1
XTAP_TAPCELL_ROW_22_461 VGND VPWR sky130_fd_sc_hd__tapvpwrvgnd_1
XFILLER_33_63 VGND VGND VPWR VPWR sky130_fd_sc_hd__decap_3
XFILLER_149_63 VGND VGND VPWR VPWR sky130_fd_sc_hd__decap_3
XFILLER_137_162 VGND VGND VPWR VPWR sky130_fd_sc_hd__decap_3
XFILLER_152_121 VGND VGND VPWR VPWR sky130_fd_sc_hd__decap_3
XFILLER_137_184 VGND VGND VPWR VPWR sky130_fd_sc_hd__decap_3
XFILLER_3_131 VGND VGND VPWR VPWR sky130_fd_sc_hd__decap_3
XFILLER_165_95 VGND VGND VPWR VPWR sky130_fd_sc_hd__decap_3
XPHY_EDGE_ROW_148_Right_148 VGND VGND VPWR VPWR sky130_fd_sc_hd__decap_3
XFILLER_3_175 VGND VGND VPWR VPWR sky130_fd_sc_hd__decap_3
XTAP_TAPCELL_ROW_77_678 VGND VPWR sky130_fd_sc_hd__tapvpwrvgnd_1
XFILLER_81_108 VGND VGND VPWR VPWR sky130_fd_sc_hd__decap_3
XFILLER_74_160 VGND VGND VPWR VPWR sky130_fd_sc_hd__decap_3
XFILLER_74_193 VGND VGND VPWR VPWR sky130_fd_sc_hd__decap_3
XTAP_TAPCELL_ROW_45_553 VGND VPWR sky130_fd_sc_hd__tapvpwrvgnd_1
XFILLER_175_202 VGND VGND VPWR VPWR sky130_fd_sc_hd__decap_3
XFILLER_88_3 VGND VGND VPWR VPWR sky130_fd_sc_hd__decap_3
XFILLER_90_80 VGND VGND VPWR VPWR sky130_fd_sc_hd__decap_3
XFILLER_128_162 VGND VGND VPWR VPWR sky130_fd_sc_hd__decap_3
XFILLER_143_110 VGND VGND VPWR VPWR sky130_fd_sc_hd__fill_2
XFILLER_128_195 VGND VGND VPWR VPWR sky130_fd_sc_hd__fill_1
X_0705_ net122 net335 VGND VGND VPWR VPWR Tile_X0Y0_OpenRAM_top.Inst_OpenRAM_top_ConfigMem.Inst_frame0_bit17.Q
+ sky130_fd_sc_hd__dlxtp_1
XFILLER_143_143 VGND VGND VPWR VPWR sky130_fd_sc_hd__decap_3
XPHY_EDGE_ROW_115_Right_115 VGND VGND VPWR VPWR sky130_fd_sc_hd__decap_3
X_0636_ Tile_X0Y1_OpenRAM_bot.Inst_OpenRAM_bot_switch_matrix.J_NS4_BEG13 net262 Tile_X0Y1_OpenRAM_bot.Inst_OpenRAM_bot_ConfigMem.Inst_frame8_bit27.Q
+ VGND VGND VPWR VPWR _0180_ sky130_fd_sc_hd__mux2_1
X_0567_ net6 net38 _0153_ net260 Tile_X0Y1_OpenRAM_bot.Inst_OpenRAM_bot_ConfigMem.Inst_frame4_bit8.Q
+ Tile_X0Y1_OpenRAM_bot.Inst_OpenRAM_bot_ConfigMem.Inst_frame4_bit9.Q VGND VGND VPWR
+ VPWR Tile_X0Y1_OpenRAM_bot.Inst_OpenRAM_bot_switch_matrix.WW4BEG12 sky130_fd_sc_hd__mux4_1
XFILLER_57_116 VGND VGND VPWR VPWR sky130_fd_sc_hd__fill_1
X_0498_ net102 Tile_X0Y0_OpenRAM_top.Inst_OpenRAM_top_ConfigMem.Inst_frame6_bit11.Q
+ VGND VGND VPWR VPWR _0137_ sky130_fd_sc_hd__nand2b_1
XTAP_TAPCELL_ROW_68_645 VGND VPWR sky130_fd_sc_hd__tapvpwrvgnd_1
XFILLER_72_108 VGND VGND VPWR VPWR sky130_fd_sc_hd__decap_3
XFILLER_54_29 VGND VGND VPWR VPWR sky130_fd_sc_hd__decap_3
XFILLER_65_182 VGND VGND VPWR VPWR sky130_fd_sc_hd__decap_3
X_1119_ net251 net298 VGND VGND VPWR VPWR Tile_X0Y1_OpenRAM_bot.Inst_OpenRAM_bot_ConfigMem.Inst_frame4_bit7.Q
+ sky130_fd_sc_hd__dlxtp_1
XFILLER_80_141 VGND VGND VPWR VPWR sky130_fd_sc_hd__decap_3
XFILLER_110_35 VGND VGND VPWR VPWR sky130_fd_sc_hd__decap_3
XFILLER_110_24 VGND VGND VPWR VPWR sky130_fd_sc_hd__decap_3
XFILLER_13_208 VGND VGND VPWR VPWR sky130_fd_sc_hd__decap_3
XTAP_TAPCELL_ROW_103_782 VGND VPWR sky130_fd_sc_hd__tapvpwrvgnd_1
XFILLER_166_224 VGND VGND VPWR VPWR sky130_fd_sc_hd__decap_3
XPHY_EDGE_ROW_17_Right_17 VGND VGND VPWR VPWR sky130_fd_sc_hd__decap_3
XFILLER_134_110 VGND VGND VPWR VPWR sky130_fd_sc_hd__decap_3
XFILLER_79_15 VGND VGND VPWR VPWR sky130_fd_sc_hd__decap_3
XFILLER_134_165 VGND VGND VPWR VPWR sky130_fd_sc_hd__fill_1
XFILLER_135_32 VGND VGND VPWR VPWR sky130_fd_sc_hd__decap_3
XFILLER_134_187 VGND VGND VPWR VPWR sky130_fd_sc_hd__decap_3
XFILLER_135_54 VGND VGND VPWR VPWR sky130_fd_sc_hd__fill_2
XFILLER_135_98 VGND VGND VPWR VPWR sky130_fd_sc_hd__decap_3
XPHY_EDGE_ROW_26_Right_26 VGND VGND VPWR VPWR sky130_fd_sc_hd__decap_3
XFILLER_0_189 VGND VGND VPWR VPWR sky130_fd_sc_hd__decap_3
XFILLER_48_138 VGND VGND VPWR VPWR sky130_fd_sc_hd__fill_2
XFILLER_151_75 VGND VGND VPWR VPWR sky130_fd_sc_hd__decap_3
XTAP_TAPCELL_ROW_126_874 VGND VPWR sky130_fd_sc_hd__tapvpwrvgnd_1
XFILLER_12_230 VGND VGND VPWR VPWR sky130_fd_sc_hd__fill_1
XFILLER_8_212 VGND VGND VPWR VPWR sky130_fd_sc_hd__decap_3
XPHY_EDGE_ROW_35_Right_35 VGND VGND VPWR VPWR sky130_fd_sc_hd__decap_3
XFILLER_172_227 VGND VGND VPWR VPWR sky130_fd_sc_hd__decap_3
XFILLER_60_61 VGND VGND VPWR VPWR sky130_fd_sc_hd__decap_3
XFILLER_176_83 VGND VGND VPWR VPWR sky130_fd_sc_hd__fill_1
XFILLER_176_50 VGND VGND VPWR VPWR sky130_fd_sc_hd__decap_3
Xoutput509 net592 VGND VGND VPWR VPWR Tile_X0Y1_S2BEG[2] sky130_fd_sc_hd__buf_2
XFILLER_5_12 VGND VGND VPWR VPWR sky130_fd_sc_hd__decap_3
XFILLER_176_94 VGND VGND VPWR VPWR sky130_fd_sc_hd__decap_3
XFILLER_125_165 VGND VGND VPWR VPWR sky130_fd_sc_hd__decap_3
XFILLER_125_143 VGND VGND VPWR VPWR sky130_fd_sc_hd__decap_3
XFILLER_5_45 VGND VGND VPWR VPWR sky130_fd_sc_hd__decap_3
XFILLER_125_187 VGND VGND VPWR VPWR sky130_fd_sc_hd__decap_3
X_1470_ Tile_X0Y1_OpenRAM_bot.Inst_OpenRAM_bot_switch_matrix.W2BEG4 VGND VGND VPWR
+ VPWR net630 sky130_fd_sc_hd__clkbuf_1
XFILLER_5_78 VGND VGND VPWR VPWR sky130_fd_sc_hd__decap_3
X_0421_ net17 Tile_X0Y0_OpenRAM_top.Inst_OpenRAM_top_switch_matrix.J_NS4_BEG5 Tile_X0Y0_OpenRAM_top.Inst_OpenRAM_top_switch_matrix.J_NS4_BEG9
+ net257 Tile_X0Y0_OpenRAM_top.Inst_OpenRAM_top_ConfigMem.Inst_frame3_bit8.Q Tile_X0Y0_OpenRAM_top.Inst_OpenRAM_top_ConfigMem.Inst_frame3_bit9.Q
+ VGND VGND VPWR VPWR Tile_X0Y0_OpenRAM_top.Inst_OpenRAM_top_switch_matrix.W6BEG6
+ sky130_fd_sc_hd__mux4_1
XPHY_EDGE_ROW_44_Right_44 VGND VGND VPWR VPWR sky130_fd_sc_hd__decap_3
XTAP_TAPCELL_ROW_149_966 VGND VPWR sky130_fd_sc_hd__tapvpwrvgnd_1
XTAP_TAPCELL_ROW_109_808 VGND VPWR sky130_fd_sc_hd__tapvpwrvgnd_1
X_0352_ net79 net71 net89 Tile_X0Y0_OpenRAM_top.Inst_OpenRAM_top_switch_matrix.J_NS2_BEG6
+ Tile_X0Y0_OpenRAM_top.Inst_OpenRAM_top_ConfigMem.Inst_frame7_bit0.Q Tile_X0Y0_OpenRAM_top.Inst_OpenRAM_top_ConfigMem.Inst_frame7_bit1.Q
+ VGND VGND VPWR VPWR Tile_X0Y0_OpenRAM_top.Inst_OpenRAM_top_switch_matrix.N2BEG6
+ sky130_fd_sc_hd__mux4_1
XFILLER_39_105 VGND VGND VPWR VPWR sky130_fd_sc_hd__fill_1
XFILLER_39_116 VGND VGND VPWR VPWR sky130_fd_sc_hd__fill_2
XTAP_TAPCELL_ROW_117_841 VGND VPWR sky130_fd_sc_hd__tapvpwrvgnd_1
X_0283_ Tile_X0Y1_OpenRAM_bot.Inst_OpenRAM_bot_ConfigMem.Inst_frame2_bit28.Q _0051_
+ _0048_ Tile_X0Y1_OpenRAM_bot.Inst_OpenRAM_bot_ConfigMem.Inst_frame2_bit31.Q VGND
+ VGND VPWR VPWR _0052_ sky130_fd_sc_hd__o211a_1
XFILLER_47_193 VGND VGND VPWR VPWR sky130_fd_sc_hd__decap_3
XFILLER_62_174 VGND VGND VPWR VPWR sky130_fd_sc_hd__decap_3
XTAP_TAPCELL_ROW_132_899 VGND VPWR sky130_fd_sc_hd__tapvpwrvgnd_1
XPHY_EDGE_ROW_53_Right_53 VGND VGND VPWR VPWR sky130_fd_sc_hd__decap_3
XFILLER_163_205 VGND VGND VPWR VPWR sky130_fd_sc_hd__decap_3
XFILLER_131_113 VGND VGND VPWR VPWR sky130_fd_sc_hd__fill_1
XFILLER_131_102 VGND VGND VPWR VPWR sky130_fd_sc_hd__decap_3
XFILLER_116_165 VGND VGND VPWR VPWR sky130_fd_sc_hd__decap_3
XPHY_EDGE_ROW_62_Right_62 VGND VGND VPWR VPWR sky130_fd_sc_hd__decap_3
X_0619_ net187 Tile_X0Y1_OpenRAM_bot.Inst_OpenRAM_bot_ConfigMem.Inst_frame1_bit2.Q
+ Tile_X0Y1_OpenRAM_bot.Inst_OpenRAM_bot_ConfigMem.Inst_frame1_bit3.Q VGND VGND VPWR
+ VPWR _0167_ sky130_fd_sc_hd__o21ba_1
XFILLER_105_24 VGND VGND VPWR VPWR sky130_fd_sc_hd__decap_3
XFILLER_105_57 VGND VGND VPWR VPWR sky130_fd_sc_hd__decap_3
XFILLER_85_211 VGND VGND VPWR VPWR sky130_fd_sc_hd__decap_3
XFILLER_38_193 VGND VGND VPWR VPWR sky130_fd_sc_hd__decap_3
XFILLER_121_78 VGND VGND VPWR VPWR sky130_fd_sc_hd__decap_3
XFILLER_121_45 VGND VGND VPWR VPWR sky130_fd_sc_hd__decap_3
XFILLER_53_163 VGND VGND VPWR VPWR sky130_fd_sc_hd__decap_3
XPHY_EDGE_ROW_71_Right_71 VGND VGND VPWR VPWR sky130_fd_sc_hd__decap_3
XFILLER_53_196 VGND VGND VPWR VPWR sky130_fd_sc_hd__decap_3
XFILLER_139_213 VGND VGND VPWR VPWR sky130_fd_sc_hd__decap_3
XFILLER_14_54 VGND VGND VPWR VPWR sky130_fd_sc_hd__fill_1
XFILLER_14_32 VGND VGND VPWR VPWR sky130_fd_sc_hd__fill_1
XFILLER_14_21 VGND VGND VPWR VPWR sky130_fd_sc_hd__decap_3
XFILLER_107_143 VGND VGND VPWR VPWR sky130_fd_sc_hd__decap_3
XFILLER_30_53 VGND VGND VPWR VPWR sky130_fd_sc_hd__decap_3
XPHY_EDGE_ROW_80_Right_80 VGND VGND VPWR VPWR sky130_fd_sc_hd__decap_3
XPHY_EDGE_ROW_15_Left_198 VGND VGND VPWR VPWR sky130_fd_sc_hd__decap_3
XFILLER_146_97 VGND VGND VPWR VPWR sky130_fd_sc_hd__fill_2
XFILLER_122_124 VGND VGND VPWR VPWR sky130_fd_sc_hd__decap_3
XFILLER_122_168 VGND VGND VPWR VPWR sky130_fd_sc_hd__fill_1
XFILLER_162_41 VGND VGND VPWR VPWR sky130_fd_sc_hd__decap_3
XFILLER_39_84 VGND VGND VPWR VPWR sky130_fd_sc_hd__decap_3
XFILLER_162_85 VGND VGND VPWR VPWR sky130_fd_sc_hd__decap_3
XFILLER_162_74 VGND VGND VPWR VPWR sky130_fd_sc_hd__decap_3
XFILLER_29_160 VGND VGND VPWR VPWR sky130_fd_sc_hd__decap_3
XFILLER_91_214 VGND VGND VPWR VPWR sky130_fd_sc_hd__decap_3
XFILLER_91_225 VGND VGND VPWR VPWR sky130_fd_sc_hd__decap_3
XFILLER_44_130 VGND VGND VPWR VPWR sky130_fd_sc_hd__decap_3
XFILLER_55_83 VGND VGND VPWR VPWR sky130_fd_sc_hd__decap_3
XTAP_TAPCELL_ROW_62_618 VGND VPWR sky130_fd_sc_hd__tapvpwrvgnd_1
X_0970_ net242 net330 VGND VGND VPWR VPWR Tile_X0Y1_OpenRAM_bot.Inst_OpenRAM_bot_ConfigMem.Inst_frame0_bit28.Q
+ sky130_fd_sc_hd__dlxtp_1
XTAP_TAPCELL_ROW_70_651 VGND VPWR sky130_fd_sc_hd__tapvpwrvgnd_1
XFILLER_71_60 VGND VGND VPWR VPWR sky130_fd_sc_hd__decap_3
XFILLER_71_82 VGND VGND VPWR VPWR sky130_fd_sc_hd__decap_3
XFILLER_145_216 VGND VGND VPWR VPWR sky130_fd_sc_hd__decap_3
Xoutput317 net400 VGND VGND VPWR VPWR DIN_A_SRAM22 sky130_fd_sc_hd__buf_2
Xoutput306 net389 VGND VGND VPWR VPWR DIN_A_SRAM12 sky130_fd_sc_hd__buf_2
Xoutput339 net422 VGND VGND VPWR VPWR Tile_X0Y0_FrameData_O[14] sky130_fd_sc_hd__buf_2
XFILLER_113_113 VGND VGND VPWR VPWR sky130_fd_sc_hd__decap_3
Xoutput328 net411 VGND VGND VPWR VPWR DIN_A_SRAM4 sky130_fd_sc_hd__buf_2
X_1453_ Tile_X0Y0_S4END[15] VGND VGND VPWR VPWR net619 sky130_fd_sc_hd__buf_6
X_0404_ net21 net53 Tile_X0Y0_OpenRAM_top.Inst_OpenRAM_top_switch_matrix.J_NS4_BEG5
+ Tile_X0Y0_OpenRAM_top.Inst_OpenRAM_top_switch_matrix.J_NS2_BEG5 Tile_X0Y0_OpenRAM_top.Inst_OpenRAM_top_ConfigMem.Inst_frame4_bit16.Q
+ Tile_X0Y0_OpenRAM_top.Inst_OpenRAM_top_ConfigMem.Inst_frame4_bit17.Q VGND VGND VPWR
+ VPWR Tile_X0Y0_OpenRAM_top.Inst_OpenRAM_top_switch_matrix.WW4BEG10 sky130_fd_sc_hd__mux4_1
XFILLER_67_200 VGND VGND VPWR VPWR sky130_fd_sc_hd__decap_3
X_1384_ Tile_X0Y0_OpenRAM_top.Inst_OpenRAM_top_switch_matrix.WW4BEG6 VGND VGND VPWR
+ VPWR net550 sky130_fd_sc_hd__buf_1
XFILLER_121_190 VGND VGND VPWR VPWR sky130_fd_sc_hd__decap_3
X_0335_ net190 net200 net182 _0083_ Tile_X0Y1_OpenRAM_bot.Inst_OpenRAM_bot_ConfigMem.Inst_frame8_bit15.Q
+ Tile_X0Y1_OpenRAM_bot.Inst_OpenRAM_bot_ConfigMem.Inst_frame8_bit14.Q VGND VGND VPWR
+ VPWR Tile_X0Y0_OpenRAM_top.Inst_OpenRAM_top_switch_matrix.N2BEGb3 sky130_fd_sc_hd__mux4_1
XFILLER_27_108 VGND VGND VPWR VPWR sky130_fd_sc_hd__decap_3
XFILLER_27_119 VGND VGND VPWR VPWR sky130_fd_sc_hd__decap_3
X_0266_ Tile_X0Y1_OpenRAM_bot.Inst_OpenRAM_bot_ConfigMem.Inst_frame3_bit9.Q Tile_X0Y1_OpenRAM_bot.Inst_OpenRAM_bot_ConfigMem.Inst_frame3_bit10.Q
+ net181 _0034_ _0035_ VGND VGND VPWR VPWR _0036_ sky130_fd_sc_hd__o311a_1
XTAP_TAPCELL_ROW_93_743 VGND VPWR sky130_fd_sc_hd__tapvpwrvgnd_1
XFILLER_35_152 VGND VGND VPWR VPWR sky130_fd_sc_hd__decap_3
XFILLER_35_196 VGND VGND VPWR VPWR sky130_fd_sc_hd__fill_2
XFILLER_50_100 VGND VGND VPWR VPWR sky130_fd_sc_hd__decap_3
XFILLER_50_144 VGND VGND VPWR VPWR sky130_fd_sc_hd__decap_3
XFILLER_50_177 VGND VGND VPWR VPWR sky130_fd_sc_hd__fill_1
XFILLER_136_227 VGND VGND VPWR VPWR sky130_fd_sc_hd__decap_3
XFILLER_104_113 VGND VGND VPWR VPWR sky130_fd_sc_hd__decap_3
XFILLER_4_9 VGND VGND VPWR VPWR sky130_fd_sc_hd__decap_3
XFILLER_58_200 VGND VGND VPWR VPWR sky130_fd_sc_hd__decap_3
XFILLER_76_27 VGND VGND VPWR VPWR sky130_fd_sc_hd__fill_1
XFILLER_76_38 VGND VGND VPWR VPWR sky130_fd_sc_hd__decap_3
XFILLER_132_44 VGND VGND VPWR VPWR sky130_fd_sc_hd__decap_3
XFILLER_73_203 VGND VGND VPWR VPWR sky130_fd_sc_hd__decap_3
XFILLER_73_225 VGND VGND VPWR VPWR sky130_fd_sc_hd__fill_1
XFILLER_26_130 VGND VGND VPWR VPWR sky130_fd_sc_hd__decap_3
XFILLER_92_15 VGND VGND VPWR VPWR sky130_fd_sc_hd__decap_3
XFILLER_132_99 VGND VGND VPWR VPWR sky130_fd_sc_hd__decap_3
XFILLER_26_141 VGND VGND VPWR VPWR sky130_fd_sc_hd__decap_3
XTAP_TAPCELL_ROW_111_814 VGND VPWR sky130_fd_sc_hd__tapvpwrvgnd_1
XFILLER_25_42 VGND VGND VPWR VPWR sky130_fd_sc_hd__decap_3
XFILLER_26_174 VGND VGND VPWR VPWR sky130_fd_sc_hd__decap_3
XFILLER_41_122 VGND VGND VPWR VPWR sky130_fd_sc_hd__decap_3
XFILLER_41_155 VGND VGND VPWR VPWR sky130_fd_sc_hd__decap_3
XFILLER_41_199 VGND VGND VPWR VPWR sky130_fd_sc_hd__decap_3
XFILLER_41_41 VGND VGND VPWR VPWR sky130_fd_sc_hd__decap_3
XFILLER_41_63 VGND VGND VPWR VPWR sky130_fd_sc_hd__decap_3
XFILLER_157_63 VGND VGND VPWR VPWR sky130_fd_sc_hd__decap_3
XPHY_EDGE_ROW_23_Left_206 VGND VGND VPWR VPWR sky130_fd_sc_hd__decap_3
XFILLER_157_96 VGND VGND VPWR VPWR sky130_fd_sc_hd__decap_3
XFILLER_173_51 VGND VGND VPWR VPWR sky130_fd_sc_hd__decap_3
XTAP_TAPCELL_ROW_169_1047 VGND VPWR sky130_fd_sc_hd__tapvpwrvgnd_1
XFILLER_173_84 VGND VGND VPWR VPWR sky130_fd_sc_hd__decap_3
XFILLER_110_138 VGND VGND VPWR VPWR sky130_fd_sc_hd__fill_2
XFILLER_2_24 VGND VGND VPWR VPWR sky130_fd_sc_hd__decap_3
XFILLER_49_200 VGND VGND VPWR VPWR sky130_fd_sc_hd__decap_3
XFILLER_49_222 VGND VGND VPWR VPWR sky130_fd_sc_hd__fill_2
XFILLER_110_149 VGND VGND VPWR VPWR sky130_fd_sc_hd__decap_3
XFILLER_103_190 VGND VGND VPWR VPWR sky130_fd_sc_hd__decap_3
XTAP_TAPCELL_ROW_134_906 VGND VPWR sky130_fd_sc_hd__tapvpwrvgnd_1
XPHY_EDGE_ROW_32_Left_215 VGND VGND VPWR VPWR sky130_fd_sc_hd__decap_3
XFILLER_64_203 VGND VGND VPWR VPWR sky130_fd_sc_hd__decap_3
XFILLER_32_100 VGND VGND VPWR VPWR sky130_fd_sc_hd__decap_3
XFILLER_177_116 VGND VGND VPWR VPWR sky130_fd_sc_hd__decap_3
XFILLER_32_133 VGND VGND VPWR VPWR sky130_fd_sc_hd__decap_3
XFILLER_32_144 VGND VGND VPWR VPWR sky130_fd_sc_hd__decap_3
XFILLER_82_70 VGND VGND VPWR VPWR sky130_fd_sc_hd__decap_3
XFILLER_177_149 VGND VGND VPWR VPWR sky130_fd_sc_hd__decap_3
XFILLER_32_177 VGND VGND VPWR VPWR sky130_fd_sc_hd__decap_3
X_0953_ net131 net268 VGND VGND VPWR VPWR Tile_X0Y0_OpenRAM_top.Inst_OpenRAM_top_ConfigMem.Inst_frame8_bit25.Q
+ sky130_fd_sc_hd__dlxtp_1
X_0884_ net137 net282 VGND VGND VPWR VPWR Tile_X0Y0_OpenRAM_top.Inst_OpenRAM_top_ConfigMem.Inst_frame6_bit30.Q
+ sky130_fd_sc_hd__dlxtp_1
XPHY_EDGE_ROW_41_Left_224 VGND VGND VPWR VPWR sky130_fd_sc_hd__decap_3
XFILLER_99_111 VGND VGND VPWR VPWR sky130_fd_sc_hd__fill_1
XFILLER_99_122 VGND VGND VPWR VPWR sky130_fd_sc_hd__decap_3
X_1505_ Tile_X0Y1_OpenRAM_bot.Inst_OpenRAM_bot_switch_matrix.WW4BEG11 VGND VGND VPWR
+ VPWR net656 sky130_fd_sc_hd__clkbuf_1
XFILLER_101_138 VGND VGND VPWR VPWR sky130_fd_sc_hd__decap_3
X_1436_ Tile_X0Y1_OpenRAM_bot.Inst_OpenRAM_bot_switch_matrix.S2BEG6 VGND VGND VPWR
+ VPWR net596 sky130_fd_sc_hd__clkbuf_2
X_1367_ Tile_X0Y0_OpenRAM_top.Inst_OpenRAM_top_switch_matrix.W6BEG1 VGND VGND VPWR
+ VPWR net529 sky130_fd_sc_hd__buf_1
XPHY_EDGE_ROW_50_Left_233 VGND VGND VPWR VPWR sky130_fd_sc_hd__decap_3
X_0318_ _0021_ Tile_X0Y1_OpenRAM_bot.Inst_OpenRAM_bot_ConfigMem.Inst_frame0_bit31.Q
+ _0077_ _0079_ VGND VGND VPWR VPWR _0080_ sky130_fd_sc_hd__a31o_1
XFILLER_46_19 VGND VGND VPWR VPWR sky130_fd_sc_hd__decap_3
XFILLER_55_225 VGND VGND VPWR VPWR sky130_fd_sc_hd__decap_3
X_1298_ Tile_X0Y1_FrameStrobe[9] VGND VGND VPWR VPWR net468 sky130_fd_sc_hd__buf_6
XFILLER_70_206 VGND VGND VPWR VPWR sky130_fd_sc_hd__decap_3
X_0249_ Tile_X0Y1_OpenRAM_bot.Inst_OpenRAM_bot_ConfigMem.Inst_frame3_bit20.Q VGND
+ VGND VPWR VPWR _0022_ sky130_fd_sc_hd__inv_2
XFILLER_23_122 VGND VGND VPWR VPWR sky130_fd_sc_hd__decap_3
XFILLER_178_18 VGND VGND VPWR VPWR sky130_fd_sc_hd__decap_3
XFILLER_178_29 VGND VGND VPWR VPWR sky130_fd_sc_hd__decap_3
XFILLER_168_127 VGND VGND VPWR VPWR sky130_fd_sc_hd__fill_1
XFILLER_109_205 VGND VGND VPWR VPWR sky130_fd_sc_hd__fill_2
XFILLER_176_171 VGND VGND VPWR VPWR sky130_fd_sc_hd__decap_3
XFILLER_11_22 VGND VGND VPWR VPWR sky130_fd_sc_hd__decap_3
XFILLER_127_22 VGND VGND VPWR VPWR sky130_fd_sc_hd__decap_3
XFILLER_11_66 VGND VGND VPWR VPWR sky130_fd_sc_hd__decap_3
XFILLER_11_55 VGND VGND VPWR VPWR sky130_fd_sc_hd__fill_1
XFILLER_127_66 VGND VGND VPWR VPWR sky130_fd_sc_hd__decap_3
XFILLER_127_55 VGND VGND VPWR VPWR sky130_fd_sc_hd__fill_1
XFILLER_11_99 VGND VGND VPWR VPWR sky130_fd_sc_hd__decap_3
XFILLER_2_6 VGND VGND VPWR VPWR sky130_fd_sc_hd__decap_3
XFILLER_87_15 VGND VGND VPWR VPWR sky130_fd_sc_hd__decap_3
XFILLER_127_99 VGND VGND VPWR VPWR sky130_fd_sc_hd__decap_3
XFILLER_87_48 VGND VGND VPWR VPWR sky130_fd_sc_hd__decap_3
Xfanout330 net331 VGND VGND VPWR VPWR net330 sky130_fd_sc_hd__buf_2
XFILLER_143_54 VGND VGND VPWR VPWR sky130_fd_sc_hd__fill_2
XFILLER_46_203 VGND VGND VPWR VPWR sky130_fd_sc_hd__decap_3
XFILLER_100_193 VGND VGND VPWR VPWR sky130_fd_sc_hd__decap_3
XFILLER_36_41 VGND VGND VPWR VPWR sky130_fd_sc_hd__decap_3
XFILLER_14_122 VGND VGND VPWR VPWR sky130_fd_sc_hd__decap_3
XFILLER_14_100 VGND VGND VPWR VPWR sky130_fd_sc_hd__decap_3
XTAP_TAPCELL_ROW_29_489 VGND VPWR sky130_fd_sc_hd__tapvpwrvgnd_1
XFILLER_36_85 VGND VGND VPWR VPWR sky130_fd_sc_hd__decap_3
XFILLER_14_144 VGND VGND VPWR VPWR sky130_fd_sc_hd__decap_3
XFILLER_159_149 VGND VGND VPWR VPWR sky130_fd_sc_hd__decap_3
XFILLER_14_177 VGND VGND VPWR VPWR sky130_fd_sc_hd__decap_3
XTAP_TAPCELL_ROW_175_1073 VGND VPWR sky130_fd_sc_hd__tapvpwrvgnd_1
XFILLER_168_62 VGND VGND VPWR VPWR sky130_fd_sc_hd__decap_3
Xinput16 DOUT_A_SRAM21 VGND VGND VPWR VPWR net16 sky130_fd_sc_hd__clkbuf_4
Xinput27 DOUT_A_SRAM31 VGND VGND VPWR VPWR net27 sky130_fd_sc_hd__clkbuf_2
XFILLER_167_193 VGND VGND VPWR VPWR sky130_fd_sc_hd__decap_3
Xinput38 DOUT_B_SRAM12 VGND VGND VPWR VPWR net38 sky130_fd_sc_hd__dlymetal6s2s_1
Xinput49 DOUT_B_SRAM22 VGND VGND VPWR VPWR net49 sky130_fd_sc_hd__clkbuf_2
XPHY_EDGE_ROW_107_Left_290 VGND VGND VPWR VPWR sky130_fd_sc_hd__decap_3
XFILLER_96_114 VGND VGND VPWR VPWR sky130_fd_sc_hd__decap_3
X_1221_ net233 net272 VGND VGND VPWR VPWR Tile_X0Y1_OpenRAM_bot.Inst_OpenRAM_bot_ConfigMem.Inst_frame7_bit1.Q
+ sky130_fd_sc_hd__dlxtp_1
XFILLER_37_214 VGND VGND VPWR VPWR sky130_fd_sc_hd__decap_3
X_1152_ net250 net290 VGND VGND VPWR VPWR Tile_X0Y1_OpenRAM_bot.Inst_OpenRAM_bot_ConfigMem.Inst_frame5_bit6.Q
+ sky130_fd_sc_hd__dlxtp_1
XFILLER_37_225 VGND VGND VPWR VPWR sky130_fd_sc_hd__decap_3
XTAP_TAPCELL_ROW_182_1099 VGND VPWR sky130_fd_sc_hd__tapvpwrvgnd_1
X_1083_ net224 net306 VGND VGND VPWR VPWR Tile_X0Y1_OpenRAM_bot.Inst_OpenRAM_bot_ConfigMem.Inst_frame3_bit11.Q
+ sky130_fd_sc_hd__dlxtp_1
XFILLER_93_80 VGND VGND VPWR VPWR sky130_fd_sc_hd__decap_3
XFILLER_20_147 VGND VGND VPWR VPWR sky130_fd_sc_hd__decap_3
XFILLER_20_125 VGND VGND VPWR VPWR sky130_fd_sc_hd__decap_3
XFILLER_165_119 VGND VGND VPWR VPWR sky130_fd_sc_hd__decap_3
X_0936_ net115 net275 VGND VGND VPWR VPWR Tile_X0Y0_OpenRAM_top.Inst_OpenRAM_top_ConfigMem.Inst_frame7_bit10.Q
+ sky130_fd_sc_hd__dlxtp_1
XFILLER_9_181 VGND VGND VPWR VPWR sky130_fd_sc_hd__decap_3
XFILLER_173_152 VGND VGND VPWR VPWR sky130_fd_sc_hd__decap_3
X_0867_ net120 net291 VGND VGND VPWR VPWR Tile_X0Y0_OpenRAM_top.Inst_OpenRAM_top_ConfigMem.Inst_frame5_bit15.Q
+ sky130_fd_sc_hd__dlxtp_1
XFILLER_173_196 VGND VGND VPWR VPWR sky130_fd_sc_hd__decap_3
X_0798_ net126 net309 VGND VGND VPWR VPWR Tile_X0Y0_OpenRAM_top.Inst_OpenRAM_top_ConfigMem.Inst_frame3_bit20.Q
+ sky130_fd_sc_hd__dlxtp_1
XFILLER_87_136 VGND VGND VPWR VPWR sky130_fd_sc_hd__decap_3
X_1419_ net239 VGND VGND VPWR VPWR net571 sky130_fd_sc_hd__buf_6
XFILLER_113_46 VGND VGND VPWR VPWR sky130_fd_sc_hd__decap_3
XFILLER_113_24 VGND VGND VPWR VPWR sky130_fd_sc_hd__decap_3
XFILLER_95_191 VGND VGND VPWR VPWR sky130_fd_sc_hd__decap_3
XFILLER_11_125 VGND VGND VPWR VPWR sky130_fd_sc_hd__decap_3
XFILLER_11_158 VGND VGND VPWR VPWR sky130_fd_sc_hd__decap_3
XFILLER_22_32 VGND VGND VPWR VPWR sky130_fd_sc_hd__fill_2
XFILLER_22_43 VGND VGND VPWR VPWR sky130_fd_sc_hd__decap_3
XFILLER_164_141 VGND VGND VPWR VPWR sky130_fd_sc_hd__decap_3
XFILLER_138_32 VGND VGND VPWR VPWR sky130_fd_sc_hd__decap_3
XPHY_EDGE_ROW_129_Right_129 VGND VGND VPWR VPWR sky130_fd_sc_hd__decap_3
XFILLER_22_76 VGND VGND VPWR VPWR sky130_fd_sc_hd__decap_3
XFILLER_98_58 VGND VGND VPWR VPWR sky130_fd_sc_hd__decap_3
XFILLER_154_20 VGND VGND VPWR VPWR sky130_fd_sc_hd__decap_3
XFILLER_0_3 VGND VGND VPWR VPWR sky130_fd_sc_hd__decap_3
XFILLER_120_200 VGND VGND VPWR VPWR sky130_fd_sc_hd__decap_3
XFILLER_78_114 VGND VGND VPWR VPWR sky130_fd_sc_hd__decap_3
XFILLER_78_147 VGND VGND VPWR VPWR sky130_fd_sc_hd__decap_3
XFILLER_19_214 VGND VGND VPWR VPWR sky130_fd_sc_hd__decap_3
XFILLER_47_40 VGND VGND VPWR VPWR sky130_fd_sc_hd__decap_3
XFILLER_170_41 VGND VGND VPWR VPWR sky130_fd_sc_hd__decap_3
XFILLER_19_225 VGND VGND VPWR VPWR sky130_fd_sc_hd__decap_3
XFILLER_86_180 VGND VGND VPWR VPWR sky130_fd_sc_hd__decap_3
XFILLER_170_74 VGND VGND VPWR VPWR sky130_fd_sc_hd__decap_3
XFILLER_170_85 VGND VGND VPWR VPWR sky130_fd_sc_hd__decap_3
XFILLER_63_94 VGND VGND VPWR VPWR sky130_fd_sc_hd__decap_3
XFILLER_179_72 VGND VGND VPWR VPWR sky130_fd_sc_hd__decap_3
XFILLER_147_108 VGND VGND VPWR VPWR sky130_fd_sc_hd__decap_3
XFILLER_8_12 VGND VGND VPWR VPWR sky130_fd_sc_hd__decap_3
XTAP_TAPCELL_ROW_25_470 VGND VPWR sky130_fd_sc_hd__tapvpwrvgnd_1
XFILLER_147_119 VGND VGND VPWR VPWR sky130_fd_sc_hd__decap_3
XFILLER_8_56 VGND VGND VPWR VPWR sky130_fd_sc_hd__decap_3
X_0721_ net125 net337 VGND VGND VPWR VPWR Tile_X0Y0_OpenRAM_top.Inst_OpenRAM_top_ConfigMem.Inst_frame0_bit1.Q
+ sky130_fd_sc_hd__dlxtp_1
XFILLER_170_100 VGND VGND VPWR VPWR sky130_fd_sc_hd__decap_3
XFILLER_155_152 VGND VGND VPWR VPWR sky130_fd_sc_hd__decap_3
XFILLER_10_180 VGND VGND VPWR VPWR sky130_fd_sc_hd__decap_3
XFILLER_6_162 VGND VGND VPWR VPWR sky130_fd_sc_hd__decap_3
XFILLER_170_133 VGND VGND VPWR VPWR sky130_fd_sc_hd__decap_3
XFILLER_155_196 VGND VGND VPWR VPWR sky130_fd_sc_hd__decap_3
XFILLER_6_195 VGND VGND VPWR VPWR sky130_fd_sc_hd__fill_1
X_0652_ _0152_ _0148_ Tile_X0Y1_OpenRAM_bot.Inst_OpenRAM_bot_ConfigMem.Inst_frame7_bit28.Q
+ VGND VGND VPWR VPWR _0193_ sky130_fd_sc_hd__mux2_1
XFILLER_170_144 VGND VGND VPWR VPWR sky130_fd_sc_hd__decap_3
X_0583_ net61 _0150_ _0154_ _0085_ Tile_X0Y1_OpenRAM_bot.Inst_OpenRAM_bot_ConfigMem.Inst_frame3_bit3.Q
+ Tile_X0Y1_OpenRAM_bot.Inst_OpenRAM_bot_ConfigMem.Inst_frame3_bit2.Q VGND VGND VPWR
+ VPWR Tile_X0Y1_OpenRAM_bot.Inst_OpenRAM_bot_switch_matrix.W6BEG9 sky130_fd_sc_hd__mux4_1
XFILLER_170_177 VGND VGND VPWR VPWR sky130_fd_sc_hd__decap_3
XFILLER_69_103 VGND VGND VPWR VPWR sky130_fd_sc_hd__decap_3
XFILLER_88_80 VGND VGND VPWR VPWR sky130_fd_sc_hd__decap_3
XFILLER_88_91 VGND VGND VPWR VPWR sky130_fd_sc_hd__decap_3
XFILLER_69_158 VGND VGND VPWR VPWR sky130_fd_sc_hd__decap_3
XFILLER_69_169 VGND VGND VPWR VPWR sky130_fd_sc_hd__decap_3
X_1204_ net231 net270 VGND VGND VPWR VPWR Tile_X0Y1_OpenRAM_bot.Inst_OpenRAM_bot_ConfigMem.Inst_frame7_bit18.Q
+ sky130_fd_sc_hd__dlxtp_1
X_1135_ net237 net287 VGND VGND VPWR VPWR Tile_X0Y1_OpenRAM_bot.Inst_OpenRAM_bot_ConfigMem.Inst_frame5_bit23.Q
+ sky130_fd_sc_hd__dlxtp_1
XTAP_TAPCELL_ROW_48_562 VGND VPWR sky130_fd_sc_hd__tapvpwrvgnd_1
XFILLER_92_150 VGND VGND VPWR VPWR sky130_fd_sc_hd__decap_3
XFILLER_25_228 VGND VGND VPWR VPWR sky130_fd_sc_hd__fill_2
XFILLER_92_183 VGND VGND VPWR VPWR sky130_fd_sc_hd__decap_3
XFILLER_178_200 VGND VGND VPWR VPWR sky130_fd_sc_hd__decap_3
X_1066_ net242 net305 VGND VGND VPWR VPWR Tile_X0Y1_OpenRAM_bot.Inst_OpenRAM_bot_ConfigMem.Inst_frame3_bit28.Q
+ sky130_fd_sc_hd__dlxtp_1
XTAP_TAPCELL_ROW_31_495 VGND VPWR sky130_fd_sc_hd__tapvpwrvgnd_1
X_0919_ net133 net275 VGND VGND VPWR VPWR Tile_X0Y0_OpenRAM_top.Inst_OpenRAM_top_ConfigMem.Inst_frame7_bit27.Q
+ sky130_fd_sc_hd__dlxtp_1
XFILLER_146_174 VGND VGND VPWR VPWR sky130_fd_sc_hd__fill_1
XFILLER_146_141 VGND VGND VPWR VPWR sky130_fd_sc_hd__fill_2
XFILLER_161_122 VGND VGND VPWR VPWR sky130_fd_sc_hd__decap_3
XFILLER_161_155 VGND VGND VPWR VPWR sky130_fd_sc_hd__fill_1
XTAP_TAPCELL_ROW_8_405 VGND VPWR sky130_fd_sc_hd__tapvpwrvgnd_1
Xinput206 Tile_X0Y1_EE4END[0] VGND VGND VPWR VPWR net206 sky130_fd_sc_hd__buf_1
Xinput217 Tile_X0Y1_EE4END[5] VGND VGND VPWR VPWR net217 sky130_fd_sc_hd__buf_1
XFILLER_124_56 VGND VGND VPWR VPWR sky130_fd_sc_hd__decap_3
Xinput228 Tile_X0Y1_FrameData[15] VGND VGND VPWR VPWR net228 sky130_fd_sc_hd__clkbuf_4
Xinput239 Tile_X0Y1_FrameData[25] VGND VGND VPWR VPWR net239 sky130_fd_sc_hd__clkbuf_4
XFILLER_75_106 VGND VGND VPWR VPWR sky130_fd_sc_hd__fill_1
XFILLER_68_180 VGND VGND VPWR VPWR sky130_fd_sc_hd__decap_3
XFILLER_83_161 VGND VGND VPWR VPWR sky130_fd_sc_hd__decap_3
XFILLER_17_87 VGND VGND VPWR VPWR sky130_fd_sc_hd__decap_3
XFILLER_169_211 VGND VGND VPWR VPWR sky130_fd_sc_hd__decap_3
XTAP_TAPCELL_ROW_54_587 VGND VPWR sky130_fd_sc_hd__tapvpwrvgnd_1
XTAP_TAPCELL_ROW_14_429 VGND VPWR sky130_fd_sc_hd__tapvpwrvgnd_1
XFILLER_149_31 VGND VGND VPWR VPWR sky130_fd_sc_hd__decap_3
XFILLER_33_53 VGND VGND VPWR VPWR sky130_fd_sc_hd__decap_3
XFILLER_33_75 VGND VGND VPWR VPWR sky130_fd_sc_hd__decap_3
XFILLER_149_97 VGND VGND VPWR VPWR sky130_fd_sc_hd__decap_3
XFILLER_137_141 VGND VGND VPWR VPWR sky130_fd_sc_hd__decap_3
XFILLER_165_30 VGND VGND VPWR VPWR sky130_fd_sc_hd__decap_3
XFILLER_165_52 VGND VGND VPWR VPWR sky130_fd_sc_hd__fill_1
XFILLER_152_144 VGND VGND VPWR VPWR sky130_fd_sc_hd__fill_2
XFILLER_98_209 VGND VGND VPWR VPWR sky130_fd_sc_hd__decap_3
XFILLER_3_143 VGND VGND VPWR VPWR sky130_fd_sc_hd__decap_3
XFILLER_165_74 VGND VGND VPWR VPWR sky130_fd_sc_hd__decap_3
XFILLER_3_187 VGND VGND VPWR VPWR sky130_fd_sc_hd__decap_3
XFILLER_58_72 VGND VGND VPWR VPWR sky130_fd_sc_hd__decap_3
XFILLER_58_94 VGND VGND VPWR VPWR sky130_fd_sc_hd__decap_3
XFILLER_59_180 VGND VGND VPWR VPWR sky130_fd_sc_hd__decap_3
XFILLER_66_139 VGND VGND VPWR VPWR sky130_fd_sc_hd__fill_1
XFILLER_74_150 VGND VGND VPWR VPWR sky130_fd_sc_hd__fill_1
XTAP_TAPCELL_ROW_77_679 VGND VPWR sky130_fd_sc_hd__tapvpwrvgnd_1
XFILLER_74_172 VGND VGND VPWR VPWR sky130_fd_sc_hd__decap_3
XFILLER_175_225 VGND VGND VPWR VPWR sky130_fd_sc_hd__decap_3
XFILLER_175_214 VGND VGND VPWR VPWR sky130_fd_sc_hd__decap_3
XFILLER_128_130 VGND VGND VPWR VPWR sky130_fd_sc_hd__decap_3
XFILLER_143_122 VGND VGND VPWR VPWR sky130_fd_sc_hd__decap_3
XFILLER_128_174 VGND VGND VPWR VPWR sky130_fd_sc_hd__decap_3
X_0704_ net123 net335 VGND VGND VPWR VPWR Tile_X0Y0_OpenRAM_top.Inst_OpenRAM_top_ConfigMem.Inst_frame0_bit18.Q
+ sky130_fd_sc_hd__dlxtp_1
XFILLER_143_155 VGND VGND VPWR VPWR sky130_fd_sc_hd__decap_3
XFILLER_99_90 VGND VGND VPWR VPWR sky130_fd_sc_hd__decap_3
X_0635_ Tile_X0Y1_OpenRAM_bot.Inst_OpenRAM_bot_ConfigMem.Inst_frame8_bit28.Q _0178_
+ VGND VGND VPWR VPWR _0179_ sky130_fd_sc_hd__and2b_1
XFILLER_89_209 VGND VGND VPWR VPWR sky130_fd_sc_hd__decap_3
X_0566_ net340 net360 _0077_ net173 Tile_X0Y1_OpenRAM_bot.Inst_OpenRAM_bot_ConfigMem.Inst_frame1_bit14.Q
+ Tile_X0Y1_OpenRAM_bot.Inst_OpenRAM_bot_ConfigMem.Inst_frame1_bit15.Q VGND VGND VPWR
+ VPWR _0153_ sky130_fd_sc_hd__mux4_2
X_0497_ Tile_X0Y0_OpenRAM_top.Inst_OpenRAM_top_switch_matrix.J_NS4_BEG5 Tile_X0Y0_OpenRAM_top.Inst_OpenRAM_top_switch_matrix.J_NS4_BEG9
+ Tile_X0Y0_OpenRAM_top.Inst_OpenRAM_top_switch_matrix.J_NS4_BEG13 Tile_X0Y0_OpenRAM_top.Inst_OpenRAM_top_switch_matrix.J_NS2_BEG5
+ Tile_X0Y0_OpenRAM_top.Inst_OpenRAM_top_ConfigMem.Inst_frame6_bit11.Q Tile_X0Y0_OpenRAM_top.Inst_OpenRAM_top_ConfigMem.Inst_frame6_bit12.Q
+ VGND VGND VPWR VPWR _0136_ sky130_fd_sc_hd__mux4_1
XFILLER_65_172 VGND VGND VPWR VPWR sky130_fd_sc_hd__fill_1
X_1118_ net252 net296 VGND VGND VPWR VPWR Tile_X0Y1_OpenRAM_bot.Inst_OpenRAM_bot_ConfigMem.Inst_frame4_bit8.Q
+ sky130_fd_sc_hd__dlxtp_1
X_1049_ net226 net312 VGND VGND VPWR VPWR Tile_X0Y1_OpenRAM_bot.Inst_OpenRAM_bot_ConfigMem.Inst_frame2_bit13.Q
+ sky130_fd_sc_hd__dlxtp_1
XFILLER_80_164 VGND VGND VPWR VPWR sky130_fd_sc_hd__decap_3
XFILLER_110_47 VGND VGND VPWR VPWR sky130_fd_sc_hd__decap_3
XFILLER_80_197 VGND VGND VPWR VPWR sky130_fd_sc_hd__decap_3
XFILLER_166_203 VGND VGND VPWR VPWR sky130_fd_sc_hd__decap_3
XTAP_TAPCELL_ROW_103_783 VGND VPWR sky130_fd_sc_hd__tapvpwrvgnd_1
XFILLER_70_18 VGND VGND VPWR VPWR sky130_fd_sc_hd__decap_3
XFILLER_119_130 VGND VGND VPWR VPWR sky130_fd_sc_hd__decap_3
XFILLER_119_89 VGND VGND VPWR VPWR sky130_fd_sc_hd__decap_3
XFILLER_102_6 VGND VGND VPWR VPWR sky130_fd_sc_hd__decap_3
XFILLER_0_113 VGND VGND VPWR VPWR sky130_fd_sc_hd__fill_2
XFILLER_135_66 VGND VGND VPWR VPWR sky130_fd_sc_hd__decap_3
XFILLER_48_117 VGND VGND VPWR VPWR sky130_fd_sc_hd__decap_3
XFILLER_95_48 VGND VGND VPWR VPWR sky130_fd_sc_hd__decap_3
XFILLER_28_75 VGND VGND VPWR VPWR sky130_fd_sc_hd__decap_3
XFILLER_151_54 VGND VGND VPWR VPWR sky130_fd_sc_hd__fill_2
XTAP_TAPCELL_ROW_126_875 VGND VPWR sky130_fd_sc_hd__tapvpwrvgnd_1
XFILLER_28_97 VGND VGND VPWR VPWR sky130_fd_sc_hd__decap_3
XFILLER_151_87 VGND VGND VPWR VPWR sky130_fd_sc_hd__decap_3
XFILLER_44_41 VGND VGND VPWR VPWR sky130_fd_sc_hd__decap_3
XFILLER_71_164 VGND VGND VPWR VPWR sky130_fd_sc_hd__decap_3
XFILLER_44_63 VGND VGND VPWR VPWR sky130_fd_sc_hd__decap_3
XFILLER_44_85 VGND VGND VPWR VPWR sky130_fd_sc_hd__decap_3
XPHY_EDGE_ROW_181_Right_181 VGND VGND VPWR VPWR sky130_fd_sc_hd__decap_3
XTAP_TAPCELL_ROW_10_410 VGND VPWR sky130_fd_sc_hd__tapvpwrvgnd_1
XFILLER_8_224 VGND VGND VPWR VPWR sky130_fd_sc_hd__decap_3
XFILLER_60_40 VGND VGND VPWR VPWR sky130_fd_sc_hd__decap_3
XFILLER_172_206 VGND VGND VPWR VPWR sky130_fd_sc_hd__decap_3
XFILLER_60_73 VGND VGND VPWR VPWR sky130_fd_sc_hd__fill_1
XFILLER_176_62 VGND VGND VPWR VPWR sky130_fd_sc_hd__decap_3
XFILLER_125_122 VGND VGND VPWR VPWR sky130_fd_sc_hd__decap_3
XFILLER_125_111 VGND VGND VPWR VPWR sky130_fd_sc_hd__fill_1
XFILLER_5_24 VGND VGND VPWR VPWR sky130_fd_sc_hd__decap_3
XFILLER_140_103 VGND VGND VPWR VPWR sky130_fd_sc_hd__decap_3
XFILLER_5_57 VGND VGND VPWR VPWR sky130_fd_sc_hd__decap_3
X_0420_ net16 Tile_X0Y0_OpenRAM_top.Inst_OpenRAM_top_switch_matrix.J_NS4_BEG10 Tile_X0Y0_OpenRAM_top.Inst_OpenRAM_top_switch_matrix.J_NS4_BEG6
+ net258 Tile_X0Y0_OpenRAM_top.Inst_OpenRAM_top_ConfigMem.Inst_frame3_bit7.Q Tile_X0Y0_OpenRAM_top.Inst_OpenRAM_top_ConfigMem.Inst_frame3_bit6.Q
+ VGND VGND VPWR VPWR Tile_X0Y0_OpenRAM_top.Inst_OpenRAM_top_switch_matrix.W6BEG5
+ sky130_fd_sc_hd__mux4_1
XFILLER_69_60 VGND VGND VPWR VPWR sky130_fd_sc_hd__decap_3
XFILLER_79_220 VGND VGND VPWR VPWR sky130_fd_sc_hd__decap_3
XTAP_TAPCELL_ROW_149_967 VGND VPWR sky130_fd_sc_hd__tapvpwrvgnd_1
X_0351_ Tile_X0Y0_OpenRAM_top.Inst_OpenRAM_top_switch_matrix.N2BEGb6 net164 net355
+ net156 Tile_X0Y0_OpenRAM_top.Inst_OpenRAM_top_ConfigMem.Inst_frame0_bit21.Q Tile_X0Y0_OpenRAM_top.Inst_OpenRAM_top_ConfigMem.Inst_frame0_bit20.Q
+ VGND VGND VPWR VPWR Tile_X0Y0_OpenRAM_top.Inst_OpenRAM_top_switch_matrix.J_NS2_BEG6
+ sky130_fd_sc_hd__mux4_2
XTAP_TAPCELL_ROW_109_809 VGND VPWR sky130_fd_sc_hd__tapvpwrvgnd_1
XFILLER_94_212 VGND VGND VPWR VPWR sky130_fd_sc_hd__decap_3
XFILLER_54_109 VGND VGND VPWR VPWR sky130_fd_sc_hd__decap_3
X_0282_ net181 Tile_X0Y1_OpenRAM_bot.Inst_OpenRAM_bot_ConfigMem.Inst_frame2_bit29.Q
+ Tile_X0Y1_OpenRAM_bot.Inst_OpenRAM_bot_ConfigMem.Inst_frame2_bit30.Q _0049_ _0050_
+ VGND VGND VPWR VPWR _0051_ sky130_fd_sc_hd__o311a_1
XFILLER_47_150 VGND VGND VPWR VPWR sky130_fd_sc_hd__decap_3
XFILLER_47_172 VGND VGND VPWR VPWR sky130_fd_sc_hd__decap_3
XFILLER_62_131 VGND VGND VPWR VPWR sky130_fd_sc_hd__decap_3
XTAP_TAPCELL_ROW_33_502 VGND VPWR sky130_fd_sc_hd__tapvpwrvgnd_1
XFILLER_62_153 VGND VGND VPWR VPWR sky130_fd_sc_hd__decap_3
XFILLER_62_197 VGND VGND VPWR VPWR sky130_fd_sc_hd__decap_3
XFILLER_163_228 VGND VGND VPWR VPWR sky130_fd_sc_hd__fill_2
XFILLER_116_122 VGND VGND VPWR VPWR sky130_fd_sc_hd__decap_3
XFILLER_116_144 VGND VGND VPWR VPWR sky130_fd_sc_hd__decap_3
XFILLER_49_19 VGND VGND VPWR VPWR sky130_fd_sc_hd__decap_3
X_0618_ _0026_ Tile_X0Y1_OpenRAM_bot.Inst_OpenRAM_bot_ConfigMem.Inst_frame1_bit1.Q
+ net263 _0166_ VGND VGND VPWR VPWR net373 sky130_fd_sc_hd__a31o_1
X_0549_ net25 net57 Tile_X0Y1_OpenRAM_bot.Inst_OpenRAM_bot_switch_matrix.J_NS4_BEG12
+ _0084_ Tile_X0Y1_OpenRAM_bot.Inst_OpenRAM_bot_ConfigMem.Inst_frame5_bit22.Q Tile_X0Y1_OpenRAM_bot.Inst_OpenRAM_bot_ConfigMem.Inst_frame5_bit23.Q
+ VGND VGND VPWR VPWR Tile_X0Y1_OpenRAM_bot.Inst_OpenRAM_bot_switch_matrix.WW4BEG3
+ sky130_fd_sc_hd__mux4_1
XFILLER_105_36 VGND VGND VPWR VPWR sky130_fd_sc_hd__decap_3
XFILLER_85_223 VGND VGND VPWR VPWR sky130_fd_sc_hd__fill_1
XFILLER_105_69 VGND VGND VPWR VPWR sky130_fd_sc_hd__decap_3
XTAP_TAPCELL_ROW_162_1020 VGND VPWR sky130_fd_sc_hd__tapvpwrvgnd_1
XFILLER_38_150 VGND VGND VPWR VPWR sky130_fd_sc_hd__decap_3
XFILLER_45_109 VGND VGND VPWR VPWR sky130_fd_sc_hd__decap_3
XFILLER_121_57 VGND VGND VPWR VPWR sky130_fd_sc_hd__decap_3
XFILLER_53_175 VGND VGND VPWR VPWR sky130_fd_sc_hd__decap_3
XFILLER_157_7 VGND VGND VPWR VPWR sky130_fd_sc_hd__fill_1
XFILLER_139_225 VGND VGND VPWR VPWR sky130_fd_sc_hd__fill_1
XFILLER_154_217 VGND VGND VPWR VPWR sky130_fd_sc_hd__decap_3
XFILLER_5_205 VGND VGND VPWR VPWR sky130_fd_sc_hd__decap_3
XFILLER_30_21 VGND VGND VPWR VPWR sky130_fd_sc_hd__decap_3
XFILLER_30_32 VGND VGND VPWR VPWR sky130_fd_sc_hd__decap_3
XFILLER_30_65 VGND VGND VPWR VPWR sky130_fd_sc_hd__decap_3
XFILLER_122_103 VGND VGND VPWR VPWR sky130_fd_sc_hd__decap_3
XFILLER_107_188 VGND VGND VPWR VPWR sky130_fd_sc_hd__decap_3
XFILLER_107_166 VGND VGND VPWR VPWR sky130_fd_sc_hd__fill_2
XFILLER_100_3 VGND VGND VPWR VPWR sky130_fd_sc_hd__decap_3
XFILLER_122_147 VGND VGND VPWR VPWR sky130_fd_sc_hd__decap_3
XFILLER_122_136 VGND VGND VPWR VPWR sky130_fd_sc_hd__decap_3
XFILLER_162_53 VGND VGND VPWR VPWR sky130_fd_sc_hd__decap_3
XFILLER_76_212 VGND VGND VPWR VPWR sky130_fd_sc_hd__fill_2
XFILLER_130_191 VGND VGND VPWR VPWR sky130_fd_sc_hd__decap_3
XFILLER_39_96 VGND VGND VPWR VPWR sky130_fd_sc_hd__decap_3
XFILLER_36_109 VGND VGND VPWR VPWR sky130_fd_sc_hd__decap_3
XFILLER_29_183 VGND VGND VPWR VPWR sky130_fd_sc_hd__decap_3
XFILLER_29_194 VGND VGND VPWR VPWR sky130_fd_sc_hd__decap_3
XFILLER_44_153 VGND VGND VPWR VPWR sky130_fd_sc_hd__decap_3
XFILLER_55_95 VGND VGND VPWR VPWR sky130_fd_sc_hd__decap_3
XTAP_TAPCELL_ROW_62_619 VGND VPWR sky130_fd_sc_hd__tapvpwrvgnd_1
XFILLER_44_175 VGND VGND VPWR VPWR sky130_fd_sc_hd__decap_3
XFILLER_44_197 VGND VGND VPWR VPWR sky130_fd_sc_hd__decap_3
XTAP_TAPCELL_ROW_70_652 VGND VPWR sky130_fd_sc_hd__tapvpwrvgnd_1
XTAP_TAPCELL_ROW_178_1082 VGND VPWR sky130_fd_sc_hd__tapvpwrvgnd_1
XFILLER_71_94 VGND VGND VPWR VPWR sky130_fd_sc_hd__decap_3
XFILLER_145_228 VGND VGND VPWR VPWR sky130_fd_sc_hd__fill_2
Xoutput307 net390 VGND VGND VPWR VPWR DIN_A_SRAM13 sky130_fd_sc_hd__buf_2
XFILLER_113_103 VGND VGND VPWR VPWR sky130_fd_sc_hd__decap_3
Xoutput318 net401 VGND VGND VPWR VPWR DIN_A_SRAM23 sky130_fd_sc_hd__buf_2
Xoutput329 net412 VGND VGND VPWR VPWR DIN_A_SRAM5 sky130_fd_sc_hd__buf_2
XFILLER_113_125 VGND VGND VPWR VPWR sky130_fd_sc_hd__decap_3
X_1452_ Tile_X0Y0_S4END[14] VGND VGND VPWR VPWR net618 sky130_fd_sc_hd__clkbuf_1
X_0403_ Tile_X0Y0_OpenRAM_top.Inst_OpenRAM_top_switch_matrix.N1END1 net362 net147
+ net167 Tile_X0Y0_OpenRAM_top.Inst_OpenRAM_top_ConfigMem.Inst_frame1_bit18.Q Tile_X0Y0_OpenRAM_top.Inst_OpenRAM_top_ConfigMem.Inst_frame1_bit19.Q
+ VGND VGND VPWR VPWR Tile_X0Y0_OpenRAM_top.Inst_OpenRAM_top_switch_matrix.J_NS4_BEG5
+ sky130_fd_sc_hd__mux4_2
XFILLER_113_169 VGND VGND VPWR VPWR sky130_fd_sc_hd__decap_3
X_1383_ Tile_X0Y0_OpenRAM_top.Inst_OpenRAM_top_switch_matrix.WW4BEG5 VGND VGND VPWR
+ VPWR net549 sky130_fd_sc_hd__buf_1
X_0334_ net352 Tile_X0Y0_OpenRAM_top.Inst_OpenRAM_top_switch_matrix.S2BEG3 net344
+ net161 Tile_X0Y1_OpenRAM_bot.Inst_OpenRAM_bot_ConfigMem.Inst_frame0_bit15.Q Tile_X0Y1_OpenRAM_bot.Inst_OpenRAM_bot_ConfigMem.Inst_frame0_bit14.Q
+ VGND VGND VPWR VPWR _0083_ sky130_fd_sc_hd__mux4_2
X_0265_ Tile_X0Y1_OpenRAM_bot.Inst_OpenRAM_bot_ConfigMem.Inst_frame3_bit10.Q _0001_
+ Tile_X0Y1_OpenRAM_bot.Inst_OpenRAM_bot_ConfigMem.Inst_frame3_bit9.Q VGND VGND VPWR
+ VPWR _0035_ sky130_fd_sc_hd__o21ai_1
XTAP_TAPCELL_ROW_93_744 VGND VPWR sky130_fd_sc_hd__tapvpwrvgnd_1
XFILLER_35_164 VGND VGND VPWR VPWR sky130_fd_sc_hd__decap_3
XFILLER_50_112 VGND VGND VPWR VPWR sky130_fd_sc_hd__decap_3
XFILLER_50_156 VGND VGND VPWR VPWR sky130_fd_sc_hd__decap_3
XFILLER_151_209 VGND VGND VPWR VPWR sky130_fd_sc_hd__decap_3
XFILLER_104_147 VGND VGND VPWR VPWR sky130_fd_sc_hd__fill_1
XFILLER_116_35 VGND VGND VPWR VPWR sky130_fd_sc_hd__decap_3
XFILLER_116_68 VGND VGND VPWR VPWR sky130_fd_sc_hd__decap_3
XFILLER_58_212 VGND VGND VPWR VPWR sky130_fd_sc_hd__decap_3
XFILLER_112_180 VGND VGND VPWR VPWR sky130_fd_sc_hd__decap_3
XFILLER_132_23 VGND VGND VPWR VPWR sky130_fd_sc_hd__decap_3
XFILLER_73_215 VGND VGND VPWR VPWR sky130_fd_sc_hd__decap_3
XFILLER_132_78 VGND VGND VPWR VPWR sky130_fd_sc_hd__decap_3
XFILLER_132_56 VGND VGND VPWR VPWR sky130_fd_sc_hd__decap_3
XFILLER_92_27 VGND VGND VPWR VPWR sky130_fd_sc_hd__fill_1
XFILLER_26_153 VGND VGND VPWR VPWR sky130_fd_sc_hd__decap_3
XFILLER_92_38 VGND VGND VPWR VPWR sky130_fd_sc_hd__decap_3
XTAP_TAPCELL_ROW_111_815 VGND VPWR sky130_fd_sc_hd__tapvpwrvgnd_1
XFILLER_26_186 VGND VGND VPWR VPWR sky130_fd_sc_hd__decap_3
XFILLER_26_197 VGND VGND VPWR VPWR sky130_fd_sc_hd__decap_3
XFILLER_179_191 VGND VGND VPWR VPWR sky130_fd_sc_hd__decap_3
XFILLER_41_167 VGND VGND VPWR VPWR sky130_fd_sc_hd__fill_1
XFILLER_41_178 VGND VGND VPWR VPWR sky130_fd_sc_hd__decap_3
XFILLER_127_228 VGND VGND VPWR VPWR sky130_fd_sc_hd__fill_2
XFILLER_41_53 VGND VGND VPWR VPWR sky130_fd_sc_hd__decap_3
XFILLER_41_75 VGND VGND VPWR VPWR sky130_fd_sc_hd__decap_3
XFILLER_157_53 VGND VGND VPWR VPWR sky130_fd_sc_hd__decap_3
XFILLER_173_30 VGND VGND VPWR VPWR sky130_fd_sc_hd__decap_3
XFILLER_173_96 VGND VGND VPWR VPWR sky130_fd_sc_hd__decap_3
XFILLER_173_63 VGND VGND VPWR VPWR sky130_fd_sc_hd__decap_3
XTAP_TAPCELL_ROW_169_1048 VGND VPWR sky130_fd_sc_hd__tapvpwrvgnd_1
XFILLER_110_117 VGND VGND VPWR VPWR sky130_fd_sc_hd__decap_3
XFILLER_2_58 VGND VGND VPWR VPWR sky130_fd_sc_hd__decap_3
XTAP_TAPCELL_ROW_134_907 VGND VPWR sky130_fd_sc_hd__tapvpwrvgnd_1
XFILLER_64_215 VGND VGND VPWR VPWR sky130_fd_sc_hd__decap_3
XFILLER_66_50 VGND VGND VPWR VPWR sky130_fd_sc_hd__decap_3
XTAP_TAPCELL_ROW_142_940 VGND VPWR sky130_fd_sc_hd__tapvpwrvgnd_1
XFILLER_17_164 VGND VGND VPWR VPWR sky130_fd_sc_hd__fill_1
XFILLER_17_142 VGND VGND VPWR VPWR sky130_fd_sc_hd__decap_3
XFILLER_32_112 VGND VGND VPWR VPWR sky130_fd_sc_hd__decap_3
XFILLER_32_156 VGND VGND VPWR VPWR sky130_fd_sc_hd__decap_3
XFILLER_82_82 VGND VGND VPWR VPWR sky130_fd_sc_hd__fill_2
XFILLER_177_128 VGND VGND VPWR VPWR sky130_fd_sc_hd__decap_3
X_0952_ net132 net268 VGND VGND VPWR VPWR Tile_X0Y0_OpenRAM_top.Inst_OpenRAM_top_ConfigMem.Inst_frame8_bit26.Q
+ sky130_fd_sc_hd__dlxtp_1
XFILLER_32_189 VGND VGND VPWR VPWR sky130_fd_sc_hd__decap_3
X_0883_ net138 net283 VGND VGND VPWR VPWR Tile_X0Y0_OpenRAM_top.Inst_OpenRAM_top_ConfigMem.Inst_frame6_bit31.Q
+ sky130_fd_sc_hd__dlxtp_1
XFILLER_63_3 VGND VGND VPWR VPWR sky130_fd_sc_hd__decap_3
X_1504_ Tile_X0Y1_OpenRAM_bot.Inst_OpenRAM_bot_switch_matrix.WW4BEG10 VGND VGND VPWR
+ VPWR net655 sky130_fd_sc_hd__buf_1
XFILLER_99_178 VGND VGND VPWR VPWR sky130_fd_sc_hd__decap_3
XFILLER_99_156 VGND VGND VPWR VPWR sky130_fd_sc_hd__decap_3
XFILLER_101_117 VGND VGND VPWR VPWR sky130_fd_sc_hd__decap_3
X_1435_ Tile_X0Y1_OpenRAM_bot.Inst_OpenRAM_bot_switch_matrix.S2BEG5 VGND VGND VPWR
+ VPWR net595 sky130_fd_sc_hd__buf_2
X_1366_ Tile_X0Y0_OpenRAM_top.Inst_OpenRAM_top_switch_matrix.W6BEG0 VGND VGND VPWR
+ VPWR net526 sky130_fd_sc_hd__clkbuf_2
X_0317_ net199 _0021_ _0078_ VGND VGND VPWR VPWR _0079_ sky130_fd_sc_hd__o21a_1
XFILLER_55_204 VGND VGND VPWR VPWR sky130_fd_sc_hd__decap_3
X_1297_ Tile_X0Y1_FrameStrobe[8] VGND VGND VPWR VPWR net467 sky130_fd_sc_hd__buf_2
XFILLER_102_15 VGND VGND VPWR VPWR sky130_fd_sc_hd__fill_1
X_0248_ Tile_X0Y1_OpenRAM_bot.Inst_OpenRAM_bot_ConfigMem.Inst_frame0_bit30.Q VGND
+ VGND VPWR VPWR _0021_ sky130_fd_sc_hd__inv_2
XFILLER_23_101 VGND VGND VPWR VPWR sky130_fd_sc_hd__decap_3
XFILLER_168_106 VGND VGND VPWR VPWR sky130_fd_sc_hd__decap_3
XFILLER_23_167 VGND VGND VPWR VPWR sky130_fd_sc_hd__fill_1
XFILLER_176_150 VGND VGND VPWR VPWR sky130_fd_sc_hd__decap_3
XFILLER_176_183 VGND VGND VPWR VPWR sky130_fd_sc_hd__decap_3
XFILLER_109_228 VGND VGND VPWR VPWR sky130_fd_sc_hd__fill_2
XFILLER_127_34 VGND VGND VPWR VPWR sky130_fd_sc_hd__decap_3
XFILLER_124_209 VGND VGND VPWR VPWR sky130_fd_sc_hd__decap_3
XFILLER_11_34 VGND VGND VPWR VPWR sky130_fd_sc_hd__decap_3
XFILLER_11_78 VGND VGND VPWR VPWR sky130_fd_sc_hd__decap_3
XFILLER_87_27 VGND VGND VPWR VPWR sky130_fd_sc_hd__decap_3
Xfanout320 net321 VGND VGND VPWR VPWR net320 sky130_fd_sc_hd__clkbuf_2
Xfanout331 Tile_X0Y1_FrameStrobe[0] VGND VGND VPWR VPWR net331 sky130_fd_sc_hd__clkbuf_2
XFILLER_100_150 VGND VGND VPWR VPWR sky130_fd_sc_hd__decap_3
XFILLER_100_172 VGND VGND VPWR VPWR sky130_fd_sc_hd__decap_3
XFILLER_36_53 VGND VGND VPWR VPWR sky130_fd_sc_hd__decap_3
XFILLER_61_229 VGND VGND VPWR VPWR sky130_fd_sc_hd__fill_2
XFILLER_159_128 VGND VGND VPWR VPWR sky130_fd_sc_hd__decap_3
XFILLER_14_189 VGND VGND VPWR VPWR sky130_fd_sc_hd__decap_3
XFILLER_14_156 VGND VGND VPWR VPWR sky130_fd_sc_hd__decap_3
XFILLER_174_109 VGND VGND VPWR VPWR sky130_fd_sc_hd__decap_3
XFILLER_168_41 VGND VGND VPWR VPWR sky130_fd_sc_hd__decap_3
XFILLER_52_85 VGND VGND VPWR VPWR sky130_fd_sc_hd__fill_2
XFILLER_168_85 VGND VGND VPWR VPWR sky130_fd_sc_hd__decap_3
XFILLER_168_74 VGND VGND VPWR VPWR sky130_fd_sc_hd__decap_3
XFILLER_167_172 VGND VGND VPWR VPWR sky130_fd_sc_hd__decap_3
Xinput28 DOUT_A_SRAM4 VGND VGND VPWR VPWR net28 sky130_fd_sc_hd__dlymetal6s2s_1
Xinput17 DOUT_A_SRAM22 VGND VGND VPWR VPWR net17 sky130_fd_sc_hd__buf_2
Xinput39 DOUT_B_SRAM13 VGND VGND VPWR VPWR net39 sky130_fd_sc_hd__buf_1
XFILLER_123_220 VGND VGND VPWR VPWR sky130_fd_sc_hd__decap_3
XFILLER_96_159 VGND VGND VPWR VPWR sky130_fd_sc_hd__decap_3
X_1220_ net244 net272 VGND VGND VPWR VPWR Tile_X0Y1_OpenRAM_bot.Inst_OpenRAM_bot_ConfigMem.Inst_frame7_bit2.Q
+ sky130_fd_sc_hd__dlxtp_1
XFILLER_77_60 VGND VGND VPWR VPWR sky130_fd_sc_hd__decap_3
XFILLER_77_82 VGND VGND VPWR VPWR sky130_fd_sc_hd__decap_3
X_1151_ net251 net290 VGND VGND VPWR VPWR Tile_X0Y1_OpenRAM_bot.Inst_OpenRAM_bot_ConfigMem.Inst_frame5_bit7.Q
+ sky130_fd_sc_hd__dlxtp_1
X_1082_ net225 net306 VGND VGND VPWR VPWR Tile_X0Y1_OpenRAM_bot.Inst_OpenRAM_bot_ConfigMem.Inst_frame3_bit12.Q
+ sky130_fd_sc_hd__dlxtp_1
XFILLER_93_92 VGND VGND VPWR VPWR sky130_fd_sc_hd__decap_3
XFILLER_20_137 VGND VGND VPWR VPWR sky130_fd_sc_hd__decap_3
XFILLER_158_183 VGND VGND VPWR VPWR sky130_fd_sc_hd__decap_3
XFILLER_158_150 VGND VGND VPWR VPWR sky130_fd_sc_hd__decap_3
X_0935_ net116 net275 VGND VGND VPWR VPWR Tile_X0Y0_OpenRAM_top.Inst_OpenRAM_top_ConfigMem.Inst_frame7_bit11.Q
+ sky130_fd_sc_hd__dlxtp_1
XFILLER_20_159 VGND VGND VPWR VPWR sky130_fd_sc_hd__decap_3
XFILLER_173_131 VGND VGND VPWR VPWR sky130_fd_sc_hd__decap_3
X_0866_ net121 net292 VGND VGND VPWR VPWR Tile_X0Y0_OpenRAM_top.Inst_OpenRAM_top_ConfigMem.Inst_frame5_bit16.Q
+ sky130_fd_sc_hd__dlxtp_1
XFILLER_9_193 VGND VGND VPWR VPWR sky130_fd_sc_hd__decap_3
XFILLER_173_175 VGND VGND VPWR VPWR sky130_fd_sc_hd__decap_3
XFILLER_173_164 VGND VGND VPWR VPWR sky130_fd_sc_hd__decap_3
XFILLER_106_209 VGND VGND VPWR VPWR sky130_fd_sc_hd__decap_3
X_0797_ net127 net309 VGND VGND VPWR VPWR Tile_X0Y0_OpenRAM_top.Inst_OpenRAM_top_ConfigMem.Inst_frame3_bit21.Q
+ sky130_fd_sc_hd__dlxtp_1
X_1418_ net238 VGND VGND VPWR VPWR net570 sky130_fd_sc_hd__buf_6
XFILLER_57_19 VGND VGND VPWR VPWR sky130_fd_sc_hd__decap_3
XFILLER_87_148 VGND VGND VPWR VPWR sky130_fd_sc_hd__decap_3
XFILLER_3_90 VGND VGND VPWR VPWR sky130_fd_sc_hd__decap_3
X_1349_ Tile_X0Y0_OpenRAM_top.Inst_OpenRAM_top_switch_matrix.W1BEG3 VGND VGND VPWR
+ VPWR net509 sky130_fd_sc_hd__buf_1
XFILLER_113_69 VGND VGND VPWR VPWR sky130_fd_sc_hd__decap_3
XFILLER_43_218 VGND VGND VPWR VPWR sky130_fd_sc_hd__decap_3
XFILLER_43_229 VGND VGND VPWR VPWR sky130_fd_sc_hd__fill_2
XFILLER_156_109 VGND VGND VPWR VPWR sky130_fd_sc_hd__decap_3
XFILLER_11_137 VGND VGND VPWR VPWR sky130_fd_sc_hd__decap_3
XFILLER_149_172 VGND VGND VPWR VPWR sky130_fd_sc_hd__decap_3
XFILLER_149_161 VGND VGND VPWR VPWR sky130_fd_sc_hd__decap_3
XFILLER_7_119 VGND VGND VPWR VPWR sky130_fd_sc_hd__decap_3
XFILLER_7_108 VGND VGND VPWR VPWR sky130_fd_sc_hd__decap_3
XFILLER_138_22 VGND VGND VPWR VPWR sky130_fd_sc_hd__decap_3
XFILLER_164_164 VGND VGND VPWR VPWR sky130_fd_sc_hd__decap_3
XFILLER_138_44 VGND VGND VPWR VPWR sky130_fd_sc_hd__fill_1
XFILLER_98_15 VGND VGND VPWR VPWR sky130_fd_sc_hd__decap_3
XFILLER_22_88 VGND VGND VPWR VPWR sky130_fd_sc_hd__decap_3
XFILLER_164_186 VGND VGND VPWR VPWR sky130_fd_sc_hd__decap_3
XFILLER_138_88 VGND VGND VPWR VPWR sky130_fd_sc_hd__decap_3
XFILLER_105_220 VGND VGND VPWR VPWR sky130_fd_sc_hd__decap_3
XFILLER_154_32 VGND VGND VPWR VPWR sky130_fd_sc_hd__decap_3
XFILLER_78_126 VGND VGND VPWR VPWR sky130_fd_sc_hd__decap_3
Xoutput490 net573 VGND VGND VPWR VPWR Tile_X0Y1_FrameData_O[27] sky130_fd_sc_hd__buf_2
XFILLER_93_107 VGND VGND VPWR VPWR sky130_fd_sc_hd__decap_3
XFILLER_47_52 VGND VGND VPWR VPWR sky130_fd_sc_hd__decap_3
XFILLER_170_53 VGND VGND VPWR VPWR sky130_fd_sc_hd__decap_3
XFILLER_170_97 VGND VGND VPWR VPWR sky130_fd_sc_hd__decap_3
XTAP_TAPCELL_ROW_2_380 VGND VPWR sky130_fd_sc_hd__tapvpwrvgnd_1
XTAP_TAPCELL_ROW_17_438 VGND VPWR sky130_fd_sc_hd__tapvpwrvgnd_1
XFILLER_179_51 VGND VGND VPWR VPWR sky130_fd_sc_hd__decap_3
XFILLER_63_73 VGND VGND VPWR VPWR sky130_fd_sc_hd__decap_3
XFILLER_179_84 VGND VGND VPWR VPWR sky130_fd_sc_hd__decap_3
XFILLER_8_24 VGND VGND VPWR VPWR sky130_fd_sc_hd__decap_3
XTAP_TAPCELL_ROW_25_471 VGND VPWR sky130_fd_sc_hd__tapvpwrvgnd_1
XFILLER_8_35 VGND VGND VPWR VPWR sky130_fd_sc_hd__decap_3
X_0720_ net136 net336 VGND VGND VPWR VPWR Tile_X0Y0_OpenRAM_top.Inst_OpenRAM_top_ConfigMem.Inst_frame0_bit2.Q
+ sky130_fd_sc_hd__dlxtp_1
XFILLER_8_68 VGND VGND VPWR VPWR sky130_fd_sc_hd__decap_3
XFILLER_155_164 VGND VGND VPWR VPWR sky130_fd_sc_hd__decap_3
XFILLER_6_141 VGND VGND VPWR VPWR sky130_fd_sc_hd__decap_3
XFILLER_6_130 VGND VGND VPWR VPWR sky130_fd_sc_hd__decap_3
XFILLER_170_112 VGND VGND VPWR VPWR sky130_fd_sc_hd__decap_3
XFILLER_6_174 VGND VGND VPWR VPWR sky130_fd_sc_hd__decap_3
X_0651_ _0189_ _0191_ _0192_ Tile_X0Y1_OpenRAM_bot.Inst_OpenRAM_bot_ConfigMem.Inst_frame7_bit3.Q
+ VGND VGND VPWR VPWR Tile_X0Y0_OpenRAM_top.N4BEG_outbuf_11.A sky130_fd_sc_hd__o22a_1
XFILLER_170_156 VGND VGND VPWR VPWR sky130_fd_sc_hd__decap_3
X_0582_ net60 _0149_ _0153_ _0084_ Tile_X0Y1_OpenRAM_bot.Inst_OpenRAM_bot_ConfigMem.Inst_frame3_bit1.Q
+ Tile_X0Y1_OpenRAM_bot.Inst_OpenRAM_bot_ConfigMem.Inst_frame3_bit0.Q VGND VGND VPWR
+ VPWR Tile_X0Y1_OpenRAM_bot.Inst_OpenRAM_bot_switch_matrix.W6BEG8 sky130_fd_sc_hd__mux4_1
XFILLER_170_189 VGND VGND VPWR VPWR sky130_fd_sc_hd__decap_3
XFILLER_111_223 VGND VGND VPWR VPWR sky130_fd_sc_hd__fill_1
XFILLER_69_137 VGND VGND VPWR VPWR sky130_fd_sc_hd__decap_3
X_1203_ net232 net270 VGND VGND VPWR VPWR Tile_X0Y1_OpenRAM_bot.Inst_OpenRAM_bot_ConfigMem.Inst_frame7_bit19.Q
+ sky130_fd_sc_hd__dlxtp_1
X_1134_ net238 net287 VGND VGND VPWR VPWR Tile_X0Y1_OpenRAM_bot.Inst_OpenRAM_bot_ConfigMem.Inst_frame5_bit24.Q
+ sky130_fd_sc_hd__dlxtp_1
XTAP_TAPCELL_ROW_48_563 VGND VPWR sky130_fd_sc_hd__tapvpwrvgnd_1
X_1065_ net243 net305 VGND VGND VPWR VPWR Tile_X0Y1_OpenRAM_bot.Inst_OpenRAM_bot_ConfigMem.Inst_frame3_bit29.Q
+ sky130_fd_sc_hd__dlxtp_1
XFILLER_92_195 VGND VGND VPWR VPWR sky130_fd_sc_hd__fill_1
XFILLER_178_212 VGND VGND VPWR VPWR sky130_fd_sc_hd__decap_3
X_0918_ net134 net274 VGND VGND VPWR VPWR Tile_X0Y0_OpenRAM_top.Inst_OpenRAM_top_ConfigMem.Inst_frame7_bit28.Q
+ sky130_fd_sc_hd__dlxtp_1
XTAP_TAPCELL_ROW_31_496 VGND VPWR sky130_fd_sc_hd__tapvpwrvgnd_1
XFILLER_146_197 VGND VGND VPWR VPWR sky130_fd_sc_hd__fill_1
X_0849_ net125 net300 VGND VGND VPWR VPWR Tile_X0Y0_OpenRAM_top.Inst_OpenRAM_top_ConfigMem.Inst_frame4_bit1.Q
+ sky130_fd_sc_hd__dlxtp_1
XFILLER_161_134 VGND VGND VPWR VPWR sky130_fd_sc_hd__decap_3
XFILLER_108_47 VGND VGND VPWR VPWR sky130_fd_sc_hd__decap_3
XFILLER_161_178 VGND VGND VPWR VPWR sky130_fd_sc_hd__decap_3
XFILLER_102_212 VGND VGND VPWR VPWR sky130_fd_sc_hd__decap_3
Xinput218 Tile_X0Y1_EE4END[6] VGND VGND VPWR VPWR net218 sky130_fd_sc_hd__buf_1
Xinput207 Tile_X0Y1_EE4END[10] VGND VGND VPWR VPWR net207 sky130_fd_sc_hd__buf_1
XFILLER_124_35 VGND VGND VPWR VPWR sky130_fd_sc_hd__decap_3
XFILLER_124_24 VGND VGND VPWR VPWR sky130_fd_sc_hd__decap_3
Xinput229 Tile_X0Y1_FrameData[16] VGND VGND VPWR VPWR net229 sky130_fd_sc_hd__clkbuf_4
XFILLER_124_68 VGND VGND VPWR VPWR sky130_fd_sc_hd__decap_3
XFILLER_68_192 VGND VGND VPWR VPWR sky130_fd_sc_hd__decap_3
XFILLER_83_140 VGND VGND VPWR VPWR sky130_fd_sc_hd__decap_3
XPHY_EDGE_ROW_162_Right_162 VGND VGND VPWR VPWR sky130_fd_sc_hd__decap_3
XFILLER_17_44 VGND VGND VPWR VPWR sky130_fd_sc_hd__decap_3
XFILLER_16_218 VGND VGND VPWR VPWR sky130_fd_sc_hd__decap_3
XFILLER_140_56 VGND VGND VPWR VPWR sky130_fd_sc_hd__decap_3
XFILLER_17_66 VGND VGND VPWR VPWR sky130_fd_sc_hd__decap_3
XFILLER_169_223 VGND VGND VPWR VPWR sky130_fd_sc_hd__fill_1
XTAP_TAPCELL_ROW_54_588 VGND VPWR sky130_fd_sc_hd__tapvpwrvgnd_1
XFILLER_149_43 VGND VGND VPWR VPWR sky130_fd_sc_hd__decap_3
XFILLER_129_109 VGND VGND VPWR VPWR sky130_fd_sc_hd__decap_3
XFILLER_137_120 VGND VGND VPWR VPWR sky130_fd_sc_hd__decap_3
XFILLER_33_87 VGND VGND VPWR VPWR sky130_fd_sc_hd__decap_3
XFILLER_149_87 VGND VGND VPWR VPWR sky130_fd_sc_hd__decap_3
XFILLER_137_153 VGND VGND VPWR VPWR sky130_fd_sc_hd__decap_3
XFILLER_152_112 VGND VGND VPWR VPWR sky130_fd_sc_hd__decap_3
XFILLER_137_175 VGND VGND VPWR VPWR sky130_fd_sc_hd__decap_3
XFILLER_3_111 VGND VGND VPWR VPWR sky130_fd_sc_hd__fill_1
XFILLER_165_42 VGND VGND VPWR VPWR sky130_fd_sc_hd__fill_1
XFILLER_3_122 VGND VGND VPWR VPWR sky130_fd_sc_hd__decap_3
XFILLER_165_86 VGND VGND VPWR VPWR sky130_fd_sc_hd__decap_3
XFILLER_3_166 VGND VGND VPWR VPWR sky130_fd_sc_hd__fill_2
XFILLER_3_199 VGND VGND VPWR VPWR sky130_fd_sc_hd__decap_3
XFILLER_66_118 VGND VGND VPWR VPWR sky130_fd_sc_hd__decap_3
XFILLER_74_184 VGND VGND VPWR VPWR sky130_fd_sc_hd__decap_3
XFILLER_74_83 VGND VGND VPWR VPWR sky130_fd_sc_hd__fill_1
XFILLER_30_221 VGND VGND VPWR VPWR sky130_fd_sc_hd__decap_3
XFILLER_90_71 VGND VGND VPWR VPWR sky130_fd_sc_hd__decap_3
XFILLER_128_153 VGND VGND VPWR VPWR sky130_fd_sc_hd__decap_3
XFILLER_143_101 VGND VGND VPWR VPWR sky130_fd_sc_hd__decap_3
XFILLER_128_197 VGND VGND VPWR VPWR sky130_fd_sc_hd__decap_3
XFILLER_128_186 VGND VGND VPWR VPWR sky130_fd_sc_hd__decap_3
X_0703_ net124 net335 VGND VGND VPWR VPWR Tile_X0Y0_OpenRAM_top.Inst_OpenRAM_top_ConfigMem.Inst_frame0_bit19.Q
+ sky130_fd_sc_hd__dlxtp_1
XFILLER_143_134 VGND VGND VPWR VPWR sky130_fd_sc_hd__decap_3
X_0634_ _0151_ _0147_ Tile_X0Y1_OpenRAM_bot.Inst_OpenRAM_bot_ConfigMem.Inst_frame8_bit27.Q
+ VGND VGND VPWR VPWR _0178_ sky130_fd_sc_hd__mux2_1
XFILLER_143_178 VGND VGND VPWR VPWR sky130_fd_sc_hd__decap_3
XFILLER_143_167 VGND VGND VPWR VPWR sky130_fd_sc_hd__fill_1
XFILLER_97_210 VGND VGND VPWR VPWR sky130_fd_sc_hd__decap_3
X_0565_ net5 net37 _0152_ _0084_ Tile_X0Y1_OpenRAM_bot.Inst_OpenRAM_bot_ConfigMem.Inst_frame4_bit6.Q
+ Tile_X0Y1_OpenRAM_bot.Inst_OpenRAM_bot_ConfigMem.Inst_frame4_bit7.Q VGND VGND VPWR
+ VPWR Tile_X0Y1_OpenRAM_bot.Inst_OpenRAM_bot_switch_matrix.WW4BEG11 sky130_fd_sc_hd__mux4_1
X_0496_ _0015_ _0131_ _0135_ VGND VGND VPWR VPWR Tile_X0Y0_OpenRAM_top.Inst_OpenRAM_top_switch_matrix.S4BEG0
+ sky130_fd_sc_hd__o21a_1
XFILLER_57_129 VGND VGND VPWR VPWR sky130_fd_sc_hd__decap_3
XFILLER_65_140 VGND VGND VPWR VPWR sky130_fd_sc_hd__decap_3
X_1117_ net253 net296 VGND VGND VPWR VPWR Tile_X0Y1_OpenRAM_bot.Inst_OpenRAM_bot_ConfigMem.Inst_frame4_bit9.Q
+ sky130_fd_sc_hd__dlxtp_1
XFILLER_110_15 VGND VGND VPWR VPWR sky130_fd_sc_hd__decap_3
XFILLER_0_91 VGND VGND VPWR VPWR sky130_fd_sc_hd__fill_1
X_1048_ net227 net314 VGND VGND VPWR VPWR Tile_X0Y1_OpenRAM_bot.Inst_OpenRAM_bot_ConfigMem.Inst_frame2_bit14.Q
+ sky130_fd_sc_hd__dlxtp_1
XFILLER_80_176 VGND VGND VPWR VPWR sky130_fd_sc_hd__decap_3
XFILLER_166_215 VGND VGND VPWR VPWR sky130_fd_sc_hd__decap_3
XPHY_EDGE_ROW_125_Left_308 VGND VGND VPWR VPWR sky130_fd_sc_hd__decap_3
XTAP_TAPCELL_ROW_103_784 VGND VPWR sky130_fd_sc_hd__tapvpwrvgnd_1
XPHY_EDGE_ROW_3_Right_3 VGND VGND VPWR VPWR sky130_fd_sc_hd__decap_3
XFILLER_119_186 VGND VGND VPWR VPWR sky130_fd_sc_hd__decap_3
XFILLER_119_57 VGND VGND VPWR VPWR sky130_fd_sc_hd__decap_3
XFILLER_134_134 VGND VGND VPWR VPWR sky130_fd_sc_hd__decap_3
XFILLER_79_39 VGND VGND VPWR VPWR sky130_fd_sc_hd__fill_2
XFILLER_134_178 VGND VGND VPWR VPWR sky130_fd_sc_hd__decap_3
XFILLER_88_221 VGND VGND VPWR VPWR sky130_fd_sc_hd__decap_3
XFILLER_135_89 VGND VGND VPWR VPWR sky130_fd_sc_hd__decap_3
XFILLER_135_78 VGND VGND VPWR VPWR sky130_fd_sc_hd__decap_3
XPHY_EDGE_ROW_134_Left_317 VGND VGND VPWR VPWR sky130_fd_sc_hd__decap_3
XFILLER_28_32 VGND VGND VPWR VPWR sky130_fd_sc_hd__fill_1
XFILLER_48_129 VGND VGND VPWR VPWR sky130_fd_sc_hd__decap_3
XFILLER_178_3 VGND VGND VPWR VPWR sky130_fd_sc_hd__decap_3
XFILLER_151_66 VGND VGND VPWR VPWR sky130_fd_sc_hd__decap_3
XFILLER_56_151 VGND VGND VPWR VPWR sky130_fd_sc_hd__decap_3
XFILLER_151_99 VGND VGND VPWR VPWR sky130_fd_sc_hd__decap_3
XTAP_TAPCELL_ROW_126_876 VGND VPWR sky130_fd_sc_hd__tapvpwrvgnd_1
XFILLER_56_184 VGND VGND VPWR VPWR sky130_fd_sc_hd__decap_3
XFILLER_71_110 VGND VGND VPWR VPWR sky130_fd_sc_hd__fill_2
XFILLER_44_20 VGND VGND VPWR VPWR sky130_fd_sc_hd__decap_3
XPHY_EDGE_ROW_143_Left_326 VGND VGND VPWR VPWR sky130_fd_sc_hd__decap_3
XFILLER_44_75 VGND VGND VPWR VPWR sky130_fd_sc_hd__decap_3
XFILLER_8_203 VGND VGND VPWR VPWR sky130_fd_sc_hd__decap_3
XFILLER_44_97 VGND VGND VPWR VPWR sky130_fd_sc_hd__decap_3
XFILLER_100_70 VGND VGND VPWR VPWR sky130_fd_sc_hd__decap_3
XTAP_TAPCELL_ROW_10_411 VGND VPWR sky130_fd_sc_hd__tapvpwrvgnd_1
XFILLER_60_52 VGND VGND VPWR VPWR sky130_fd_sc_hd__decap_3
XFILLER_176_74 VGND VGND VPWR VPWR sky130_fd_sc_hd__decap_3
XFILLER_176_41 VGND VGND VPWR VPWR sky130_fd_sc_hd__decap_3
XFILLER_172_218 VGND VGND VPWR VPWR sky130_fd_sc_hd__decap_3
Xclkbuf_1_0__f_Tile_X0Y1_UserCLK clknet_0_Tile_X0Y1_UserCLK VGND VGND VPWR VPWR clknet_1_0__leaf_Tile_X0Y1_UserCLK
+ sky130_fd_sc_hd__clkbuf_16
XFILLER_176_85 VGND VGND VPWR VPWR sky130_fd_sc_hd__decap_3
XFILLER_5_36 VGND VGND VPWR VPWR sky130_fd_sc_hd__decap_3
XFILLER_125_178 VGND VGND VPWR VPWR sky130_fd_sc_hd__decap_3
XFILLER_5_69 VGND VGND VPWR VPWR sky130_fd_sc_hd__decap_3
XPHY_EDGE_ROW_152_Left_335 VGND VGND VPWR VPWR sky130_fd_sc_hd__decap_3
XFILLER_69_72 VGND VGND VPWR VPWR sky130_fd_sc_hd__fill_1
XTAP_TAPCELL_ROW_149_968 VGND VPWR sky130_fd_sc_hd__tapvpwrvgnd_1
XFILLER_140_159 VGND VGND VPWR VPWR sky130_fd_sc_hd__decap_3
XFILLER_69_94 VGND VGND VPWR VPWR sky130_fd_sc_hd__decap_3
X_0350_ net187 net197 net179 _0086_ Tile_X0Y1_OpenRAM_bot.Inst_OpenRAM_bot_ConfigMem.Inst_frame8_bit21.Q
+ Tile_X0Y1_OpenRAM_bot.Inst_OpenRAM_bot_ConfigMem.Inst_frame8_bit20.Q VGND VGND VPWR
+ VPWR Tile_X0Y0_OpenRAM_top.Inst_OpenRAM_top_switch_matrix.N2BEGb6 sky130_fd_sc_hd__mux4_1
X_0281_ _0001_ Tile_X0Y1_OpenRAM_bot.Inst_OpenRAM_bot_ConfigMem.Inst_frame2_bit30.Q
+ Tile_X0Y1_OpenRAM_bot.Inst_OpenRAM_bot_ConfigMem.Inst_frame2_bit29.Q VGND VGND VPWR
+ VPWR _0050_ sky130_fd_sc_hd__o21ai_1
XFILLER_94_224 VGND VGND VPWR VPWR sky130_fd_sc_hd__fill_2
XFILLER_10_6 VGND VGND VPWR VPWR sky130_fd_sc_hd__decap_3
XFILLER_47_162 VGND VGND VPWR VPWR sky130_fd_sc_hd__decap_3
XFILLER_47_184 VGND VGND VPWR VPWR sky130_fd_sc_hd__decap_3
XPHY_EDGE_ROW_161_Left_344 VGND VGND VPWR VPWR sky130_fd_sc_hd__decap_3
XTAP_TAPCELL_ROW_33_503 VGND VPWR sky130_fd_sc_hd__tapvpwrvgnd_1
XFILLER_62_165 VGND VGND VPWR VPWR sky130_fd_sc_hd__decap_3
XFILLER_93_3 VGND VGND VPWR VPWR sky130_fd_sc_hd__decap_3
XFILLER_116_134 VGND VGND VPWR VPWR sky130_fd_sc_hd__decap_3
XPHY_EDGE_ROW_170_Left_353 VGND VGND VPWR VPWR sky130_fd_sc_hd__decap_3
XFILLER_116_156 VGND VGND VPWR VPWR sky130_fd_sc_hd__decap_3
XFILLER_131_148 VGND VGND VPWR VPWR sky130_fd_sc_hd__decap_3
X_0617_ net178 _0026_ _0165_ VGND VGND VPWR VPWR _0166_ sky130_fd_sc_hd__o21a_1
XFILLER_105_15 VGND VGND VPWR VPWR sky130_fd_sc_hd__decap_3
X_0548_ net14 net46 Tile_X0Y1_OpenRAM_bot.Inst_OpenRAM_bot_switch_matrix.J_NS4_BEG13
+ _0085_ Tile_X0Y1_OpenRAM_bot.Inst_OpenRAM_bot_ConfigMem.Inst_frame5_bit20.Q Tile_X0Y1_OpenRAM_bot.Inst_OpenRAM_bot_ConfigMem.Inst_frame5_bit21.Q
+ VGND VGND VPWR VPWR Tile_X0Y1_OpenRAM_bot.Inst_OpenRAM_bot_switch_matrix.WW4BEG2
+ sky130_fd_sc_hd__mux4_1
XFILLER_105_48 VGND VGND VPWR VPWR sky130_fd_sc_hd__decap_3
XFILLER_85_202 VGND VGND VPWR VPWR sky130_fd_sc_hd__decap_3
X_0479_ _0119_ _0120_ _0121_ Tile_X0Y0_OpenRAM_top.Inst_OpenRAM_top_ConfigMem.Inst_frame7_bit8.Q
+ Tile_X0Y0_OpenRAM_top.Inst_OpenRAM_top_ConfigMem.Inst_frame7_bit9.Q VGND VGND VPWR
+ VPWR _0122_ sky130_fd_sc_hd__a221o_1
XTAP_TAPCELL_ROW_162_1021 VGND VPWR sky130_fd_sc_hd__tapvpwrvgnd_1
XFILLER_53_110 VGND VGND VPWR VPWR sky130_fd_sc_hd__fill_2
XFILLER_121_69 VGND VGND VPWR VPWR sky130_fd_sc_hd__decap_3
XFILLER_121_36 VGND VGND VPWR VPWR sky130_fd_sc_hd__decap_3
XFILLER_53_187 VGND VGND VPWR VPWR sky130_fd_sc_hd__decap_3
XFILLER_81_29 VGND VGND VPWR VPWR sky130_fd_sc_hd__decap_3
XFILLER_139_204 VGND VGND VPWR VPWR sky130_fd_sc_hd__decap_3
XFILLER_14_45 VGND VGND VPWR VPWR sky130_fd_sc_hd__decap_3
XFILLER_154_229 VGND VGND VPWR VPWR sky130_fd_sc_hd__fill_1
XFILLER_5_228 VGND VGND VPWR VPWR sky130_fd_sc_hd__decap_3
XFILLER_5_217 VGND VGND VPWR VPWR sky130_fd_sc_hd__decap_3
XFILLER_146_22 VGND VGND VPWR VPWR sky130_fd_sc_hd__decap_3
XFILLER_107_134 VGND VGND VPWR VPWR sky130_fd_sc_hd__decap_3
XFILLER_30_44 VGND VGND VPWR VPWR sky130_fd_sc_hd__decap_3
XFILLER_146_44 VGND VGND VPWR VPWR sky130_fd_sc_hd__fill_2
XFILLER_30_77 VGND VGND VPWR VPWR sky130_fd_sc_hd__decap_3
XFILLER_30_88 VGND VGND VPWR VPWR sky130_fd_sc_hd__decap_3
XFILLER_146_77 VGND VGND VPWR VPWR sky130_fd_sc_hd__decap_3
XFILLER_122_115 VGND VGND VPWR VPWR sky130_fd_sc_hd__decap_3
XFILLER_122_159 VGND VGND VPWR VPWR sky130_fd_sc_hd__decap_3
XFILLER_39_20 VGND VGND VPWR VPWR sky130_fd_sc_hd__fill_1
XFILLER_39_42 VGND VGND VPWR VPWR sky130_fd_sc_hd__fill_2
XTAP_TAPCELL_ROW_87_720 VGND VPWR sky130_fd_sc_hd__tapvpwrvgnd_1
XFILLER_162_65 VGND VGND VPWR VPWR sky130_fd_sc_hd__decap_3
XFILLER_162_98 VGND VGND VPWR VPWR sky130_fd_sc_hd__decap_3
XFILLER_91_205 VGND VGND VPWR VPWR sky130_fd_sc_hd__decap_3
XFILLER_44_121 VGND VGND VPWR VPWR sky130_fd_sc_hd__decap_3
XFILLER_55_52 VGND VGND VPWR VPWR sky130_fd_sc_hd__decap_3
XFILLER_55_63 VGND VGND VPWR VPWR sky130_fd_sc_hd__decap_3
XTAP_TAPCELL_ROW_70_653 VGND VPWR sky130_fd_sc_hd__tapvpwrvgnd_1
XFILLER_71_51 VGND VGND VPWR VPWR sky130_fd_sc_hd__decap_3
XTAP_TAPCELL_ROW_178_1083 VGND VPWR sky130_fd_sc_hd__tapvpwrvgnd_1
XFILLER_145_207 VGND VGND VPWR VPWR sky130_fd_sc_hd__decap_3
Xoutput308 net391 VGND VGND VPWR VPWR DIN_A_SRAM14 sky130_fd_sc_hd__buf_2
Xoutput319 net402 VGND VGND VPWR VPWR DIN_A_SRAM24 sky130_fd_sc_hd__buf_2
X_1451_ Tile_X0Y0_S4END[13] VGND VGND VPWR VPWR net617 sky130_fd_sc_hd__buf_6
X_1382_ Tile_X0Y0_OpenRAM_top.Inst_OpenRAM_top_switch_matrix.WW4BEG4 VGND VGND VPWR
+ VPWR net548 sky130_fd_sc_hd__clkbuf_2
X_0402_ net20 net52 Tile_X0Y0_OpenRAM_top.Inst_OpenRAM_top_switch_matrix.J_NS4_BEG6
+ Tile_X0Y0_OpenRAM_top.Inst_OpenRAM_top_switch_matrix.J_NS2_BEG6 Tile_X0Y0_OpenRAM_top.Inst_OpenRAM_top_ConfigMem.Inst_frame4_bit14.Q
+ Tile_X0Y0_OpenRAM_top.Inst_OpenRAM_top_ConfigMem.Inst_frame4_bit15.Q VGND VGND VPWR
+ VPWR Tile_X0Y0_OpenRAM_top.Inst_OpenRAM_top_switch_matrix.WW4BEG9 sky130_fd_sc_hd__mux4_1
XFILLER_96_70 VGND VGND VPWR VPWR sky130_fd_sc_hd__fill_2
X_0333_ net82 net74 net88 net256 Tile_X0Y0_OpenRAM_top.Inst_OpenRAM_top_ConfigMem.Inst_frame7_bit30.Q
+ Tile_X0Y0_OpenRAM_top.Inst_OpenRAM_top_ConfigMem.Inst_frame7_bit31.Q VGND VGND VPWR
+ VPWR Tile_X0Y0_OpenRAM_top.Inst_OpenRAM_top_switch_matrix.S2BEG3 sky130_fd_sc_hd__mux4_2
XFILLER_121_181 VGND VGND VPWR VPWR sky130_fd_sc_hd__decap_3
X_0264_ net160 Tile_X0Y1_OpenRAM_bot.Inst_OpenRAM_bot_ConfigMem.Inst_frame3_bit10.Q
+ VGND VGND VPWR VPWR _0034_ sky130_fd_sc_hd__nand2b_1
XTAP_TAPCELL_ROW_93_745 VGND VPWR sky130_fd_sc_hd__tapvpwrvgnd_1
XFILLER_35_143 VGND VGND VPWR VPWR sky130_fd_sc_hd__decap_3
XFILLER_35_187 VGND VGND VPWR VPWR sky130_fd_sc_hd__decap_3
XFILLER_50_124 VGND VGND VPWR VPWR sky130_fd_sc_hd__fill_2
XFILLER_2_209 VGND VGND VPWR VPWR sky130_fd_sc_hd__fill_2
XFILLER_104_137 VGND VGND VPWR VPWR sky130_fd_sc_hd__decap_3
XFILLER_116_25 VGND VGND VPWR VPWR sky130_fd_sc_hd__decap_3
XFILLER_58_224 VGND VGND VPWR VPWR sky130_fd_sc_hd__decap_3
XFILLER_76_18 VGND VGND VPWR VPWR sky130_fd_sc_hd__decap_3
XFILLER_76_29 VGND VGND VPWR VPWR sky130_fd_sc_hd__decap_3
XFILLER_112_192 VGND VGND VPWR VPWR sky130_fd_sc_hd__decap_3
XFILLER_132_35 VGND VGND VPWR VPWR sky130_fd_sc_hd__decap_3
XFILLER_25_11 VGND VGND VPWR VPWR sky130_fd_sc_hd__fill_1
XTAP_TAPCELL_ROW_151_974 VGND VPWR sky130_fd_sc_hd__tapvpwrvgnd_1
XFILLER_25_33 VGND VGND VPWR VPWR sky130_fd_sc_hd__decap_3
XFILLER_41_113 VGND VGND VPWR VPWR sky130_fd_sc_hd__decap_3
XTAP_TAPCELL_ROW_111_816 VGND VPWR sky130_fd_sc_hd__tapvpwrvgnd_1
XFILLER_25_55 VGND VGND VPWR VPWR sky130_fd_sc_hd__fill_1
XFILLER_41_146 VGND VGND VPWR VPWR sky130_fd_sc_hd__decap_3
XFILLER_25_99 VGND VGND VPWR VPWR sky130_fd_sc_hd__fill_1
XFILLER_127_207 VGND VGND VPWR VPWR sky130_fd_sc_hd__decap_3
XFILLER_157_87 VGND VGND VPWR VPWR sky130_fd_sc_hd__decap_3
XFILLER_150_221 VGND VGND VPWR VPWR sky130_fd_sc_hd__decap_3
XFILLER_173_42 VGND VGND VPWR VPWR sky130_fd_sc_hd__decap_3
XFILLER_1_220 VGND VGND VPWR VPWR sky130_fd_sc_hd__decap_3
XFILLER_173_75 VGND VGND VPWR VPWR sky130_fd_sc_hd__decap_3
XTAP_TAPCELL_ROW_169_1049 VGND VPWR sky130_fd_sc_hd__tapvpwrvgnd_1
XFILLER_2_15 VGND VGND VPWR VPWR sky130_fd_sc_hd__decap_3
XFILLER_106_80 VGND VGND VPWR VPWR sky130_fd_sc_hd__decap_3
XFILLER_103_181 VGND VGND VPWR VPWR sky130_fd_sc_hd__decap_3
XTAP_TAPCELL_ROW_134_908 VGND VPWR sky130_fd_sc_hd__tapvpwrvgnd_1
XFILLER_106_91 VGND VGND VPWR VPWR sky130_fd_sc_hd__decap_3
XFILLER_66_62 VGND VGND VPWR VPWR sky130_fd_sc_hd__fill_1
XTAP_TAPCELL_ROW_142_941 VGND VPWR sky130_fd_sc_hd__tapvpwrvgnd_1
XFILLER_82_50 VGND VGND VPWR VPWR sky130_fd_sc_hd__decap_3
XFILLER_32_124 VGND VGND VPWR VPWR sky130_fd_sc_hd__decap_3
XFILLER_82_61 VGND VGND VPWR VPWR sky130_fd_sc_hd__decap_3
X_0951_ net133 net268 VGND VGND VPWR VPWR Tile_X0Y0_OpenRAM_top.Inst_OpenRAM_top_ConfigMem.Inst_frame8_bit27.Q
+ sky130_fd_sc_hd__dlxtp_1
XFILLER_32_168 VGND VGND VPWR VPWR sky130_fd_sc_hd__decap_3
X_0882_ net114 net291 VGND VGND VPWR VPWR Tile_X0Y0_OpenRAM_top.Inst_OpenRAM_top_ConfigMem.Inst_frame5_bit0.Q
+ sky130_fd_sc_hd__dlxtp_1
XFILLER_99_102 VGND VGND VPWR VPWR sky130_fd_sc_hd__decap_3
XFILLER_99_135 VGND VGND VPWR VPWR sky130_fd_sc_hd__decap_3
XFILLER_99_113 VGND VGND VPWR VPWR sky130_fd_sc_hd__decap_3
X_1503_ Tile_X0Y1_OpenRAM_bot.Inst_OpenRAM_bot_switch_matrix.WW4BEG9 VGND VGND VPWR
+ VPWR net669 sky130_fd_sc_hd__buf_1
XFILLER_101_129 VGND VGND VPWR VPWR sky130_fd_sc_hd__decap_3
X_1434_ Tile_X0Y1_OpenRAM_bot.Inst_OpenRAM_bot_switch_matrix.S2BEG4 VGND VGND VPWR
+ VPWR net594 sky130_fd_sc_hd__clkbuf_2
X_1365_ Tile_X0Y0_OpenRAM_top.Inst_OpenRAM_top_switch_matrix.W2BEGb7 VGND VGND VPWR
+ VPWR net525 sky130_fd_sc_hd__buf_1
X_0316_ net340 Tile_X0Y1_OpenRAM_bot.Inst_OpenRAM_bot_ConfigMem.Inst_frame0_bit30.Q
+ Tile_X0Y1_OpenRAM_bot.Inst_OpenRAM_bot_ConfigMem.Inst_frame0_bit31.Q VGND VGND VPWR
+ VPWR _0078_ sky130_fd_sc_hd__o21ba_1
XFILLER_55_216 VGND VGND VPWR VPWR sky130_fd_sc_hd__decap_3
X_1296_ net276 VGND VGND VPWR VPWR net466 sky130_fd_sc_hd__buf_1
X_0247_ Tile_X0Y1_OpenRAM_bot.Inst_OpenRAM_bot_ConfigMem.Inst_frame0_bit28.Q VGND
+ VGND VPWR VPWR _0020_ sky130_fd_sc_hd__inv_2
XFILLER_23_113 VGND VGND VPWR VPWR sky130_fd_sc_hd__decap_3
XFILLER_168_118 VGND VGND VPWR VPWR sky130_fd_sc_hd__decap_3
XFILLER_176_162 VGND VGND VPWR VPWR sky130_fd_sc_hd__decap_3
XFILLER_31_190 VGND VGND VPWR VPWR sky130_fd_sc_hd__decap_3
XFILLER_176_195 VGND VGND VPWR VPWR sky130_fd_sc_hd__fill_1
XFILLER_11_13 VGND VGND VPWR VPWR sky130_fd_sc_hd__decap_3
XFILLER_11_57 VGND VGND VPWR VPWR sky130_fd_sc_hd__decap_3
XFILLER_11_46 VGND VGND VPWR VPWR sky130_fd_sc_hd__decap_3
XFILLER_127_57 VGND VGND VPWR VPWR sky130_fd_sc_hd__decap_3
XFILLER_127_46 VGND VGND VPWR VPWR sky130_fd_sc_hd__decap_3
XFILLER_87_39 VGND VGND VPWR VPWR sky130_fd_sc_hd__decap_3
Xfanout310 net311 VGND VGND VPWR VPWR net310 sky130_fd_sc_hd__buf_2
Xfanout321 Tile_X0Y1_FrameStrobe[2] VGND VGND VPWR VPWR net321 sky130_fd_sc_hd__clkbuf_2
Xfanout332 Tile_X0Y1_FrameStrobe[0] VGND VGND VPWR VPWR net332 sky130_fd_sc_hd__buf_2
XFILLER_143_45 VGND VGND VPWR VPWR sky130_fd_sc_hd__decap_3
XFILLER_143_78 VGND VGND VPWR VPWR sky130_fd_sc_hd__decap_3
XFILLER_100_162 VGND VGND VPWR VPWR sky130_fd_sc_hd__decap_3
XFILLER_36_32 VGND VGND VPWR VPWR sky130_fd_sc_hd__decap_3
XFILLER_61_208 VGND VGND VPWR VPWR sky130_fd_sc_hd__decap_3
XFILLER_36_65 VGND VGND VPWR VPWR sky130_fd_sc_hd__decap_3
XFILLER_14_168 VGND VGND VPWR VPWR sky130_fd_sc_hd__decap_3
XFILLER_168_53 VGND VGND VPWR VPWR sky130_fd_sc_hd__decap_3
XFILLER_167_162 VGND VGND VPWR VPWR sky130_fd_sc_hd__decap_3
Xinput18 DOUT_A_SRAM23 VGND VGND VPWR VPWR net18 sky130_fd_sc_hd__buf_2
XFILLER_168_97 VGND VGND VPWR VPWR sky130_fd_sc_hd__decap_3
XFILLER_167_184 VGND VGND VPWR VPWR sky130_fd_sc_hd__decap_3
Xinput29 DOUT_A_SRAM5 VGND VGND VPWR VPWR net29 sky130_fd_sc_hd__buf_1
XFILLER_182_165 VGND VGND VPWR VPWR sky130_fd_sc_hd__decap_3
XPHY_EDGE_ROW_176_Right_176 VGND VGND VPWR VPWR sky130_fd_sc_hd__decap_3
XFILLER_77_72 VGND VGND VPWR VPWR sky130_fd_sc_hd__decap_3
XFILLER_96_138 VGND VGND VPWR VPWR sky130_fd_sc_hd__fill_2
X_1150_ net252 net287 VGND VGND VPWR VPWR Tile_X0Y1_OpenRAM_bot.Inst_OpenRAM_bot_ConfigMem.Inst_frame5_bit8.Q
+ sky130_fd_sc_hd__dlxtp_1
XFILLER_37_205 VGND VGND VPWR VPWR sky130_fd_sc_hd__decap_3
XFILLER_77_94 VGND VGND VPWR VPWR sky130_fd_sc_hd__decap_3
X_1081_ net226 net306 VGND VGND VPWR VPWR Tile_X0Y1_OpenRAM_bot.Inst_OpenRAM_bot_ConfigMem.Inst_frame3_bit13.Q
+ sky130_fd_sc_hd__dlxtp_1
XFILLER_93_60 VGND VGND VPWR VPWR sky130_fd_sc_hd__fill_1
XFILLER_93_71 VGND VGND VPWR VPWR sky130_fd_sc_hd__decap_3
X_0934_ net117 net275 VGND VGND VPWR VPWR Tile_X0Y0_OpenRAM_top.Inst_OpenRAM_top_ConfigMem.Inst_frame7_bit12.Q
+ sky130_fd_sc_hd__dlxtp_1
XFILLER_13_190 VGND VGND VPWR VPWR sky130_fd_sc_hd__decap_3
XFILLER_9_161 VGND VGND VPWR VPWR sky130_fd_sc_hd__decap_3
XFILLER_158_195 VGND VGND VPWR VPWR sky130_fd_sc_hd__fill_1
X_0865_ net122 net292 VGND VGND VPWR VPWR Tile_X0Y0_OpenRAM_top.Inst_OpenRAM_top_ConfigMem.Inst_frame5_bit17.Q
+ sky130_fd_sc_hd__dlxtp_1
XFILLER_9_172 VGND VGND VPWR VPWR sky130_fd_sc_hd__decap_3
XFILLER_173_143 VGND VGND VPWR VPWR sky130_fd_sc_hd__decap_3
XFILLER_173_187 VGND VGND VPWR VPWR sky130_fd_sc_hd__decap_3
X_0796_ net128 net309 VGND VGND VPWR VPWR Tile_X0Y0_OpenRAM_top.Inst_OpenRAM_top_ConfigMem.Inst_frame3_bit22.Q
+ sky130_fd_sc_hd__dlxtp_1
XFILLER_114_221 VGND VGND VPWR VPWR sky130_fd_sc_hd__decap_3
XPHY_EDGE_ROW_143_Right_143 VGND VGND VPWR VPWR sky130_fd_sc_hd__decap_3
XFILLER_87_105 VGND VGND VPWR VPWR sky130_fd_sc_hd__decap_3
X_1417_ net237 VGND VGND VPWR VPWR net569 sky130_fd_sc_hd__buf_4
X_1348_ Tile_X0Y0_OpenRAM_top.Inst_OpenRAM_top_switch_matrix.W1BEG2 VGND VGND VPWR
+ VPWR net508 sky130_fd_sc_hd__clkbuf_1
X_1279_ net128 VGND VGND VPWR VPWR net431 sky130_fd_sc_hd__buf_1
XFILLER_11_105 VGND VGND VPWR VPWR sky130_fd_sc_hd__decap_3
XFILLER_11_116 VGND VGND VPWR VPWR sky130_fd_sc_hd__decap_3
XFILLER_149_140 VGND VGND VPWR VPWR sky130_fd_sc_hd__decap_3
XFILLER_11_149 VGND VGND VPWR VPWR sky130_fd_sc_hd__decap_3
XFILLER_22_23 VGND VGND VPWR VPWR sky130_fd_sc_hd__decap_3
XFILLER_149_184 VGND VGND VPWR VPWR sky130_fd_sc_hd__decap_3
XFILLER_22_67 VGND VGND VPWR VPWR sky130_fd_sc_hd__decap_3
XFILLER_138_78 VGND VGND VPWR VPWR sky130_fd_sc_hd__decap_3
XFILLER_98_38 VGND VGND VPWR VPWR sky130_fd_sc_hd__decap_3
XFILLER_98_27 VGND VGND VPWR VPWR sky130_fd_sc_hd__fill_1
Xoutput480 net563 VGND VGND VPWR VPWR Tile_X0Y1_FrameData_O[18] sky130_fd_sc_hd__buf_2
XFILLER_154_44 VGND VGND VPWR VPWR sky130_fd_sc_hd__decap_3
XFILLER_78_105 VGND VGND VPWR VPWR sky130_fd_sc_hd__decap_3
Xoutput491 net574 VGND VGND VPWR VPWR Tile_X0Y1_FrameData_O[28] sky130_fd_sc_hd__buf_2
XFILLER_154_88 VGND VGND VPWR VPWR sky130_fd_sc_hd__decap_3
XPHY_EDGE_ROW_110_Right_110 VGND VGND VPWR VPWR sky130_fd_sc_hd__decap_3
XFILLER_78_138 VGND VGND VPWR VPWR sky130_fd_sc_hd__fill_2
XFILLER_19_205 VGND VGND VPWR VPWR sky130_fd_sc_hd__decap_3
XFILLER_170_32 VGND VGND VPWR VPWR sky130_fd_sc_hd__decap_3
XFILLER_170_21 VGND VGND VPWR VPWR sky130_fd_sc_hd__decap_3
XFILLER_170_65 VGND VGND VPWR VPWR sky130_fd_sc_hd__decap_3
XTAP_TAPCELL_ROW_2_381 VGND VPWR sky130_fd_sc_hd__tapvpwrvgnd_1
XFILLER_103_92 VGND VGND VPWR VPWR sky130_fd_sc_hd__decap_3
XFILLER_103_70 VGND VGND VPWR VPWR sky130_fd_sc_hd__decap_3
XTAP_TAPCELL_ROW_17_439 VGND VPWR sky130_fd_sc_hd__tapvpwrvgnd_1
XFILLER_179_30 VGND VGND VPWR VPWR sky130_fd_sc_hd__decap_3
XFILLER_63_52 VGND VGND VPWR VPWR sky130_fd_sc_hd__decap_3
XFILLER_63_63 VGND VGND VPWR VPWR sky130_fd_sc_hd__decap_3
XFILLER_63_85 VGND VGND VPWR VPWR sky130_fd_sc_hd__decap_3
XFILLER_179_63 VGND VGND VPWR VPWR sky130_fd_sc_hd__decap_3
XTAP_TAPCELL_ROW_25_472 VGND VPWR sky130_fd_sc_hd__tapvpwrvgnd_1
XFILLER_179_96 VGND VGND VPWR VPWR sky130_fd_sc_hd__decap_3
XFILLER_8_47 VGND VGND VPWR VPWR sky130_fd_sc_hd__decap_3
XFILLER_10_171 VGND VGND VPWR VPWR sky130_fd_sc_hd__decap_3
XFILLER_6_153 VGND VGND VPWR VPWR sky130_fd_sc_hd__decap_3
XFILLER_170_124 VGND VGND VPWR VPWR sky130_fd_sc_hd__decap_3
XFILLER_6_186 VGND VGND VPWR VPWR sky130_fd_sc_hd__decap_3
X_0650_ net177 net196 net215 _0153_ Tile_X0Y1_OpenRAM_bot.Inst_OpenRAM_bot_ConfigMem.Inst_frame7_bit2.Q
+ Tile_X0Y1_OpenRAM_bot.Inst_OpenRAM_bot_ConfigMem.Inst_frame7_bit1.Q VGND VGND VPWR
+ VPWR _0192_ sky130_fd_sc_hd__mux4_1
XFILLER_6_197 VGND VGND VPWR VPWR sky130_fd_sc_hd__decap_3
X_0581_ net31 _0148_ _0152_ net260 Tile_X0Y1_OpenRAM_bot.Inst_OpenRAM_bot_ConfigMem.Inst_frame4_bit31.Q
+ Tile_X0Y1_OpenRAM_bot.Inst_OpenRAM_bot_ConfigMem.Inst_frame4_bit30.Q VGND VGND VPWR
+ VPWR Tile_X0Y1_OpenRAM_bot.Inst_OpenRAM_bot_switch_matrix.W6BEG7 sky130_fd_sc_hd__mux4_1
XFILLER_170_168 VGND VGND VPWR VPWR sky130_fd_sc_hd__decap_3
XPHY_EDGE_ROW_29_Left_212 VGND VGND VPWR VPWR sky130_fd_sc_hd__decap_3
XFILLER_88_71 VGND VGND VPWR VPWR sky130_fd_sc_hd__decap_3
XFILLER_69_149 VGND VGND VPWR VPWR sky130_fd_sc_hd__decap_3
X_1202_ net234 net270 VGND VGND VPWR VPWR Tile_X0Y1_OpenRAM_bot.Inst_OpenRAM_bot_ConfigMem.Inst_frame7_bit20.Q
+ sky130_fd_sc_hd__dlxtp_1
X_1133_ net239 net287 VGND VGND VPWR VPWR Tile_X0Y1_OpenRAM_bot.Inst_OpenRAM_bot_ConfigMem.Inst_frame5_bit25.Q
+ sky130_fd_sc_hd__dlxtp_1
XFILLER_77_193 VGND VGND VPWR VPWR sky130_fd_sc_hd__decap_3
XFILLER_92_130 VGND VGND VPWR VPWR sky130_fd_sc_hd__decap_3
XFILLER_92_141 VGND VGND VPWR VPWR sky130_fd_sc_hd__decap_3
XFILLER_25_219 VGND VGND VPWR VPWR sky130_fd_sc_hd__decap_3
XTAP_TAPCELL_ROW_48_564 VGND VPWR sky130_fd_sc_hd__tapvpwrvgnd_1
X_1064_ net245 net304 VGND VGND VPWR VPWR Tile_X0Y1_OpenRAM_bot.Inst_OpenRAM_bot_ConfigMem.Inst_frame3_bit30.Q
+ sky130_fd_sc_hd__dlxtp_1
XFILLER_92_174 VGND VGND VPWR VPWR sky130_fd_sc_hd__decap_3
XFILLER_178_224 VGND VGND VPWR VPWR sky130_fd_sc_hd__decap_3
XPHY_EDGE_ROW_38_Left_221 VGND VGND VPWR VPWR sky130_fd_sc_hd__decap_3
X_0917_ net135 net277 VGND VGND VPWR VPWR Tile_X0Y0_OpenRAM_top.Inst_OpenRAM_top_ConfigMem.Inst_frame7_bit29.Q
+ sky130_fd_sc_hd__dlxtp_1
XFILLER_146_132 VGND VGND VPWR VPWR sky130_fd_sc_hd__decap_3
XTAP_TAPCELL_ROW_31_497 VGND VPWR sky130_fd_sc_hd__tapvpwrvgnd_1
XFILLER_161_113 VGND VGND VPWR VPWR sky130_fd_sc_hd__decap_3
X_0848_ net136 net300 VGND VGND VPWR VPWR Tile_X0Y0_OpenRAM_top.Inst_OpenRAM_top_ConfigMem.Inst_frame4_bit2.Q
+ sky130_fd_sc_hd__dlxtp_1
XFILLER_161_146 VGND VGND VPWR VPWR sky130_fd_sc_hd__fill_1
X_0779_ net143 net319 VGND VGND VPWR VPWR Tile_X0Y0_OpenRAM_top.Inst_OpenRAM_top_ConfigMem.Inst_frame2_bit7.Q
+ sky130_fd_sc_hd__dlxtp_1
XPHY_EDGE_ROW_47_Left_230 VGND VGND VPWR VPWR sky130_fd_sc_hd__decap_3
XFILLER_102_224 VGND VGND VPWR VPWR sky130_fd_sc_hd__fill_1
Xinput208 Tile_X0Y1_EE4END[11] VGND VGND VPWR VPWR net208 sky130_fd_sc_hd__buf_1
Xinput219 Tile_X0Y1_EE4END[7] VGND VGND VPWR VPWR net219 sky130_fd_sc_hd__buf_1
XTAP_TAPCELL_ROW_165_1030 VGND VPWR sky130_fd_sc_hd__tapvpwrvgnd_1
XFILLER_68_171 VGND VGND VPWR VPWR sky130_fd_sc_hd__decap_3
XFILLER_84_29 VGND VGND VPWR VPWR sky130_fd_sc_hd__decap_3
XFILLER_140_24 VGND VGND VPWR VPWR sky130_fd_sc_hd__decap_3
XFILLER_83_152 VGND VGND VPWR VPWR sky130_fd_sc_hd__decap_3
XFILLER_17_78 VGND VGND VPWR VPWR sky130_fd_sc_hd__decap_3
XFILLER_169_202 VGND VGND VPWR VPWR sky130_fd_sc_hd__decap_3
XFILLER_140_68 VGND VGND VPWR VPWR sky130_fd_sc_hd__decap_3
XFILLER_33_11 VGND VGND VPWR VPWR sky130_fd_sc_hd__decap_3
XTAP_TAPCELL_ROW_54_589 VGND VPWR sky130_fd_sc_hd__tapvpwrvgnd_1
XFILLER_149_22 VGND VGND VPWR VPWR sky130_fd_sc_hd__decap_3
XFILLER_33_66 VGND VGND VPWR VPWR sky130_fd_sc_hd__decap_3
XFILLER_149_66 VGND VGND VPWR VPWR sky130_fd_sc_hd__decap_3
XFILLER_137_110 VGND VGND VPWR VPWR sky130_fd_sc_hd__fill_2
XFILLER_137_132 VGND VGND VPWR VPWR sky130_fd_sc_hd__decap_3
XFILLER_165_21 VGND VGND VPWR VPWR sky130_fd_sc_hd__decap_3
XFILLER_152_124 VGND VGND VPWR VPWR sky130_fd_sc_hd__fill_2
XFILLER_137_187 VGND VGND VPWR VPWR sky130_fd_sc_hd__fill_1
XFILLER_137_165 VGND VGND VPWR VPWR sky130_fd_sc_hd__decap_3
XFILLER_3_134 VGND VGND VPWR VPWR sky130_fd_sc_hd__decap_3
XFILLER_165_98 VGND VGND VPWR VPWR sky130_fd_sc_hd__decap_3
XFILLER_3_178 VGND VGND VPWR VPWR sky130_fd_sc_hd__decap_3
XFILLER_74_141 VGND VGND VPWR VPWR sky130_fd_sc_hd__decap_3
XFILLER_114_91 VGND VGND VPWR VPWR sky130_fd_sc_hd__decap_3
XFILLER_74_40 VGND VGND VPWR VPWR sky130_fd_sc_hd__decap_3
XFILLER_74_163 VGND VGND VPWR VPWR sky130_fd_sc_hd__decap_3
XFILLER_30_200 VGND VGND VPWR VPWR sky130_fd_sc_hd__decap_3
XFILLER_175_205 VGND VGND VPWR VPWR sky130_fd_sc_hd__decap_3
XFILLER_88_6 VGND VGND VPWR VPWR sky130_fd_sc_hd__decap_3
XFILLER_128_121 VGND VGND VPWR VPWR sky130_fd_sc_hd__decap_3
XFILLER_90_83 VGND VGND VPWR VPWR sky130_fd_sc_hd__fill_1
XFILLER_143_113 VGND VGND VPWR VPWR sky130_fd_sc_hd__decap_3
XFILLER_128_165 VGND VGND VPWR VPWR sky130_fd_sc_hd__decap_3
X_0702_ net126 net334 VGND VGND VPWR VPWR Tile_X0Y0_OpenRAM_top.Inst_OpenRAM_top_ConfigMem.Inst_frame0_bit20.Q
+ sky130_fd_sc_hd__dlxtp_1
XFILLER_143_146 VGND VGND VPWR VPWR sky130_fd_sc_hd__decap_3
XFILLER_99_81 VGND VGND VPWR VPWR sky130_fd_sc_hd__decap_3
X_0633_ _0174_ _0176_ _0177_ Tile_X0Y1_OpenRAM_bot.Inst_OpenRAM_bot_ConfigMem.Inst_frame8_bit26.Q
+ VGND VGND VPWR VPWR Tile_X0Y0_OpenRAM_top.N4BEG_outbuf_8.A sky130_fd_sc_hd__o22a_1
XFILLER_97_222 VGND VGND VPWR VPWR sky130_fd_sc_hd__fill_2
X_0564_ net254 net357 _0091_ net170 Tile_X0Y1_OpenRAM_bot.Inst_OpenRAM_bot_ConfigMem.Inst_frame1_bit16.Q
+ Tile_X0Y1_OpenRAM_bot.Inst_OpenRAM_bot_ConfigMem.Inst_frame1_bit17.Q VGND VGND VPWR
+ VPWR _0152_ sky130_fd_sc_hd__mux4_2
X_0495_ _0132_ _0133_ _0134_ Tile_X0Y0_OpenRAM_top.Inst_OpenRAM_top_ConfigMem.Inst_frame6_bit9.Q
+ Tile_X0Y0_OpenRAM_top.Inst_OpenRAM_top_ConfigMem.Inst_frame6_bit10.Q VGND VGND VPWR
+ VPWR _0135_ sky130_fd_sc_hd__a221o_1
XFILLER_151_190 VGND VGND VPWR VPWR sky130_fd_sc_hd__decap_3
X_1116_ net223 net297 VGND VGND VPWR VPWR Tile_X0Y1_OpenRAM_bot.Inst_OpenRAM_bot_ConfigMem.Inst_frame4_bit10.Q
+ sky130_fd_sc_hd__dlxtp_1
XFILLER_65_152 VGND VGND VPWR VPWR sky130_fd_sc_hd__decap_3
XFILLER_65_185 VGND VGND VPWR VPWR sky130_fd_sc_hd__decap_3
X_1047_ net228 net314 VGND VGND VPWR VPWR Tile_X0Y1_OpenRAM_bot.Inst_OpenRAM_bot_ConfigMem.Inst_frame2_bit15.Q
+ sky130_fd_sc_hd__dlxtp_1
XFILLER_80_144 VGND VGND VPWR VPWR sky130_fd_sc_hd__decap_3
XFILLER_110_38 VGND VGND VPWR VPWR sky130_fd_sc_hd__decap_3
XFILLER_110_27 VGND VGND VPWR VPWR sky130_fd_sc_hd__fill_1
XFILLER_21_200 VGND VGND VPWR VPWR sky130_fd_sc_hd__decap_3
XTAP_TAPCELL_ROW_103_785 VGND VPWR sky130_fd_sc_hd__tapvpwrvgnd_1
XFILLER_166_227 VGND VGND VPWR VPWR sky130_fd_sc_hd__decap_3
XFILLER_119_110 VGND VGND VPWR VPWR sky130_fd_sc_hd__fill_2
XFILLER_9_90 VGND VGND VPWR VPWR sky130_fd_sc_hd__decap_3
XFILLER_181_219 VGND VGND VPWR VPWR sky130_fd_sc_hd__decap_3
XFILLER_134_113 VGND VGND VPWR VPWR sky130_fd_sc_hd__decap_3
XFILLER_119_165 VGND VGND VPWR VPWR sky130_fd_sc_hd__decap_3
XFILLER_119_198 VGND VGND VPWR VPWR sky130_fd_sc_hd__decap_3
XFILLER_135_35 VGND VGND VPWR VPWR sky130_fd_sc_hd__fill_1
XFILLER_135_57 VGND VGND VPWR VPWR sky130_fd_sc_hd__decap_3
XFILLER_48_108 VGND VGND VPWR VPWR sky130_fd_sc_hd__decap_3
XFILLER_95_17 VGND VGND VPWR VPWR sky130_fd_sc_hd__fill_1
XFILLER_95_39 VGND VGND VPWR VPWR sky130_fd_sc_hd__decap_3
XFILLER_56_141 VGND VGND VPWR VPWR sky130_fd_sc_hd__decap_3
XFILLER_151_78 VGND VGND VPWR VPWR sky130_fd_sc_hd__decap_3
XTAP_TAPCELL_ROW_126_877 VGND VPWR sky130_fd_sc_hd__tapvpwrvgnd_1
XFILLER_44_32 VGND VGND VPWR VPWR sky130_fd_sc_hd__decap_3
XFILLER_157_205 VGND VGND VPWR VPWR sky130_fd_sc_hd__decap_3
XFILLER_100_82 VGND VGND VPWR VPWR sky130_fd_sc_hd__fill_2
XFILLER_8_215 VGND VGND VPWR VPWR sky130_fd_sc_hd__decap_3
XTAP_TAPCELL_ROW_10_412 VGND VPWR sky130_fd_sc_hd__tapvpwrvgnd_1
XTAP_TAPCELL_ROW_50_570 VGND VPWR sky130_fd_sc_hd__tapvpwrvgnd_1
XFILLER_60_64 VGND VGND VPWR VPWR sky130_fd_sc_hd__decap_3
XFILLER_176_53 VGND VGND VPWR VPWR sky130_fd_sc_hd__decap_3
XFILLER_125_113 VGND VGND VPWR VPWR sky130_fd_sc_hd__decap_3
XFILLER_125_102 VGND VGND VPWR VPWR sky130_fd_sc_hd__decap_3
XFILLER_176_97 VGND VGND VPWR VPWR sky130_fd_sc_hd__decap_3
XFILLER_5_15 VGND VGND VPWR VPWR sky130_fd_sc_hd__decap_3
XFILLER_109_91 VGND VGND VPWR VPWR sky130_fd_sc_hd__decap_3
XFILLER_5_48 VGND VGND VPWR VPWR sky130_fd_sc_hd__decap_3
XFILLER_69_40 VGND VGND VPWR VPWR sky130_fd_sc_hd__fill_2
XFILLER_79_211 VGND VGND VPWR VPWR sky130_fd_sc_hd__decap_3
XFILLER_133_190 VGND VGND VPWR VPWR sky130_fd_sc_hd__decap_3
XTAP_TAPCELL_ROW_149_969 VGND VPWR sky130_fd_sc_hd__tapvpwrvgnd_1
X_0280_ net160 Tile_X0Y1_OpenRAM_bot.Inst_OpenRAM_bot_ConfigMem.Inst_frame2_bit30.Q
+ VGND VGND VPWR VPWR _0049_ sky130_fd_sc_hd__nand2b_1
XPHY_EDGE_ROW_13_Right_13 VGND VGND VPWR VPWR sky130_fd_sc_hd__decap_3
XFILLER_85_72 VGND VGND VPWR VPWR sky130_fd_sc_hd__decap_3
XFILLER_47_196 VGND VGND VPWR VPWR sky130_fd_sc_hd__decap_3
XFILLER_62_100 VGND VGND VPWR VPWR sky130_fd_sc_hd__fill_1
XFILLER_62_122 VGND VGND VPWR VPWR sky130_fd_sc_hd__decap_3
XTAP_TAPCELL_ROW_73_662 VGND VPWR sky130_fd_sc_hd__tapvpwrvgnd_1
XTAP_TAPCELL_ROW_33_504 VGND VPWR sky130_fd_sc_hd__tapvpwrvgnd_1
XFILLER_62_177 VGND VGND VPWR VPWR sky130_fd_sc_hd__decap_3
XFILLER_86_3 VGND VGND VPWR VPWR sky130_fd_sc_hd__decap_3
XFILLER_163_208 VGND VGND VPWR VPWR sky130_fd_sc_hd__decap_3
XPHY_EDGE_ROW_22_Right_22 VGND VGND VPWR VPWR sky130_fd_sc_hd__decap_3
XFILLER_131_105 VGND VGND VPWR VPWR sky130_fd_sc_hd__decap_3
X_0616_ net186 Tile_X0Y1_OpenRAM_bot.Inst_OpenRAM_bot_ConfigMem.Inst_frame1_bit0.Q
+ Tile_X0Y1_OpenRAM_bot.Inst_OpenRAM_bot_ConfigMem.Inst_frame1_bit1.Q VGND VGND VPWR
+ VPWR _0165_ sky130_fd_sc_hd__o21ba_1
X_0547_ net3 net35 Tile_X0Y1_OpenRAM_bot.Inst_OpenRAM_bot_switch_matrix.J_NS4_BEG14
+ _0086_ Tile_X0Y1_OpenRAM_bot.Inst_OpenRAM_bot_ConfigMem.Inst_frame5_bit18.Q Tile_X0Y1_OpenRAM_bot.Inst_OpenRAM_bot_ConfigMem.Inst_frame5_bit19.Q
+ VGND VGND VPWR VPWR Tile_X0Y1_OpenRAM_bot.Inst_OpenRAM_bot_switch_matrix.WW4BEG1
+ sky130_fd_sc_hd__mux4_1
XFILLER_105_27 VGND VGND VPWR VPWR sky130_fd_sc_hd__decap_3
XPHY_EDGE_ROW_31_Right_31 VGND VGND VPWR VPWR sky130_fd_sc_hd__decap_3
XFILLER_85_214 VGND VGND VPWR VPWR sky130_fd_sc_hd__decap_3
XFILLER_85_225 VGND VGND VPWR VPWR sky130_fd_sc_hd__decap_3
X_0478_ net97 Tile_X0Y0_OpenRAM_top.Inst_OpenRAM_top_switch_matrix.J_NS4_BEG1 Tile_X0Y0_OpenRAM_top.Inst_OpenRAM_top_ConfigMem.Inst_frame7_bit7.Q
+ VGND VGND VPWR VPWR _0121_ sky130_fd_sc_hd__mux2_1
XTAP_TAPCELL_ROW_96_754 VGND VPWR sky130_fd_sc_hd__tapvpwrvgnd_1
XFILLER_38_141 VGND VGND VPWR VPWR sky130_fd_sc_hd__decap_3
XFILLER_121_48 VGND VGND VPWR VPWR sky130_fd_sc_hd__decap_3
XFILLER_53_166 VGND VGND VPWR VPWR sky130_fd_sc_hd__fill_2
XFILLER_53_199 VGND VGND VPWR VPWR sky130_fd_sc_hd__decap_3
XFILLER_14_24 VGND VGND VPWR VPWR sky130_fd_sc_hd__decap_3
XFILLER_139_216 VGND VGND VPWR VPWR sky130_fd_sc_hd__decap_3
XPHY_EDGE_ROW_40_Right_40 VGND VGND VPWR VPWR sky130_fd_sc_hd__decap_3
XFILLER_14_79 VGND VGND VPWR VPWR sky130_fd_sc_hd__fill_2
XFILLER_30_56 VGND VGND VPWR VPWR sky130_fd_sc_hd__decap_3
XFILLER_122_127 VGND VGND VPWR VPWR sky130_fd_sc_hd__decap_3
XFILLER_162_44 VGND VGND VPWR VPWR sky130_fd_sc_hd__decap_3
XTAP_TAPCELL_ROW_87_721 VGND VPWR sky130_fd_sc_hd__tapvpwrvgnd_1
XFILLER_162_77 VGND VGND VPWR VPWR sky130_fd_sc_hd__decap_3
XFILLER_39_87 VGND VGND VPWR VPWR sky130_fd_sc_hd__decap_3
XFILLER_162_88 VGND VGND VPWR VPWR sky130_fd_sc_hd__decap_3
XFILLER_29_163 VGND VGND VPWR VPWR sky130_fd_sc_hd__decap_3
XFILLER_91_217 VGND VGND VPWR VPWR sky130_fd_sc_hd__decap_3
XFILLER_44_100 VGND VGND VPWR VPWR sky130_fd_sc_hd__decap_3
XFILLER_91_228 VGND VGND VPWR VPWR sky130_fd_sc_hd__fill_2
XFILLER_44_133 VGND VGND VPWR VPWR sky130_fd_sc_hd__decap_3
XFILLER_55_86 VGND VGND VPWR VPWR sky130_fd_sc_hd__decap_3
XFILLER_111_81 VGND VGND VPWR VPWR sky130_fd_sc_hd__decap_3
XFILLER_71_30 VGND VGND VPWR VPWR sky130_fd_sc_hd__decap_3
XFILLER_71_63 VGND VGND VPWR VPWR sky130_fd_sc_hd__decap_3
XTAP_TAPCELL_ROW_178_1084 VGND VPWR sky130_fd_sc_hd__tapvpwrvgnd_1
XFILLER_71_85 VGND VGND VPWR VPWR sky130_fd_sc_hd__decap_3
XFILLER_145_219 VGND VGND VPWR VPWR sky130_fd_sc_hd__decap_3
Xoutput309 net392 VGND VGND VPWR VPWR DIN_A_SRAM15 sky130_fd_sc_hd__buf_2
X_1450_ Tile_X0Y0_S4END[12] VGND VGND VPWR VPWR net616 sky130_fd_sc_hd__buf_6
XFILLER_113_116 VGND VGND VPWR VPWR sky130_fd_sc_hd__decap_3
X_1381_ Tile_X0Y0_OpenRAM_top.Inst_OpenRAM_top_switch_matrix.WW4BEG3 VGND VGND VPWR
+ VPWR net547 sky130_fd_sc_hd__buf_1
XFILLER_113_149 VGND VGND VPWR VPWR sky130_fd_sc_hd__decap_3
X_0401_ Tile_X0Y0_OpenRAM_top.Inst_OpenRAM_top_switch_matrix.N1END2 net363 net148
+ net168 Tile_X0Y0_OpenRAM_top.Inst_OpenRAM_top_ConfigMem.Inst_frame1_bit20.Q Tile_X0Y0_OpenRAM_top.Inst_OpenRAM_top_ConfigMem.Inst_frame1_bit21.Q
+ VGND VGND VPWR VPWR Tile_X0Y0_OpenRAM_top.Inst_OpenRAM_top_switch_matrix.J_NS4_BEG6
+ sky130_fd_sc_hd__mux4_2
X_0332_ net83 net75 net93 Tile_X0Y0_OpenRAM_top.Inst_OpenRAM_top_switch_matrix.J_NS2_BEG2
+ Tile_X0Y0_OpenRAM_top.Inst_OpenRAM_top_ConfigMem.Inst_frame8_bit24.Q Tile_X0Y0_OpenRAM_top.Inst_OpenRAM_top_ConfigMem.Inst_frame8_bit25.Q
+ VGND VGND VPWR VPWR Tile_X0Y0_OpenRAM_top.Inst_OpenRAM_top_switch_matrix.N2BEG2
+ sky130_fd_sc_hd__mux4_1
XFILLER_67_225 VGND VGND VPWR VPWR sky130_fd_sc_hd__fill_1
XFILLER_121_193 VGND VGND VPWR VPWR sky130_fd_sc_hd__decap_3
XFILLER_96_82 VGND VGND VPWR VPWR sky130_fd_sc_hd__fill_2
XFILLER_82_217 VGND VGND VPWR VPWR sky130_fd_sc_hd__decap_3
X_0263_ Tile_X0Y1_OpenRAM_bot.Inst_OpenRAM_bot_ConfigMem.Inst_frame3_bit9.Q _0032_
+ _0031_ VGND VGND VPWR VPWR _0033_ sky130_fd_sc_hd__o21a_1
XTAP_TAPCELL_ROW_145_950 VGND VPWR sky130_fd_sc_hd__tapvpwrvgnd_1
XFILLER_35_111 VGND VGND VPWR VPWR sky130_fd_sc_hd__fill_1
XFILLER_35_122 VGND VGND VPWR VPWR sky130_fd_sc_hd__decap_3
XFILLER_35_155 VGND VGND VPWR VPWR sky130_fd_sc_hd__decap_3
XFILLER_50_103 VGND VGND VPWR VPWR sky130_fd_sc_hd__decap_3
XPHY_EDGE_ROW_11_Left_194 VGND VGND VPWR VPWR sky130_fd_sc_hd__decap_3
XFILLER_50_147 VGND VGND VPWR VPWR sky130_fd_sc_hd__decap_3
XFILLER_104_116 VGND VGND VPWR VPWR sky130_fd_sc_hd__decap_3
XFILLER_6_91 VGND VGND VPWR VPWR sky130_fd_sc_hd__decap_3
XFILLER_6_80 VGND VGND VPWR VPWR sky130_fd_sc_hd__decap_3
XFILLER_58_203 VGND VGND VPWR VPWR sky130_fd_sc_hd__decap_3
XFILLER_112_171 VGND VGND VPWR VPWR sky130_fd_sc_hd__decap_3
XFILLER_73_206 VGND VGND VPWR VPWR sky130_fd_sc_hd__decap_3
XFILLER_132_47 VGND VGND VPWR VPWR sky130_fd_sc_hd__decap_3
XFILLER_26_100 VGND VGND VPWR VPWR sky130_fd_sc_hd__fill_1
XFILLER_92_18 VGND VGND VPWR VPWR sky130_fd_sc_hd__decap_3
XFILLER_26_122 VGND VGND VPWR VPWR sky130_fd_sc_hd__decap_3
XFILLER_26_133 VGND VGND VPWR VPWR sky130_fd_sc_hd__decap_3
XFILLER_26_144 VGND VGND VPWR VPWR sky130_fd_sc_hd__decap_3
XFILLER_92_29 VGND VGND VPWR VPWR sky130_fd_sc_hd__decap_3
XTAP_TAPCELL_ROW_151_975 VGND VPWR sky130_fd_sc_hd__tapvpwrvgnd_1
XFILLER_25_45 VGND VGND VPWR VPWR sky130_fd_sc_hd__decap_3
XFILLER_26_177 VGND VGND VPWR VPWR sky130_fd_sc_hd__decap_3
XTAP_TAPCELL_ROW_111_817 VGND VPWR sky130_fd_sc_hd__tapvpwrvgnd_1
XFILLER_41_125 VGND VGND VPWR VPWR sky130_fd_sc_hd__decap_3
XFILLER_41_158 VGND VGND VPWR VPWR sky130_fd_sc_hd__decap_3
XFILLER_41_169 VGND VGND VPWR VPWR sky130_fd_sc_hd__decap_3
XFILLER_41_44 VGND VGND VPWR VPWR sky130_fd_sc_hd__decap_3
XFILLER_41_66 VGND VGND VPWR VPWR sky130_fd_sc_hd__decap_3
XPHY_EDGE_ROW_157_Right_157 VGND VGND VPWR VPWR sky130_fd_sc_hd__decap_3
XFILLER_157_66 VGND VGND VPWR VPWR sky130_fd_sc_hd__decap_3
XFILLER_157_99 VGND VGND VPWR VPWR sky130_fd_sc_hd__fill_1
XFILLER_150_200 VGND VGND VPWR VPWR sky130_fd_sc_hd__decap_3
XFILLER_173_21 VGND VGND VPWR VPWR sky130_fd_sc_hd__decap_3
XFILLER_173_87 VGND VGND VPWR VPWR sky130_fd_sc_hd__decap_3
XFILLER_173_54 VGND VGND VPWR VPWR sky130_fd_sc_hd__fill_2
XFILLER_110_108 VGND VGND VPWR VPWR sky130_fd_sc_hd__fill_2
XFILLER_49_203 VGND VGND VPWR VPWR sky130_fd_sc_hd__fill_1
XFILLER_103_193 VGND VGND VPWR VPWR sky130_fd_sc_hd__decap_3
XFILLER_2_27 VGND VGND VPWR VPWR sky130_fd_sc_hd__fill_1
XFILLER_49_225 VGND VGND VPWR VPWR sky130_fd_sc_hd__fill_1
XFILLER_64_206 VGND VGND VPWR VPWR sky130_fd_sc_hd__decap_3
XFILLER_66_41 VGND VGND VPWR VPWR sky130_fd_sc_hd__decap_3
XTAP_TAPCELL_ROW_134_909 VGND VPWR sky130_fd_sc_hd__tapvpwrvgnd_1
XFILLER_17_111 VGND VGND VPWR VPWR sky130_fd_sc_hd__fill_1
XFILLER_17_122 VGND VGND VPWR VPWR sky130_fd_sc_hd__decap_3
XFILLER_122_91 VGND VGND VPWR VPWR sky130_fd_sc_hd__decap_3
XFILLER_122_80 VGND VGND VPWR VPWR sky130_fd_sc_hd__decap_3
XFILLER_32_103 VGND VGND VPWR VPWR sky130_fd_sc_hd__decap_3
XFILLER_32_136 VGND VGND VPWR VPWR sky130_fd_sc_hd__decap_3
XFILLER_32_147 VGND VGND VPWR VPWR sky130_fd_sc_hd__decap_3
XFILLER_82_73 VGND VGND VPWR VPWR sky130_fd_sc_hd__decap_3
XFILLER_177_119 VGND VGND VPWR VPWR sky130_fd_sc_hd__decap_3
X_0950_ net134 net268 VGND VGND VPWR VPWR Tile_X0Y0_OpenRAM_top.Inst_OpenRAM_top_ConfigMem.Inst_frame8_bit28.Q
+ sky130_fd_sc_hd__dlxtp_1
XFILLER_40_180 VGND VGND VPWR VPWR sky130_fd_sc_hd__fill_2
X_0881_ net125 net291 VGND VGND VPWR VPWR Tile_X0Y0_OpenRAM_top.Inst_OpenRAM_top_ConfigMem.Inst_frame5_bit1.Q
+ sky130_fd_sc_hd__dlxtp_1
XPHY_EDGE_ROW_124_Right_124 VGND VGND VPWR VPWR sky130_fd_sc_hd__decap_3
XFILLER_141_222 VGND VGND VPWR VPWR sky130_fd_sc_hd__fill_2
XFILLER_99_125 VGND VGND VPWR VPWR sky130_fd_sc_hd__decap_3
X_1502_ Tile_X0Y1_OpenRAM_bot.Inst_OpenRAM_bot_switch_matrix.WW4BEG8 VGND VGND VPWR
+ VPWR net668 sky130_fd_sc_hd__clkbuf_1
XFILLER_99_169 VGND VGND VPWR VPWR sky130_fd_sc_hd__decap_3
XFILLER_49_3 VGND VGND VPWR VPWR sky130_fd_sc_hd__fill_1
X_1433_ Tile_X0Y1_OpenRAM_bot.Inst_OpenRAM_bot_switch_matrix.S2BEG3 VGND VGND VPWR
+ VPWR net593 sky130_fd_sc_hd__clkbuf_2
X_1364_ Tile_X0Y0_OpenRAM_top.Inst_OpenRAM_top_switch_matrix.W2BEGb6 VGND VGND VPWR
+ VPWR net524 sky130_fd_sc_hd__buf_1
X_1295_ net284 VGND VGND VPWR VPWR net465 sky130_fd_sc_hd__clkbuf_1
X_0315_ net69 net88 Tile_X0Y0_OpenRAM_top.Inst_OpenRAM_top_switch_matrix.J_NS4_BEG15
+ _0076_ Tile_X0Y0_OpenRAM_top.Inst_OpenRAM_top_ConfigMem.Inst_frame7_bit22.Q Tile_X0Y0_OpenRAM_top.Inst_OpenRAM_top_ConfigMem.Inst_frame7_bit23.Q
+ VGND VGND VPWR VPWR _0077_ sky130_fd_sc_hd__mux4_2
XFILLER_55_228 VGND VGND VPWR VPWR sky130_fd_sc_hd__decap_3
X_0246_ Tile_X0Y1_OpenRAM_bot.Inst_OpenRAM_bot_ConfigMem.Inst_frame0_bit26.Q VGND
+ VGND VPWR VPWR _0019_ sky130_fd_sc_hd__inv_2
XFILLER_70_209 VGND VGND VPWR VPWR sky130_fd_sc_hd__decap_3
XFILLER_23_125 VGND VGND VPWR VPWR sky130_fd_sc_hd__decap_3
XFILLER_176_141 VGND VGND VPWR VPWR sky130_fd_sc_hd__decap_3
XFILLER_176_130 VGND VGND VPWR VPWR sky130_fd_sc_hd__decap_3
XFILLER_176_174 VGND VGND VPWR VPWR sky130_fd_sc_hd__decap_3
XFILLER_109_219 VGND VGND VPWR VPWR sky130_fd_sc_hd__decap_3
XFILLER_127_25 VGND VGND VPWR VPWR sky130_fd_sc_hd__decap_3
XFILLER_11_25 VGND VGND VPWR VPWR sky130_fd_sc_hd__decap_3
XFILLER_132_200 VGND VGND VPWR VPWR sky130_fd_sc_hd__decap_3
XFILLER_11_69 VGND VGND VPWR VPWR sky130_fd_sc_hd__decap_3
XFILLER_127_69 VGND VGND VPWR VPWR sky130_fd_sc_hd__fill_2
XFILLER_2_9 VGND VGND VPWR VPWR sky130_fd_sc_hd__decap_3
XFILLER_87_18 VGND VGND VPWR VPWR sky130_fd_sc_hd__decap_3
Xfanout300 net301 VGND VGND VPWR VPWR net300 sky130_fd_sc_hd__buf_2
Xfanout322 net324 VGND VGND VPWR VPWR net322 sky130_fd_sc_hd__clkbuf_2
Xfanout311 Tile_X0Y1_FrameStrobe[3] VGND VGND VPWR VPWR net311 sky130_fd_sc_hd__buf_2
XFILLER_98_180 VGND VGND VPWR VPWR sky130_fd_sc_hd__decap_3
Xfanout333 Tile_X0Y1_FrameStrobe[0] VGND VGND VPWR VPWR net333 sky130_fd_sc_hd__dlymetal6s2s_1
XFILLER_100_141 VGND VGND VPWR VPWR sky130_fd_sc_hd__decap_3
XFILLER_100_130 VGND VGND VPWR VPWR sky130_fd_sc_hd__decap_3
XFILLER_46_206 VGND VGND VPWR VPWR sky130_fd_sc_hd__decap_3
XFILLER_36_22 VGND VGND VPWR VPWR sky130_fd_sc_hd__decap_3
XFILLER_36_44 VGND VGND VPWR VPWR sky130_fd_sc_hd__decap_3
XFILLER_14_103 VGND VGND VPWR VPWR sky130_fd_sc_hd__fill_1
XFILLER_36_88 VGND VGND VPWR VPWR sky130_fd_sc_hd__decap_3
XFILLER_159_108 VGND VGND VPWR VPWR sky130_fd_sc_hd__decap_3
XFILLER_14_125 VGND VGND VPWR VPWR sky130_fd_sc_hd__decap_3
XFILLER_14_147 VGND VGND VPWR VPWR sky130_fd_sc_hd__decap_3
XFILLER_168_32 VGND VGND VPWR VPWR sky130_fd_sc_hd__decap_3
XFILLER_168_21 VGND VGND VPWR VPWR sky130_fd_sc_hd__decap_3
XFILLER_168_65 VGND VGND VPWR VPWR sky130_fd_sc_hd__decap_3
Xinput19 DOUT_A_SRAM24 VGND VGND VPWR VPWR net19 sky130_fd_sc_hd__clkbuf_2
XFILLER_167_196 VGND VGND VPWR VPWR sky130_fd_sc_hd__decap_3
XFILLER_123_211 VGND VGND VPWR VPWR sky130_fd_sc_hd__decap_3
XFILLER_77_51 VGND VGND VPWR VPWR sky130_fd_sc_hd__decap_3
XFILLER_89_191 VGND VGND VPWR VPWR sky130_fd_sc_hd__decap_3
XTAP_TAPCELL_ROW_5_390 VGND VPWR sky130_fd_sc_hd__tapvpwrvgnd_1
XFILLER_37_217 VGND VGND VPWR VPWR sky130_fd_sc_hd__decap_3
X_1080_ net227 net306 VGND VGND VPWR VPWR Tile_X0Y1_OpenRAM_bot.Inst_OpenRAM_bot_ConfigMem.Inst_frame3_bit14.Q
+ sky130_fd_sc_hd__dlxtp_1
XFILLER_93_83 VGND VGND VPWR VPWR sky130_fd_sc_hd__decap_3
XFILLER_20_128 VGND VGND VPWR VPWR sky130_fd_sc_hd__decap_3
XFILLER_158_141 VGND VGND VPWR VPWR sky130_fd_sc_hd__decap_3
X_0933_ net118 net274 VGND VGND VPWR VPWR Tile_X0Y0_OpenRAM_top.Inst_OpenRAM_top_ConfigMem.Inst_frame7_bit13.Q
+ sky130_fd_sc_hd__dlxtp_1
XFILLER_9_140 VGND VGND VPWR VPWR sky130_fd_sc_hd__decap_3
XFILLER_173_122 VGND VGND VPWR VPWR sky130_fd_sc_hd__decap_3
XFILLER_173_111 VGND VGND VPWR VPWR sky130_fd_sc_hd__fill_1
X_0864_ net123 net293 VGND VGND VPWR VPWR Tile_X0Y0_OpenRAM_top.Inst_OpenRAM_top_ConfigMem.Inst_frame5_bit18.Q
+ sky130_fd_sc_hd__dlxtp_1
XFILLER_9_184 VGND VGND VPWR VPWR sky130_fd_sc_hd__decap_3
XFILLER_173_155 VGND VGND VPWR VPWR sky130_fd_sc_hd__decap_3
XFILLER_173_199 VGND VGND VPWR VPWR sky130_fd_sc_hd__decap_3
X_0795_ net129 net309 VGND VGND VPWR VPWR Tile_X0Y0_OpenRAM_top.Inst_OpenRAM_top_ConfigMem.Inst_frame3_bit23.Q
+ sky130_fd_sc_hd__dlxtp_1
X_1416_ net236 VGND VGND VPWR VPWR net568 sky130_fd_sc_hd__buf_4
XFILLER_87_139 VGND VGND VPWR VPWR sky130_fd_sc_hd__decap_3
X_1347_ Tile_X0Y0_OpenRAM_top.Inst_OpenRAM_top_switch_matrix.W1BEG1 VGND VGND VPWR
+ VPWR net507 sky130_fd_sc_hd__clkbuf_1
XFILLER_3_81 VGND VGND VPWR VPWR sky130_fd_sc_hd__decap_3
XFILLER_95_150 VGND VGND VPWR VPWR sky130_fd_sc_hd__decap_3
XFILLER_113_27 VGND VGND VPWR VPWR sky130_fd_sc_hd__decap_3
XFILLER_95_172 VGND VGND VPWR VPWR sky130_fd_sc_hd__fill_1
X_1278_ net127 VGND VGND VPWR VPWR net430 sky130_fd_sc_hd__buf_1
XFILLER_113_49 VGND VGND VPWR VPWR sky130_fd_sc_hd__decap_3
XFILLER_95_194 VGND VGND VPWR VPWR sky130_fd_sc_hd__decap_3
X_0229_ Tile_X0Y0_OpenRAM_top.Inst_OpenRAM_top_ConfigMem.Inst_frame0_bit27.Q VGND
+ VGND VPWR VPWR _0002_ sky130_fd_sc_hd__inv_1
XFILLER_11_128 VGND VGND VPWR VPWR sky130_fd_sc_hd__decap_3
XFILLER_149_152 VGND VGND VPWR VPWR sky130_fd_sc_hd__decap_3
XFILLER_22_46 VGND VGND VPWR VPWR sky130_fd_sc_hd__decap_3
XFILLER_164_144 VGND VGND VPWR VPWR sky130_fd_sc_hd__decap_3
XFILLER_164_133 VGND VGND VPWR VPWR sky130_fd_sc_hd__decap_3
XFILLER_138_35 VGND VGND VPWR VPWR sky130_fd_sc_hd__decap_3
XFILLER_22_79 VGND VGND VPWR VPWR sky130_fd_sc_hd__decap_3
XFILLER_0_6 VGND VGND VPWR VPWR sky130_fd_sc_hd__decap_3
XFILLER_154_23 VGND VGND VPWR VPWR sky130_fd_sc_hd__decap_3
Xoutput470 net553 VGND VGND VPWR VPWR Tile_X0Y0_WW4BEG[9] sky130_fd_sc_hd__buf_2
XFILLER_120_203 VGND VGND VPWR VPWR sky130_fd_sc_hd__decap_3
XFILLER_78_117 VGND VGND VPWR VPWR sky130_fd_sc_hd__decap_3
Xoutput492 net575 VGND VGND VPWR VPWR Tile_X0Y1_FrameData_O[29] sky130_fd_sc_hd__buf_2
Xoutput481 net564 VGND VGND VPWR VPWR Tile_X0Y1_FrameData_O[19] sky130_fd_sc_hd__buf_2
XFILLER_19_228 VGND VGND VPWR VPWR sky130_fd_sc_hd__fill_2
XFILLER_19_217 VGND VGND VPWR VPWR sky130_fd_sc_hd__decap_3
XFILLER_47_43 VGND VGND VPWR VPWR sky130_fd_sc_hd__decap_3
XFILLER_86_183 VGND VGND VPWR VPWR sky130_fd_sc_hd__decap_3
XFILLER_170_44 VGND VGND VPWR VPWR sky130_fd_sc_hd__decap_3
XFILLER_170_88 VGND VGND VPWR VPWR sky130_fd_sc_hd__decap_3
XFILLER_170_77 VGND VGND VPWR VPWR sky130_fd_sc_hd__decap_3
XFILLER_103_60 VGND VGND VPWR VPWR sky130_fd_sc_hd__decap_3
XFILLER_34_209 VGND VGND VPWR VPWR sky130_fd_sc_hd__fill_2
XTAP_TAPCELL_ROW_57_598 VGND VPWR sky130_fd_sc_hd__tapvpwrvgnd_1
XFILLER_179_42 VGND VGND VPWR VPWR sky130_fd_sc_hd__decap_3
XPHY_EDGE_ROW_69_Right_69 VGND VGND VPWR VPWR sky130_fd_sc_hd__decap_3
XFILLER_179_75 VGND VGND VPWR VPWR sky130_fd_sc_hd__decap_3
XFILLER_8_15 VGND VGND VPWR VPWR sky130_fd_sc_hd__decap_3
XTAP_TAPCELL_ROW_25_473 VGND VPWR sky130_fd_sc_hd__tapvpwrvgnd_1
XFILLER_63_97 VGND VGND VPWR VPWR sky130_fd_sc_hd__fill_1
XFILLER_155_122 VGND VGND VPWR VPWR sky130_fd_sc_hd__decap_3
XFILLER_155_111 VGND VGND VPWR VPWR sky130_fd_sc_hd__fill_1
XFILLER_10_150 VGND VGND VPWR VPWR sky130_fd_sc_hd__decap_3
XFILLER_8_59 VGND VGND VPWR VPWR sky130_fd_sc_hd__decap_3
XFILLER_155_155 VGND VGND VPWR VPWR sky130_fd_sc_hd__decap_3
XFILLER_6_121 VGND VGND VPWR VPWR sky130_fd_sc_hd__decap_3
XFILLER_170_103 VGND VGND VPWR VPWR sky130_fd_sc_hd__decap_3
XFILLER_155_199 VGND VGND VPWR VPWR sky130_fd_sc_hd__decap_3
XFILLER_6_165 VGND VGND VPWR VPWR sky130_fd_sc_hd__decap_3
XFILLER_170_147 VGND VGND VPWR VPWR sky130_fd_sc_hd__decap_3
XFILLER_170_136 VGND VGND VPWR VPWR sky130_fd_sc_hd__decap_3
X_0580_ net30 _0147_ _0151_ net261 Tile_X0Y1_OpenRAM_bot.Inst_OpenRAM_bot_ConfigMem.Inst_frame4_bit29.Q
+ Tile_X0Y1_OpenRAM_bot.Inst_OpenRAM_bot_ConfigMem.Inst_frame4_bit28.Q VGND VGND VPWR
+ VPWR Tile_X0Y1_OpenRAM_bot.Inst_OpenRAM_bot_switch_matrix.W6BEG6 sky130_fd_sc_hd__mux4_1
XPHY_EDGE_ROW_78_Right_78 VGND VGND VPWR VPWR sky130_fd_sc_hd__decap_3
XFILLER_69_106 VGND VGND VPWR VPWR sky130_fd_sc_hd__decap_3
XFILLER_88_50 VGND VGND VPWR VPWR sky130_fd_sc_hd__decap_3
XFILLER_111_225 VGND VGND VPWR VPWR sky130_fd_sc_hd__fill_2
XFILLER_88_83 VGND VGND VPWR VPWR sky130_fd_sc_hd__fill_1
XFILLER_88_94 VGND VGND VPWR VPWR sky130_fd_sc_hd__decap_3
X_1201_ net235 net270 VGND VGND VPWR VPWR Tile_X0Y1_OpenRAM_bot.Inst_OpenRAM_bot_ConfigMem.Inst_frame7_bit21.Q
+ sky130_fd_sc_hd__dlxtp_1
XFILLER_77_150 VGND VGND VPWR VPWR sky130_fd_sc_hd__fill_2
X_1132_ net240 net288 VGND VGND VPWR VPWR Tile_X0Y1_OpenRAM_bot.Inst_OpenRAM_bot_ConfigMem.Inst_frame5_bit26.Q
+ sky130_fd_sc_hd__dlxtp_1
XTAP_TAPCELL_ROW_48_565 VGND VPWR sky130_fd_sc_hd__tapvpwrvgnd_1
X_1063_ net246 net304 VGND VGND VPWR VPWR Tile_X0Y1_OpenRAM_bot.Inst_OpenRAM_bot_ConfigMem.Inst_frame3_bit31.Q
+ sky130_fd_sc_hd__dlxtp_1
XFILLER_92_153 VGND VGND VPWR VPWR sky130_fd_sc_hd__decap_3
XFILLER_33_220 VGND VGND VPWR VPWR sky130_fd_sc_hd__decap_3
XPHY_EDGE_ROW_87_Right_87 VGND VGND VPWR VPWR sky130_fd_sc_hd__decap_3
XFILLER_92_186 VGND VGND VPWR VPWR sky130_fd_sc_hd__decap_3
XFILLER_92_197 VGND VGND VPWR VPWR sky130_fd_sc_hd__decap_3
XFILLER_178_203 VGND VGND VPWR VPWR sky130_fd_sc_hd__decap_3
X_0916_ net137 net274 VGND VGND VPWR VPWR Tile_X0Y0_OpenRAM_top.Inst_OpenRAM_top_ConfigMem.Inst_frame7_bit30.Q
+ sky130_fd_sc_hd__dlxtp_1
X_0847_ net139 net300 VGND VGND VPWR VPWR Tile_X0Y0_OpenRAM_top.Inst_OpenRAM_top_ConfigMem.Inst_frame4_bit3.Q
+ sky130_fd_sc_hd__dlxtp_1
XPHY_EDGE_ROW_96_Right_96 VGND VGND VPWR VPWR sky130_fd_sc_hd__decap_3
XFILLER_161_125 VGND VGND VPWR VPWR sky130_fd_sc_hd__decap_3
X_0778_ net144 net320 VGND VGND VPWR VPWR Tile_X0Y0_OpenRAM_top.Inst_OpenRAM_top_ConfigMem.Inst_frame2_bit8.Q
+ sky130_fd_sc_hd__dlxtp_1
XFILLER_161_169 VGND VGND VPWR VPWR sky130_fd_sc_hd__decap_3
Xinput209 Tile_X0Y1_EE4END[12] VGND VGND VPWR VPWR net209 sky130_fd_sc_hd__buf_1
XFILLER_124_15 VGND VGND VPWR VPWR sky130_fd_sc_hd__decap_3
XTAP_TAPCELL_ROW_165_1031 VGND VPWR sky130_fd_sc_hd__tapvpwrvgnd_1
XFILLER_124_59 VGND VGND VPWR VPWR sky130_fd_sc_hd__decap_3
XFILLER_68_150 VGND VGND VPWR VPWR sky130_fd_sc_hd__decap_3
XFILLER_68_183 VGND VGND VPWR VPWR sky130_fd_sc_hd__decap_3
XFILLER_83_131 VGND VGND VPWR VPWR sky130_fd_sc_hd__decap_3
XPHY_EDGE_ROW_3_Left_186 VGND VGND VPWR VPWR sky130_fd_sc_hd__decap_3
XFILLER_83_164 VGND VGND VPWR VPWR sky130_fd_sc_hd__decap_3
XFILLER_17_57 VGND VGND VPWR VPWR sky130_fd_sc_hd__decap_3
XFILLER_169_214 VGND VGND VPWR VPWR sky130_fd_sc_hd__decap_3
XTAP_TAPCELL_ROW_106_794 VGND VPWR sky130_fd_sc_hd__tapvpwrvgnd_1
XFILLER_169_225 VGND VGND VPWR VPWR sky130_fd_sc_hd__decap_3
XFILLER_149_34 VGND VGND VPWR VPWR sky130_fd_sc_hd__decap_3
XFILLER_33_78 VGND VGND VPWR VPWR sky130_fd_sc_hd__decap_3
XFILLER_137_144 VGND VGND VPWR VPWR sky130_fd_sc_hd__decap_3
XFILLER_3_102 VGND VGND VPWR VPWR sky130_fd_sc_hd__decap_3
XFILLER_165_33 VGND VGND VPWR VPWR sky130_fd_sc_hd__decap_3
XFILLER_3_113 VGND VGND VPWR VPWR sky130_fd_sc_hd__decap_3
XFILLER_165_77 VGND VGND VPWR VPWR sky130_fd_sc_hd__decap_3
XFILLER_3_146 VGND VGND VPWR VPWR sky130_fd_sc_hd__decap_3
XFILLER_160_180 VGND VGND VPWR VPWR sky130_fd_sc_hd__decap_3
XFILLER_181_21 VGND VGND VPWR VPWR sky130_fd_sc_hd__decap_3
XFILLER_58_75 VGND VGND VPWR VPWR sky130_fd_sc_hd__fill_1
XFILLER_58_97 VGND VGND VPWR VPWR sky130_fd_sc_hd__decap_3
XFILLER_59_161 VGND VGND VPWR VPWR sky130_fd_sc_hd__decap_3
XTAP_TAPCELL_ROW_129_886 VGND VPWR sky130_fd_sc_hd__tapvpwrvgnd_1
XFILLER_59_183 VGND VGND VPWR VPWR sky130_fd_sc_hd__decap_3
XFILLER_74_175 VGND VGND VPWR VPWR sky130_fd_sc_hd__decap_3
XFILLER_74_85 VGND VGND VPWR VPWR sky130_fd_sc_hd__fill_2
XFILLER_74_197 VGND VGND VPWR VPWR sky130_fd_sc_hd__decap_3
XFILLER_130_80 VGND VGND VPWR VPWR sky130_fd_sc_hd__decap_3
XFILLER_30_212 VGND VGND VPWR VPWR sky130_fd_sc_hd__decap_3
XFILLER_175_217 VGND VGND VPWR VPWR sky130_fd_sc_hd__decap_3
XFILLER_130_91 VGND VGND VPWR VPWR sky130_fd_sc_hd__decap_3
XFILLER_90_62 VGND VGND VPWR VPWR sky130_fd_sc_hd__decap_3
XFILLER_175_228 VGND VGND VPWR VPWR sky130_fd_sc_hd__fill_2
XFILLER_128_133 VGND VGND VPWR VPWR sky130_fd_sc_hd__decap_3
X_0701_ net127 net334 VGND VGND VPWR VPWR Tile_X0Y0_OpenRAM_top.Inst_OpenRAM_top_ConfigMem.Inst_frame0_bit21.Q
+ sky130_fd_sc_hd__dlxtp_1
XFILLER_128_177 VGND VGND VPWR VPWR sky130_fd_sc_hd__decap_3
XFILLER_143_125 VGND VGND VPWR VPWR sky130_fd_sc_hd__decap_3
XFILLER_99_60 VGND VGND VPWR VPWR sky130_fd_sc_hd__decap_3
X_0632_ net174 net204 net206 _0156_ Tile_X0Y1_OpenRAM_bot.Inst_OpenRAM_bot_ConfigMem.Inst_frame8_bit25.Q
+ Tile_X0Y1_OpenRAM_bot.Inst_OpenRAM_bot_ConfigMem.Inst_frame8_bit24.Q VGND VGND VPWR
+ VPWR _0177_ sky130_fd_sc_hd__mux4_1
XFILLER_143_169 VGND VGND VPWR VPWR sky130_fd_sc_hd__decap_3
XFILLER_143_158 VGND VGND VPWR VPWR sky130_fd_sc_hd__decap_3
XFILLER_99_93 VGND VGND VPWR VPWR sky130_fd_sc_hd__decap_3
X_0563_ net4 net36 _0151_ _0085_ Tile_X0Y1_OpenRAM_bot.Inst_OpenRAM_bot_ConfigMem.Inst_frame4_bit4.Q
+ Tile_X0Y1_OpenRAM_bot.Inst_OpenRAM_bot_ConfigMem.Inst_frame4_bit5.Q VGND VGND VPWR
+ VPWR Tile_X0Y1_OpenRAM_bot.Inst_OpenRAM_bot_switch_matrix.WW4BEG10 sky130_fd_sc_hd__mux4_1
X_0494_ net92 Tile_X0Y0_OpenRAM_top.Inst_OpenRAM_top_switch_matrix.J_NS4_BEG0 Tile_X0Y0_OpenRAM_top.Inst_OpenRAM_top_ConfigMem.Inst_frame6_bit8.Q
+ VGND VGND VPWR VPWR _0134_ sky130_fd_sc_hd__mux2_1
X_1115_ net224 net297 VGND VGND VPWR VPWR Tile_X0Y1_OpenRAM_bot.Inst_OpenRAM_bot_ConfigMem.Inst_frame4_bit11.Q
+ sky130_fd_sc_hd__dlxtp_1
X_1046_ net229 net313 VGND VGND VPWR VPWR Tile_X0Y1_OpenRAM_bot.Inst_OpenRAM_bot_ConfigMem.Inst_frame2_bit16.Q
+ sky130_fd_sc_hd__dlxtp_1
XFILLER_80_167 VGND VGND VPWR VPWR sky130_fd_sc_hd__decap_3
XFILLER_166_206 VGND VGND VPWR VPWR sky130_fd_sc_hd__decap_3
XFILLER_119_133 VGND VGND VPWR VPWR sky130_fd_sc_hd__decap_3
XFILLER_142_180 VGND VGND VPWR VPWR sky130_fd_sc_hd__fill_1
XFILLER_88_212 VGND VGND VPWR VPWR sky130_fd_sc_hd__decap_3
XFILLER_135_69 VGND VGND VPWR VPWR sky130_fd_sc_hd__decap_3
XFILLER_28_78 VGND VGND VPWR VPWR sky130_fd_sc_hd__decap_3
XFILLER_71_101 VGND VGND VPWR VPWR sky130_fd_sc_hd__decap_3
XFILLER_44_44 VGND VGND VPWR VPWR sky130_fd_sc_hd__decap_3
XFILLER_71_156 VGND VGND VPWR VPWR sky130_fd_sc_hd__decap_3
XFILLER_71_167 VGND VGND VPWR VPWR sky130_fd_sc_hd__fill_1
XFILLER_44_66 VGND VGND VPWR VPWR sky130_fd_sc_hd__decap_3
XTAP_TAPCELL_ROW_42_538 VGND VPWR sky130_fd_sc_hd__tapvpwrvgnd_1
XFILLER_44_88 VGND VGND VPWR VPWR sky130_fd_sc_hd__decap_3
XFILLER_100_61 VGND VGND VPWR VPWR sky130_fd_sc_hd__decap_3
XFILLER_8_227 VGND VGND VPWR VPWR sky130_fd_sc_hd__decap_3
XFILLER_176_21 VGND VGND VPWR VPWR sky130_fd_sc_hd__decap_3
XTAP_TAPCELL_ROW_10_413 VGND VPWR sky130_fd_sc_hd__tapvpwrvgnd_1
XTAP_TAPCELL_ROW_50_571 VGND VPWR sky130_fd_sc_hd__tapvpwrvgnd_1
XFILLER_60_43 VGND VGND VPWR VPWR sky130_fd_sc_hd__decap_3
XFILLER_176_65 VGND VGND VPWR VPWR sky130_fd_sc_hd__decap_3
XFILLER_176_32 VGND VGND VPWR VPWR sky130_fd_sc_hd__decap_3
XFILLER_172_209 VGND VGND VPWR VPWR sky130_fd_sc_hd__decap_3
XFILLER_5_27 VGND VGND VPWR VPWR sky130_fd_sc_hd__decap_3
XFILLER_140_106 VGND VGND VPWR VPWR sky130_fd_sc_hd__decap_3
XFILLER_125_169 VGND VGND VPWR VPWR sky130_fd_sc_hd__decap_3
XFILLER_140_139 VGND VGND VPWR VPWR sky130_fd_sc_hd__fill_1
XFILLER_69_63 VGND VGND VPWR VPWR sky130_fd_sc_hd__decap_3
XFILLER_79_223 VGND VGND VPWR VPWR sky130_fd_sc_hd__fill_1
XPHY_EDGE_ROW_66_Left_249 VGND VGND VPWR VPWR sky130_fd_sc_hd__decap_3
XFILLER_94_215 VGND VGND VPWR VPWR sky130_fd_sc_hd__decap_3
XFILLER_47_131 VGND VGND VPWR VPWR sky130_fd_sc_hd__decap_3
XFILLER_47_153 VGND VGND VPWR VPWR sky130_fd_sc_hd__decap_3
XFILLER_47_175 VGND VGND VPWR VPWR sky130_fd_sc_hd__decap_3
XFILLER_141_90 VGND VGND VPWR VPWR sky130_fd_sc_hd__decap_3
XFILLER_62_134 VGND VGND VPWR VPWR sky130_fd_sc_hd__decap_3
XFILLER_62_156 VGND VGND VPWR VPWR sky130_fd_sc_hd__decap_3
XTAP_TAPCELL_ROW_33_505 VGND VPWR sky130_fd_sc_hd__tapvpwrvgnd_1
XTAP_TAPCELL_ROW_73_663 VGND VPWR sky130_fd_sc_hd__tapvpwrvgnd_1
XPHY_EDGE_ROW_75_Left_258 VGND VGND VPWR VPWR sky130_fd_sc_hd__decap_3
XFILLER_79_3 VGND VGND VPWR VPWR sky130_fd_sc_hd__decap_3
XFILLER_171_220 VGND VGND VPWR VPWR sky130_fd_sc_hd__decap_3
XFILLER_116_125 VGND VGND VPWR VPWR sky130_fd_sc_hd__decap_3
XFILLER_116_147 VGND VGND VPWR VPWR sky130_fd_sc_hd__decap_3
XFILLER_131_139 VGND VGND VPWR VPWR sky130_fd_sc_hd__decap_3
X_0615_ net177 net219 net212 Tile_X0Y1_OpenRAM_bot.Inst_OpenRAM_bot_switch_matrix.J_NS4_BEG15
+ Tile_X0Y1_OpenRAM_bot.Inst_OpenRAM_bot_ConfigMem.Inst_frame2_bit26.Q Tile_X0Y1_OpenRAM_bot.Inst_OpenRAM_bot_ConfigMem.Inst_frame2_bit27.Q
+ VGND VGND VPWR VPWR net392 sky130_fd_sc_hd__mux4_2
X_0546_ net2 net34 Tile_X0Y1_OpenRAM_bot.Inst_OpenRAM_bot_switch_matrix.J_NS4_BEG15
+ _0087_ Tile_X0Y1_OpenRAM_bot.Inst_OpenRAM_bot_ConfigMem.Inst_frame5_bit16.Q Tile_X0Y1_OpenRAM_bot.Inst_OpenRAM_bot_ConfigMem.Inst_frame5_bit17.Q
+ VGND VGND VPWR VPWR Tile_X0Y1_OpenRAM_bot.Inst_OpenRAM_bot_switch_matrix.WW4BEG0
+ sky130_fd_sc_hd__mux4_1
XPHY_EDGE_ROW_84_Left_267 VGND VGND VPWR VPWR sky130_fd_sc_hd__decap_3
X_0477_ net67 Tile_X0Y0_OpenRAM_top.Inst_OpenRAM_top_ConfigMem.Inst_frame7_bit7.Q
+ Tile_X0Y0_OpenRAM_top.Inst_OpenRAM_top_ConfigMem.Inst_frame7_bit8.Q VGND VGND VPWR
+ VPWR _0120_ sky130_fd_sc_hd__o21ba_1
XFILLER_105_39 VGND VGND VPWR VPWR sky130_fd_sc_hd__decap_3
XTAP_TAPCELL_ROW_96_755 VGND VPWR sky130_fd_sc_hd__tapvpwrvgnd_1
XFILLER_38_153 VGND VGND VPWR VPWR sky130_fd_sc_hd__decap_3
XFILLER_38_197 VGND VGND VPWR VPWR sky130_fd_sc_hd__fill_1
XFILLER_53_101 VGND VGND VPWR VPWR sky130_fd_sc_hd__decap_3
XPHY_EDGE_ROW_138_Right_138 VGND VGND VPWR VPWR sky130_fd_sc_hd__decap_3
XFILLER_53_178 VGND VGND VPWR VPWR sky130_fd_sc_hd__decap_3
X_1029_ net233 net325 VGND VGND VPWR VPWR Tile_X0Y1_OpenRAM_bot.Inst_OpenRAM_bot_ConfigMem.Inst_frame1_bit1.Q
+ sky130_fd_sc_hd__dlxtp_1
XPHY_EDGE_ROW_93_Left_276 VGND VGND VPWR VPWR sky130_fd_sc_hd__decap_3
XFILLER_5_208 VGND VGND VPWR VPWR sky130_fd_sc_hd__decap_3
XFILLER_107_125 VGND VGND VPWR VPWR sky130_fd_sc_hd__decap_3
XFILLER_30_24 VGND VGND VPWR VPWR sky130_fd_sc_hd__decap_3
XFILLER_30_35 VGND VGND VPWR VPWR sky130_fd_sc_hd__decap_3
XFILLER_107_169 VGND VGND VPWR VPWR sky130_fd_sc_hd__fill_1
XFILLER_100_6 VGND VGND VPWR VPWR sky130_fd_sc_hd__decap_3
XFILLER_30_68 VGND VGND VPWR VPWR sky130_fd_sc_hd__decap_3
XFILLER_122_139 VGND VGND VPWR VPWR sky130_fd_sc_hd__fill_1
XFILLER_162_56 VGND VGND VPWR VPWR sky130_fd_sc_hd__decap_3
XFILLER_130_194 VGND VGND VPWR VPWR sky130_fd_sc_hd__fill_2
XFILLER_29_120 VGND VGND VPWR VPWR sky130_fd_sc_hd__fill_2
XFILLER_39_99 VGND VGND VPWR VPWR sky130_fd_sc_hd__decap_3
XFILLER_29_186 VGND VGND VPWR VPWR sky130_fd_sc_hd__decap_3
XFILLER_29_197 VGND VGND VPWR VPWR sky130_fd_sc_hd__decap_3
XFILLER_55_43 VGND VGND VPWR VPWR sky130_fd_sc_hd__decap_3
XTAP_TAPCELL_ROW_114_826 VGND VPWR sky130_fd_sc_hd__tapvpwrvgnd_1
XFILLER_44_156 VGND VGND VPWR VPWR sky130_fd_sc_hd__decap_3
XPHY_EDGE_ROW_105_Right_105 VGND VGND VPWR VPWR sky130_fd_sc_hd__decap_3
XFILLER_44_178 VGND VGND VPWR VPWR sky130_fd_sc_hd__decap_3
XFILLER_55_98 VGND VGND VPWR VPWR sky130_fd_sc_hd__decap_3
XFILLER_111_60 VGND VGND VPWR VPWR sky130_fd_sc_hd__decap_3
XFILLER_71_42 VGND VGND VPWR VPWR sky130_fd_sc_hd__decap_3
XTAP_TAPCELL_ROW_178_1085 VGND VPWR sky130_fd_sc_hd__tapvpwrvgnd_1
XFILLER_4_230 VGND VGND VPWR VPWR sky130_fd_sc_hd__fill_1
XFILLER_113_128 VGND VGND VPWR VPWR sky130_fd_sc_hd__decap_3
XFILLER_113_106 VGND VGND VPWR VPWR sky130_fd_sc_hd__decap_3
X_1380_ Tile_X0Y0_OpenRAM_top.Inst_OpenRAM_top_switch_matrix.WW4BEG2 VGND VGND VPWR
+ VPWR net546 sky130_fd_sc_hd__clkbuf_1
X_0400_ net19 net51 Tile_X0Y0_OpenRAM_top.Inst_OpenRAM_top_switch_matrix.J_NS4_BEG7
+ Tile_X0Y0_OpenRAM_top.Inst_OpenRAM_top_switch_matrix.J_NS2_BEG7 Tile_X0Y0_OpenRAM_top.Inst_OpenRAM_top_ConfigMem.Inst_frame4_bit12.Q
+ Tile_X0Y0_OpenRAM_top.Inst_OpenRAM_top_ConfigMem.Inst_frame4_bit13.Q VGND VGND VPWR
+ VPWR Tile_X0Y0_OpenRAM_top.Inst_OpenRAM_top_switch_matrix.WW4BEG8 sky130_fd_sc_hd__mux4_1
XFILLER_121_161 VGND VGND VPWR VPWR sky130_fd_sc_hd__decap_3
XFILLER_96_50 VGND VGND VPWR VPWR sky130_fd_sc_hd__fill_2
X_0331_ Tile_X0Y0_OpenRAM_top.Inst_OpenRAM_top_switch_matrix.N2BEGb2 net351 net160
+ net152 Tile_X0Y0_OpenRAM_top.Inst_OpenRAM_top_ConfigMem.Inst_frame0_bit12.Q Tile_X0Y0_OpenRAM_top.Inst_OpenRAM_top_ConfigMem.Inst_frame0_bit13.Q
+ VGND VGND VPWR VPWR Tile_X0Y0_OpenRAM_top.Inst_OpenRAM_top_switch_matrix.J_NS2_BEG2
+ sky130_fd_sc_hd__mux4_2
XTAP_TAPCELL_ROW_137_918 VGND VPWR sky130_fd_sc_hd__tapvpwrvgnd_1
X_0262_ net182 net161 Tile_X0Y1_OpenRAM_bot.Inst_OpenRAM_bot_ConfigMem.Inst_frame3_bit10.Q
+ VGND VGND VPWR VPWR _0032_ sky130_fd_sc_hd__mux2_1
XTAP_TAPCELL_ROW_145_951 VGND VPWR sky130_fd_sc_hd__tapvpwrvgnd_1
XFILLER_35_167 VGND VGND VPWR VPWR sky130_fd_sc_hd__fill_1
XFILLER_50_115 VGND VGND VPWR VPWR sky130_fd_sc_hd__decap_3
XFILLER_50_159 VGND VGND VPWR VPWR sky130_fd_sc_hd__decap_3
XFILLER_136_209 VGND VGND VPWR VPWR sky130_fd_sc_hd__decap_3
XFILLER_116_38 VGND VGND VPWR VPWR sky130_fd_sc_hd__decap_3
XFILLER_116_16 VGND VGND VPWR VPWR sky130_fd_sc_hd__decap_3
XFILLER_112_150 VGND VGND VPWR VPWR sky130_fd_sc_hd__decap_3
XFILLER_58_215 VGND VGND VPWR VPWR sky130_fd_sc_hd__decap_3
XFILLER_112_183 VGND VGND VPWR VPWR sky130_fd_sc_hd__decap_3
X_0529_ net340 net25 _0077_ net57 Tile_X0Y1_OpenRAM_bot.Inst_OpenRAM_bot_ConfigMem.Inst_frame6_bit15.Q
+ Tile_X0Y1_OpenRAM_bot.Inst_OpenRAM_bot_ConfigMem.Inst_frame6_bit14.Q VGND VGND VPWR
+ VPWR Tile_X0Y1_OpenRAM_bot.Inst_OpenRAM_bot_switch_matrix.W1BEG3 sky130_fd_sc_hd__mux4_1
XFILLER_132_26 VGND VGND VPWR VPWR sky130_fd_sc_hd__fill_2
XFILLER_132_59 VGND VGND VPWR VPWR sky130_fd_sc_hd__decap_3
XFILLER_73_218 VGND VGND VPWR VPWR sky130_fd_sc_hd__decap_3
XFILLER_25_24 VGND VGND VPWR VPWR sky130_fd_sc_hd__decap_3
XFILLER_26_189 VGND VGND VPWR VPWR sky130_fd_sc_hd__decap_3
XTAP_TAPCELL_ROW_151_976 VGND VPWR sky130_fd_sc_hd__tapvpwrvgnd_1
XFILLER_25_57 VGND VGND VPWR VPWR sky130_fd_sc_hd__decap_3
XFILLER_179_172 VGND VGND VPWR VPWR sky130_fd_sc_hd__decap_3
XFILLER_179_150 VGND VGND VPWR VPWR sky130_fd_sc_hd__decap_3
XFILLER_179_194 VGND VGND VPWR VPWR sky130_fd_sc_hd__decap_3
XFILLER_157_23 VGND VGND VPWR VPWR sky130_fd_sc_hd__decap_3
XFILLER_41_78 VGND VGND VPWR VPWR sky130_fd_sc_hd__fill_2
XFILLER_157_78 VGND VGND VPWR VPWR sky130_fd_sc_hd__decap_3
XFILLER_150_212 VGND VGND VPWR VPWR sky130_fd_sc_hd__decap_3
XFILLER_173_33 VGND VGND VPWR VPWR sky130_fd_sc_hd__decap_3
XFILLER_9_3 VGND VGND VPWR VPWR sky130_fd_sc_hd__decap_3
XFILLER_1_211 VGND VGND VPWR VPWR sky130_fd_sc_hd__decap_3
XFILLER_173_66 VGND VGND VPWR VPWR sky130_fd_sc_hd__decap_3
XFILLER_173_99 VGND VGND VPWR VPWR sky130_fd_sc_hd__decap_3
XFILLER_106_71 VGND VGND VPWR VPWR sky130_fd_sc_hd__decap_3
XFILLER_103_172 VGND VGND VPWR VPWR sky130_fd_sc_hd__decap_3
XFILLER_103_161 VGND VGND VPWR VPWR sky130_fd_sc_hd__decap_3
XFILLER_66_53 VGND VGND VPWR VPWR sky130_fd_sc_hd__decap_3
XFILLER_64_218 VGND VGND VPWR VPWR sky130_fd_sc_hd__decap_3
XFILLER_66_75 VGND VGND VPWR VPWR sky130_fd_sc_hd__decap_3
XFILLER_17_145 VGND VGND VPWR VPWR sky130_fd_sc_hd__fill_1
XFILLER_82_41 VGND VGND VPWR VPWR sky130_fd_sc_hd__decap_3
XFILLER_32_115 VGND VGND VPWR VPWR sky130_fd_sc_hd__decap_3
XFILLER_32_159 VGND VGND VPWR VPWR sky130_fd_sc_hd__decap_3
XFILLER_82_85 VGND VGND VPWR VPWR sky130_fd_sc_hd__decap_3
X_0880_ net136 net292 VGND VGND VPWR VPWR Tile_X0Y0_OpenRAM_top.Inst_OpenRAM_top_ConfigMem.Inst_frame5_bit2.Q
+ sky130_fd_sc_hd__dlxtp_1
XPHY_EDGE_ROW_149_Left_332 VGND VGND VPWR VPWR sky130_fd_sc_hd__decap_3
XFILLER_63_6 VGND VGND VPWR VPWR sky130_fd_sc_hd__fill_2
X_1501_ Tile_X0Y1_OpenRAM_bot.Inst_OpenRAM_bot_switch_matrix.WW4BEG7 VGND VGND VPWR
+ VPWR net667 sky130_fd_sc_hd__buf_1
XFILLER_99_159 VGND VGND VPWR VPWR sky130_fd_sc_hd__decap_3
X_1432_ Tile_X0Y1_OpenRAM_bot.Inst_OpenRAM_bot_switch_matrix.S2BEG2 VGND VGND VPWR
+ VPWR net592 sky130_fd_sc_hd__clkbuf_2
X_1363_ Tile_X0Y0_OpenRAM_top.Inst_OpenRAM_top_switch_matrix.W2BEGb5 VGND VGND VPWR
+ VPWR net523 sky130_fd_sc_hd__buf_1
XPHY_EDGE_ROW_158_Left_341 VGND VGND VPWR VPWR sky130_fd_sc_hd__decap_3
X_0314_ Tile_X0Y0_OpenRAM_top.Inst_OpenRAM_top_ConfigMem.Inst_frame0_bit30.Q _0075_
+ _0004_ _0074_ VGND VGND VPWR VPWR _0076_ sky130_fd_sc_hd__a2bb2o_1
X_1294_ net293 VGND VGND VPWR VPWR net464 sky130_fd_sc_hd__clkbuf_2
XFILLER_55_207 VGND VGND VPWR VPWR sky130_fd_sc_hd__decap_3
X_0245_ Tile_X0Y0_OpenRAM_top.Inst_OpenRAM_top_ConfigMem.Inst_frame0_bit25.Q VGND
+ VGND VPWR VPWR _0018_ sky130_fd_sc_hd__inv_1
XFILLER_102_29 VGND VGND VPWR VPWR sky130_fd_sc_hd__decap_3
XFILLER_23_104 VGND VGND VPWR VPWR sky130_fd_sc_hd__decap_3
XPHY_EDGE_ROW_167_Left_350 VGND VGND VPWR VPWR sky130_fd_sc_hd__decap_3
XFILLER_176_153 VGND VGND VPWR VPWR sky130_fd_sc_hd__decap_3
XFILLER_31_181 VGND VGND VPWR VPWR sky130_fd_sc_hd__decap_3
XFILLER_176_197 VGND VGND VPWR VPWR sky130_fd_sc_hd__decap_3
XFILLER_176_186 VGND VGND VPWR VPWR sky130_fd_sc_hd__decap_3
XFILLER_11_37 VGND VGND VPWR VPWR sky130_fd_sc_hd__decap_3
XFILLER_127_37 VGND VGND VPWR VPWR sky130_fd_sc_hd__decap_3
Xfanout323 net325 VGND VGND VPWR VPWR net323 sky130_fd_sc_hd__clkbuf_2
Xfanout312 net315 VGND VGND VPWR VPWR net312 sky130_fd_sc_hd__clkbuf_2
Xfanout301 Tile_X0Y1_FrameStrobe[4] VGND VGND VPWR VPWR net301 sky130_fd_sc_hd__buf_2
XFILLER_143_36 VGND VGND VPWR VPWR sky130_fd_sc_hd__decap_3
XFILLER_98_192 VGND VGND VPWR VPWR sky130_fd_sc_hd__decap_3
Xfanout334 net338 VGND VGND VPWR VPWR net334 sky130_fd_sc_hd__buf_2
XFILLER_143_69 VGND VGND VPWR VPWR sky130_fd_sc_hd__decap_3
XFILLER_100_175 VGND VGND VPWR VPWR sky130_fd_sc_hd__decap_3
XFILLER_100_153 VGND VGND VPWR VPWR sky130_fd_sc_hd__decap_3
XFILLER_100_197 VGND VGND VPWR VPWR sky130_fd_sc_hd__decap_3
XFILLER_36_56 VGND VGND VPWR VPWR sky130_fd_sc_hd__decap_3
XFILLER_14_159 VGND VGND VPWR VPWR sky130_fd_sc_hd__decap_3
XFILLER_52_22 VGND VGND VPWR VPWR sky130_fd_sc_hd__decap_3
XFILLER_167_131 VGND VGND VPWR VPWR sky130_fd_sc_hd__fill_1
XFILLER_168_44 VGND VGND VPWR VPWR sky130_fd_sc_hd__decap_3
XFILLER_168_88 VGND VGND VPWR VPWR sky130_fd_sc_hd__decap_3
XFILLER_168_77 VGND VGND VPWR VPWR sky130_fd_sc_hd__decap_3
XFILLER_167_175 VGND VGND VPWR VPWR sky130_fd_sc_hd__decap_3
XFILLER_182_145 VGND VGND VPWR VPWR sky130_fd_sc_hd__fill_2
XFILLER_123_223 VGND VGND VPWR VPWR sky130_fd_sc_hd__fill_1
XFILLER_117_81 VGND VGND VPWR VPWR sky130_fd_sc_hd__decap_3
XFILLER_77_30 VGND VGND VPWR VPWR sky130_fd_sc_hd__decap_3
XFILLER_77_63 VGND VGND VPWR VPWR sky130_fd_sc_hd__decap_3
XFILLER_89_181 VGND VGND VPWR VPWR sky130_fd_sc_hd__fill_1
XFILLER_77_85 VGND VGND VPWR VPWR sky130_fd_sc_hd__decap_3
XTAP_TAPCELL_ROW_5_391 VGND VPWR sky130_fd_sc_hd__tapvpwrvgnd_1
XFILLER_93_51 VGND VGND VPWR VPWR sky130_fd_sc_hd__decap_3
XTAP_TAPCELL_ROW_28_482 VGND VPWR sky130_fd_sc_hd__tapvpwrvgnd_1
XFILLER_60_221 VGND VGND VPWR VPWR sky130_fd_sc_hd__decap_3
XFILLER_93_95 VGND VGND VPWR VPWR sky130_fd_sc_hd__decap_3
XFILLER_158_131 VGND VGND VPWR VPWR sky130_fd_sc_hd__decap_3
X_0932_ net119 net274 VGND VGND VPWR VPWR Tile_X0Y0_OpenRAM_top.Inst_OpenRAM_top_ConfigMem.Inst_frame7_bit14.Q
+ sky130_fd_sc_hd__dlxtp_1
XFILLER_13_181 VGND VGND VPWR VPWR sky130_fd_sc_hd__decap_3
XFILLER_9_152 VGND VGND VPWR VPWR sky130_fd_sc_hd__decap_3
XFILLER_158_197 VGND VGND VPWR VPWR sky130_fd_sc_hd__decap_3
XFILLER_158_186 VGND VGND VPWR VPWR sky130_fd_sc_hd__decap_3
X_0863_ net124 net293 VGND VGND VPWR VPWR Tile_X0Y0_OpenRAM_top.Inst_OpenRAM_top_ConfigMem.Inst_frame5_bit19.Q
+ sky130_fd_sc_hd__dlxtp_1
XFILLER_173_134 VGND VGND VPWR VPWR sky130_fd_sc_hd__decap_3
XFILLER_9_196 VGND VGND VPWR VPWR sky130_fd_sc_hd__decap_3
XFILLER_173_178 VGND VGND VPWR VPWR sky130_fd_sc_hd__decap_3
XFILLER_173_167 VGND VGND VPWR VPWR sky130_fd_sc_hd__fill_1
X_0794_ net130 net309 VGND VGND VPWR VPWR Tile_X0Y0_OpenRAM_top.Inst_OpenRAM_top_ConfigMem.Inst_frame3_bit24.Q
+ sky130_fd_sc_hd__dlxtp_1
XFILLER_114_212 VGND VGND VPWR VPWR sky130_fd_sc_hd__decap_3
X_1415_ net235 VGND VGND VPWR VPWR net567 sky130_fd_sc_hd__buf_4
X_1346_ Tile_X0Y0_OpenRAM_top.Inst_OpenRAM_top_switch_matrix.W1BEG0 VGND VGND VPWR
+ VPWR net506 sky130_fd_sc_hd__buf_1
XFILLER_3_60 VGND VGND VPWR VPWR sky130_fd_sc_hd__decap_3
XFILLER_3_93 VGND VGND VPWR VPWR sky130_fd_sc_hd__decap_3
XFILLER_95_162 VGND VGND VPWR VPWR sky130_fd_sc_hd__fill_1
X_1277_ net126 VGND VGND VPWR VPWR net429 sky130_fd_sc_hd__buf_1
X_0228_ net183 VGND VGND VPWR VPWR _0001_ sky130_fd_sc_hd__inv_2
XTAP_TAPCELL_ROW_159_1006 VGND VPWR sky130_fd_sc_hd__tapvpwrvgnd_1
XFILLER_149_164 VGND VGND VPWR VPWR sky130_fd_sc_hd__decap_3
XFILLER_149_131 VGND VGND VPWR VPWR sky130_fd_sc_hd__decap_3
XFILLER_149_175 VGND VGND VPWR VPWR sky130_fd_sc_hd__decap_3
XFILLER_138_25 VGND VGND VPWR VPWR sky130_fd_sc_hd__decap_3
XFILLER_164_189 VGND VGND VPWR VPWR sky130_fd_sc_hd__decap_3
XFILLER_164_167 VGND VGND VPWR VPWR sky130_fd_sc_hd__fill_1
XFILLER_98_29 VGND VGND VPWR VPWR sky130_fd_sc_hd__decap_3
XFILLER_98_18 VGND VGND VPWR VPWR sky130_fd_sc_hd__decap_3
XFILLER_105_223 VGND VGND VPWR VPWR sky130_fd_sc_hd__fill_1
XFILLER_154_35 VGND VGND VPWR VPWR sky130_fd_sc_hd__decap_3
Xoutput471 net554 VGND VGND VPWR VPWR Tile_X0Y1_FrameData_O[0] sky130_fd_sc_hd__buf_2
Xoutput460 net543 VGND VGND VPWR VPWR Tile_X0Y0_WW4BEG[14] sky130_fd_sc_hd__buf_2
Xoutput493 net576 VGND VGND VPWR VPWR Tile_X0Y1_FrameData_O[2] sky130_fd_sc_hd__buf_2
Xoutput482 net565 VGND VGND VPWR VPWR Tile_X0Y1_FrameData_O[1] sky130_fd_sc_hd__buf_2
XFILLER_47_55 VGND VGND VPWR VPWR sky130_fd_sc_hd__fill_1
XFILLER_170_56 VGND VGND VPWR VPWR sky130_fd_sc_hd__decap_3
XFILLER_42_221 VGND VGND VPWR VPWR sky130_fd_sc_hd__decap_3
XTAP_TAPCELL_ROW_57_599 VGND VPWR sky130_fd_sc_hd__tapvpwrvgnd_1
XFILLER_63_32 VGND VGND VPWR VPWR sky130_fd_sc_hd__fill_2
XFILLER_179_21 VGND VGND VPWR VPWR sky130_fd_sc_hd__decap_3
XFILLER_63_76 VGND VGND VPWR VPWR sky130_fd_sc_hd__decap_3
XFILLER_179_54 VGND VGND VPWR VPWR sky130_fd_sc_hd__fill_2
XFILLER_179_87 VGND VGND VPWR VPWR sky130_fd_sc_hd__decap_3
XFILLER_8_38 VGND VGND VPWR VPWR sky130_fd_sc_hd__decap_3
XFILLER_8_27 VGND VGND VPWR VPWR sky130_fd_sc_hd__fill_1
XFILLER_6_100 VGND VGND VPWR VPWR sky130_fd_sc_hd__decap_3
XFILLER_10_195 VGND VGND VPWR VPWR sky130_fd_sc_hd__fill_1
XFILLER_10_162 VGND VGND VPWR VPWR sky130_fd_sc_hd__decap_3
XFILLER_6_144 VGND VGND VPWR VPWR sky130_fd_sc_hd__decap_3
XFILLER_6_133 VGND VGND VPWR VPWR sky130_fd_sc_hd__decap_3
XFILLER_170_115 VGND VGND VPWR VPWR sky130_fd_sc_hd__decap_3
XFILLER_155_167 VGND VGND VPWR VPWR sky130_fd_sc_hd__fill_1
XFILLER_12_80 VGND VGND VPWR VPWR sky130_fd_sc_hd__decap_3
XFILLER_6_177 VGND VGND VPWR VPWR sky130_fd_sc_hd__decap_3
XFILLER_128_91 VGND VGND VPWR VPWR sky130_fd_sc_hd__decap_3
XFILLER_12_91 VGND VGND VPWR VPWR sky130_fd_sc_hd__decap_3
XFILLER_170_159 VGND VGND VPWR VPWR sky130_fd_sc_hd__decap_3
XFILLER_88_62 VGND VGND VPWR VPWR sky130_fd_sc_hd__decap_3
XFILLER_77_140 VGND VGND VPWR VPWR sky130_fd_sc_hd__decap_3
X_1200_ net236 net271 VGND VGND VPWR VPWR Tile_X0Y1_OpenRAM_bot.Inst_OpenRAM_bot_ConfigMem.Inst_frame7_bit22.Q
+ sky130_fd_sc_hd__dlxtp_1
XFILLER_77_162 VGND VGND VPWR VPWR sky130_fd_sc_hd__decap_3
X_1131_ net241 net288 VGND VGND VPWR VPWR Tile_X0Y1_OpenRAM_bot.Inst_OpenRAM_bot_ConfigMem.Inst_frame5_bit27.Q
+ sky130_fd_sc_hd__dlxtp_1
X_1062_ net222 net313 VGND VGND VPWR VPWR Tile_X0Y1_OpenRAM_bot.Inst_OpenRAM_bot_ConfigMem.Inst_frame2_bit0.Q
+ sky130_fd_sc_hd__dlxtp_1
XFILLER_178_215 VGND VGND VPWR VPWR sky130_fd_sc_hd__decap_3
X_0915_ net138 net274 VGND VGND VPWR VPWR Tile_X0Y0_OpenRAM_top.Inst_OpenRAM_top_ConfigMem.Inst_frame7_bit31.Q
+ sky130_fd_sc_hd__dlxtp_1
XFILLER_161_104 VGND VGND VPWR VPWR sky130_fd_sc_hd__decap_3
X_0846_ net140 net302 VGND VGND VPWR VPWR Tile_X0Y0_OpenRAM_top.Inst_OpenRAM_top_ConfigMem.Inst_frame4_bit4.Q
+ sky130_fd_sc_hd__dlxtp_1
XFILLER_161_137 VGND VGND VPWR VPWR sky130_fd_sc_hd__decap_3
X_0777_ net145 net320 VGND VGND VPWR VPWR Tile_X0Y0_OpenRAM_top.Inst_OpenRAM_top_ConfigMem.Inst_frame2_bit9.Q
+ sky130_fd_sc_hd__dlxtp_1
XFILLER_102_215 VGND VGND VPWR VPWR sky130_fd_sc_hd__decap_3
XFILLER_124_27 VGND VGND VPWR VPWR sky130_fd_sc_hd__fill_1
XTAP_TAPCELL_ROW_165_1032 VGND VPWR sky130_fd_sc_hd__tapvpwrvgnd_1
XFILLER_68_162 VGND VGND VPWR VPWR sky130_fd_sc_hd__decap_3
X_1329_ Tile_X0Y1_N4END[8] VGND VGND VPWR VPWR net489 sky130_fd_sc_hd__clkbuf_1
XFILLER_68_195 VGND VGND VPWR VPWR sky130_fd_sc_hd__fill_1
XFILLER_17_47 VGND VGND VPWR VPWR sky130_fd_sc_hd__decap_3
XFILLER_83_143 VGND VGND VPWR VPWR sky130_fd_sc_hd__decap_3
XFILLER_17_69 VGND VGND VPWR VPWR sky130_fd_sc_hd__decap_3
XFILLER_83_187 VGND VGND VPWR VPWR sky130_fd_sc_hd__decap_3
XFILLER_140_59 VGND VGND VPWR VPWR sky130_fd_sc_hd__decap_3
XTAP_TAPCELL_ROW_106_795 VGND VPWR sky130_fd_sc_hd__tapvpwrvgnd_1
XFILLER_24_232 VGND VGND VPWR VPWR sky130_fd_sc_hd__fill_2
XFILLER_149_13 VGND VGND VPWR VPWR sky130_fd_sc_hd__decap_3
XFILLER_33_57 VGND VGND VPWR VPWR sky130_fd_sc_hd__decap_3
XFILLER_149_57 VGND VGND VPWR VPWR sky130_fd_sc_hd__decap_3
XFILLER_149_46 VGND VGND VPWR VPWR sky130_fd_sc_hd__decap_3
XFILLER_137_123 VGND VGND VPWR VPWR sky130_fd_sc_hd__decap_3
XTAP_TAPCELL_ROW_172_1058 VGND VPWR sky130_fd_sc_hd__tapvpwrvgnd_1
XFILLER_152_115 VGND VGND VPWR VPWR sky130_fd_sc_hd__decap_3
XFILLER_137_178 VGND VGND VPWR VPWR sky130_fd_sc_hd__decap_3
XFILLER_137_156 VGND VGND VPWR VPWR sky130_fd_sc_hd__decap_3
XFILLER_109_3 VGND VGND VPWR VPWR sky130_fd_sc_hd__fill_2
XPHY_EDGE_ROW_104_Left_287 VGND VGND VPWR VPWR sky130_fd_sc_hd__decap_3
XFILLER_3_125 VGND VGND VPWR VPWR sky130_fd_sc_hd__decap_3
XFILLER_165_89 VGND VGND VPWR VPWR sky130_fd_sc_hd__decap_3
XFILLER_3_169 VGND VGND VPWR VPWR sky130_fd_sc_hd__decap_3
XFILLER_58_21 VGND VGND VPWR VPWR sky130_fd_sc_hd__decap_3
XFILLER_160_192 VGND VGND VPWR VPWR sky130_fd_sc_hd__decap_3
Xoutput290 net373 VGND VGND VPWR VPWR ADDR_B_SRAM0 sky130_fd_sc_hd__buf_2
XFILLER_58_32 VGND VGND VPWR VPWR sky130_fd_sc_hd__decap_3
XFILLER_59_140 VGND VGND VPWR VPWR sky130_fd_sc_hd__decap_3
XTAP_TAPCELL_ROW_129_887 VGND VPWR sky130_fd_sc_hd__tapvpwrvgnd_1
XPHY_EDGE_ROW_113_Left_296 VGND VGND VPWR VPWR sky130_fd_sc_hd__decap_3
XFILLER_15_210 VGND VGND VPWR VPWR sky130_fd_sc_hd__decap_3
XFILLER_74_187 VGND VGND VPWR VPWR sky130_fd_sc_hd__decap_3
XTAP_TAPCELL_ROW_13_422 VGND VPWR sky130_fd_sc_hd__tapvpwrvgnd_1
XFILLER_90_41 VGND VGND VPWR VPWR sky130_fd_sc_hd__decap_3
XFILLER_128_112 VGND VGND VPWR VPWR sky130_fd_sc_hd__decap_3
XFILLER_90_74 VGND VGND VPWR VPWR sky130_fd_sc_hd__decap_3
X_0700_ net128 net334 VGND VGND VPWR VPWR Tile_X0Y0_OpenRAM_top.Inst_OpenRAM_top_ConfigMem.Inst_frame0_bit22.Q
+ sky130_fd_sc_hd__dlxtp_1
XFILLER_143_104 VGND VGND VPWR VPWR sky130_fd_sc_hd__decap_3
XFILLER_128_156 VGND VGND VPWR VPWR sky130_fd_sc_hd__decap_3
XFILLER_143_137 VGND VGND VPWR VPWR sky130_fd_sc_hd__decap_3
XFILLER_128_189 VGND VGND VPWR VPWR sky130_fd_sc_hd__decap_3
XFILLER_99_72 VGND VGND VPWR VPWR sky130_fd_sc_hd__decap_3
X_0631_ Tile_X0Y1_OpenRAM_bot.Inst_OpenRAM_bot_ConfigMem.Inst_frame8_bit25.Q _0175_
+ Tile_X0Y1_OpenRAM_bot.Inst_OpenRAM_bot_ConfigMem.Inst_frame8_bit26.Q VGND VGND VPWR
+ VPWR _0176_ sky130_fd_sc_hd__a21bo_1
X_0562_ net255 net358 _0063_ net171 Tile_X0Y1_OpenRAM_bot.Inst_OpenRAM_bot_ConfigMem.Inst_frame1_bit18.Q
+ Tile_X0Y1_OpenRAM_bot.Inst_OpenRAM_bot_ConfigMem.Inst_frame1_bit19.Q VGND VGND VPWR
+ VPWR _0151_ sky130_fd_sc_hd__mux4_2
XFILLER_97_213 VGND VGND VPWR VPWR sky130_fd_sc_hd__decap_3
X_0493_ net66 Tile_X0Y0_OpenRAM_top.Inst_OpenRAM_top_ConfigMem.Inst_frame6_bit8.Q
+ Tile_X0Y0_OpenRAM_top.Inst_OpenRAM_top_ConfigMem.Inst_frame6_bit9.Q VGND VGND VPWR
+ VPWR _0133_ sky130_fd_sc_hd__o21ba_1
XPHY_EDGE_ROW_119_Right_119 VGND VGND VPWR VPWR sky130_fd_sc_hd__decap_3
X_1114_ net225 net299 VGND VGND VPWR VPWR Tile_X0Y1_OpenRAM_bot.Inst_OpenRAM_bot_ConfigMem.Inst_frame4_bit12.Q
+ sky130_fd_sc_hd__dlxtp_1
XFILLER_65_143 VGND VGND VPWR VPWR sky130_fd_sc_hd__decap_3
XTAP_TAPCELL_ROW_36_514 VGND VPWR sky130_fd_sc_hd__tapvpwrvgnd_1
X_1045_ net230 net313 VGND VGND VPWR VPWR Tile_X0Y1_OpenRAM_bot.Inst_OpenRAM_bot_ConfigMem.Inst_frame2_bit17.Q
+ sky130_fd_sc_hd__dlxtp_1
XFILLER_110_29 VGND VGND VPWR VPWR sky130_fd_sc_hd__decap_3
XFILLER_110_18 VGND VGND VPWR VPWR sky130_fd_sc_hd__decap_3
XFILLER_166_218 VGND VGND VPWR VPWR sky130_fd_sc_hd__decap_3
XFILLER_9_81 VGND VGND VPWR VPWR sky130_fd_sc_hd__decap_3
XFILLER_119_16 VGND VGND VPWR VPWR sky130_fd_sc_hd__fill_1
XFILLER_119_38 VGND VGND VPWR VPWR sky130_fd_sc_hd__decap_3
XFILLER_134_137 VGND VGND VPWR VPWR sky130_fd_sc_hd__decap_3
XFILLER_119_189 VGND VGND VPWR VPWR sky130_fd_sc_hd__decap_3
X_0829_ net127 net301 VGND VGND VPWR VPWR Tile_X0Y0_OpenRAM_top.Inst_OpenRAM_top_ConfigMem.Inst_frame4_bit21.Q
+ sky130_fd_sc_hd__dlxtp_1
XFILLER_134_159 VGND VGND VPWR VPWR sky130_fd_sc_hd__decap_3
XFILLER_135_26 VGND VGND VPWR VPWR sky130_fd_sc_hd__decap_3
XFILLER_88_224 VGND VGND VPWR VPWR sky130_fd_sc_hd__decap_3
XFILLER_135_48 VGND VGND VPWR VPWR sky130_fd_sc_hd__decap_3
XFILLER_0_139 VGND VGND VPWR VPWR sky130_fd_sc_hd__fill_1
XTAP_TAPCELL_ROW_59_606 VGND VPWR sky130_fd_sc_hd__tapvpwrvgnd_1
XFILLER_56_110 VGND VGND VPWR VPWR sky130_fd_sc_hd__decap_3
XFILLER_56_154 VGND VGND VPWR VPWR sky130_fd_sc_hd__decap_3
XFILLER_178_6 VGND VGND VPWR VPWR sky130_fd_sc_hd__decap_3
XFILLER_151_69 VGND VGND VPWR VPWR sky130_fd_sc_hd__decap_3
XFILLER_56_187 VGND VGND VPWR VPWR sky130_fd_sc_hd__fill_2
XFILLER_71_113 VGND VGND VPWR VPWR sky130_fd_sc_hd__fill_1
XFILLER_44_23 VGND VGND VPWR VPWR sky130_fd_sc_hd__decap_3
XFILLER_12_224 VGND VGND VPWR VPWR sky130_fd_sc_hd__decap_3
XTAP_TAPCELL_ROW_42_539 VGND VPWR sky130_fd_sc_hd__tapvpwrvgnd_1
XFILLER_44_78 VGND VGND VPWR VPWR sky130_fd_sc_hd__decap_3
XFILLER_157_229 VGND VGND VPWR VPWR sky130_fd_sc_hd__fill_1
XFILLER_100_73 VGND VGND VPWR VPWR sky130_fd_sc_hd__decap_3
XFILLER_8_206 VGND VGND VPWR VPWR sky130_fd_sc_hd__decap_3
XTAP_TAPCELL_ROW_50_572 VGND VPWR sky130_fd_sc_hd__tapvpwrvgnd_1
XFILLER_60_55 VGND VGND VPWR VPWR sky130_fd_sc_hd__decap_3
XFILLER_176_44 VGND VGND VPWR VPWR sky130_fd_sc_hd__decap_3
XFILLER_180_221 VGND VGND VPWR VPWR sky130_fd_sc_hd__decap_3
XFILLER_176_88 VGND VGND VPWR VPWR sky130_fd_sc_hd__decap_3
XFILLER_176_77 VGND VGND VPWR VPWR sky130_fd_sc_hd__decap_3
XFILLER_125_137 VGND VGND VPWR VPWR sky130_fd_sc_hd__decap_3
XFILLER_125_159 VGND VGND VPWR VPWR sky130_fd_sc_hd__decap_3
XFILLER_109_60 VGND VGND VPWR VPWR sky130_fd_sc_hd__decap_3
XFILLER_5_39 VGND VGND VPWR VPWR sky130_fd_sc_hd__decap_3
XFILLER_79_202 VGND VGND VPWR VPWR sky130_fd_sc_hd__decap_3
XFILLER_133_181 VGND VGND VPWR VPWR sky130_fd_sc_hd__decap_3
XFILLER_69_97 VGND VGND VPWR VPWR sky130_fd_sc_hd__decap_3
XPHY_EDGE_ROW_121_Left_304 VGND VGND VPWR VPWR sky130_fd_sc_hd__decap_3
XFILLER_10_9 VGND VGND VPWR VPWR sky130_fd_sc_hd__decap_3
XFILLER_85_30 VGND VGND VPWR VPWR sky130_fd_sc_hd__decap_3
XFILLER_47_165 VGND VGND VPWR VPWR sky130_fd_sc_hd__decap_3
XFILLER_47_187 VGND VGND VPWR VPWR sky130_fd_sc_hd__decap_3
XFILLER_62_168 VGND VGND VPWR VPWR sky130_fd_sc_hd__decap_3
XTAP_TAPCELL_ROW_73_664 VGND VPWR sky130_fd_sc_hd__tapvpwrvgnd_1
XFILLER_70_190 VGND VGND VPWR VPWR sky130_fd_sc_hd__decap_3
XFILLER_93_6 VGND VGND VPWR VPWR sky130_fd_sc_hd__decap_3
XPHY_EDGE_ROW_130_Left_313 VGND VGND VPWR VPWR sky130_fd_sc_hd__decap_3
XFILLER_116_137 VGND VGND VPWR VPWR sky130_fd_sc_hd__decap_3
XFILLER_116_159 VGND VGND VPWR VPWR sky130_fd_sc_hd__decap_3
X_0614_ net176 net218 net211 Tile_X0Y1_OpenRAM_bot.Inst_OpenRAM_bot_switch_matrix.J_NS4_BEG14
+ Tile_X0Y1_OpenRAM_bot.Inst_OpenRAM_bot_ConfigMem.Inst_frame2_bit24.Q Tile_X0Y1_OpenRAM_bot.Inst_OpenRAM_bot_ConfigMem.Inst_frame2_bit25.Q
+ VGND VGND VPWR VPWR net391 sky130_fd_sc_hd__mux4_2
X_0545_ net9 net41 net263 _0087_ Tile_X0Y1_OpenRAM_bot.Inst_OpenRAM_bot_ConfigMem.Inst_frame5_bit14.Q
+ Tile_X0Y1_OpenRAM_bot.Inst_OpenRAM_bot_ConfigMem.Inst_frame5_bit15.Q VGND VGND VPWR
+ VPWR Tile_X0Y1_OpenRAM_bot.Inst_OpenRAM_bot_switch_matrix.W2BEGb7 sky130_fd_sc_hd__mux4_1
X_0476_ net105 Tile_X0Y0_OpenRAM_top.Inst_OpenRAM_top_ConfigMem.Inst_frame7_bit7.Q
+ VGND VGND VPWR VPWR _0119_ sky130_fd_sc_hd__nand2b_1
XFILLER_105_18 VGND VGND VPWR VPWR sky130_fd_sc_hd__decap_3
XPHY_EDGE_ROW_7_Right_7 VGND VGND VPWR VPWR sky130_fd_sc_hd__decap_3
XFILLER_85_205 VGND VGND VPWR VPWR sky130_fd_sc_hd__decap_3
XTAP_TAPCELL_ROW_108_802 VGND VPWR sky130_fd_sc_hd__tapvpwrvgnd_1
XFILLER_38_132 VGND VGND VPWR VPWR sky130_fd_sc_hd__decap_3
XTAP_TAPCELL_ROW_96_756 VGND VPWR sky130_fd_sc_hd__tapvpwrvgnd_1
XFILLER_121_39 VGND VGND VPWR VPWR sky130_fd_sc_hd__decap_3
XFILLER_53_135 VGND VGND VPWR VPWR sky130_fd_sc_hd__decap_3
X_1028_ net244 net325 VGND VGND VPWR VPWR Tile_X0Y1_OpenRAM_bot.Inst_OpenRAM_bot_ConfigMem.Inst_frame1_bit2.Q
+ sky130_fd_sc_hd__dlxtp_1
XFILLER_139_207 VGND VGND VPWR VPWR sky130_fd_sc_hd__decap_3
XFILLER_14_48 VGND VGND VPWR VPWR sky130_fd_sc_hd__decap_3
XFILLER_107_137 VGND VGND VPWR VPWR sky130_fd_sc_hd__decap_3
XFILLER_30_47 VGND VGND VPWR VPWR sky130_fd_sc_hd__decap_3
XFILLER_146_25 VGND VGND VPWR VPWR sky130_fd_sc_hd__decap_3
XFILLER_122_118 VGND VGND VPWR VPWR sky130_fd_sc_hd__decap_3
XFILLER_162_24 VGND VGND VPWR VPWR sky130_fd_sc_hd__decap_3
XFILLER_162_68 VGND VGND VPWR VPWR sky130_fd_sc_hd__decap_3
XFILLER_39_78 VGND VGND VPWR VPWR sky130_fd_sc_hd__decap_3
XFILLER_91_208 VGND VGND VPWR VPWR sky130_fd_sc_hd__decap_3
XFILLER_176_3 VGND VGND VPWR VPWR sky130_fd_sc_hd__decap_3
XTAP_TAPCELL_ROW_114_827 VGND VPWR sky130_fd_sc_hd__tapvpwrvgnd_1
XFILLER_44_124 VGND VGND VPWR VPWR sky130_fd_sc_hd__decap_3
XFILLER_55_55 VGND VGND VPWR VPWR sky130_fd_sc_hd__fill_1
XFILLER_55_66 VGND VGND VPWR VPWR sky130_fd_sc_hd__decap_3
XTAP_TAPCELL_ROW_122_860 VGND VPWR sky130_fd_sc_hd__tapvpwrvgnd_1
XFILLER_111_72 VGND VGND VPWR VPWR sky130_fd_sc_hd__decap_3
XFILLER_71_21 VGND VGND VPWR VPWR sky130_fd_sc_hd__decap_3
XFILLER_111_94 VGND VGND VPWR VPWR sky130_fd_sc_hd__decap_3
XFILLER_71_54 VGND VGND VPWR VPWR sky130_fd_sc_hd__fill_2
XFILLER_136_80 VGND VGND VPWR VPWR sky130_fd_sc_hd__decap_3
XFILLER_20_91 VGND VGND VPWR VPWR sky130_fd_sc_hd__decap_3
XFILLER_20_80 VGND VGND VPWR VPWR sky130_fd_sc_hd__decap_3
XFILLER_136_91 VGND VGND VPWR VPWR sky130_fd_sc_hd__fill_1
XFILLER_121_140 VGND VGND VPWR VPWR sky130_fd_sc_hd__decap_3
X_0330_ net191 net201 net183 _0082_ Tile_X0Y1_OpenRAM_bot.Inst_OpenRAM_bot_ConfigMem.Inst_frame8_bit13.Q
+ Tile_X0Y1_OpenRAM_bot.Inst_OpenRAM_bot_ConfigMem.Inst_frame8_bit12.Q VGND VGND VPWR
+ VPWR Tile_X0Y0_OpenRAM_top.Inst_OpenRAM_top_switch_matrix.N2BEGb2 sky130_fd_sc_hd__mux4_1
XTAP_TAPCELL_ROW_137_919 VGND VPWR sky130_fd_sc_hd__tapvpwrvgnd_1
XFILLER_121_184 VGND VGND VPWR VPWR sky130_fd_sc_hd__decap_3
X_0261_ Tile_X0Y1_OpenRAM_bot.Inst_OpenRAM_bot_ConfigMem.Inst_frame3_bit10.Q Tile_X0Y0_OpenRAM_top.Inst_OpenRAM_top_switch_matrix.S2BEG0
+ Tile_X0Y1_OpenRAM_bot.Inst_OpenRAM_bot_ConfigMem.Inst_frame3_bit9.Q VGND VGND VPWR
+ VPWR _0031_ sky130_fd_sc_hd__or3b_1
XTAP_TAPCELL_ROW_145_952 VGND VPWR sky130_fd_sc_hd__tapvpwrvgnd_1
XFILLER_35_102 VGND VGND VPWR VPWR sky130_fd_sc_hd__decap_3
XFILLER_35_113 VGND VGND VPWR VPWR sky130_fd_sc_hd__decap_3
XFILLER_35_146 VGND VGND VPWR VPWR sky130_fd_sc_hd__decap_3
XFILLER_50_138 VGND VGND VPWR VPWR sky130_fd_sc_hd__fill_2
XFILLER_91_3 VGND VGND VPWR VPWR sky130_fd_sc_hd__decap_3
XFILLER_144_221 VGND VGND VPWR VPWR sky130_fd_sc_hd__decap_3
XFILLER_104_107 VGND VGND VPWR VPWR sky130_fd_sc_hd__decap_3
XFILLER_6_71 VGND VGND VPWR VPWR sky130_fd_sc_hd__decap_3
XPHY_EDGE_ROW_171_Right_171 VGND VGND VPWR VPWR sky130_fd_sc_hd__decap_3
X_0528_ net339 net14 _0070_ net46 Tile_X0Y1_OpenRAM_bot.Inst_OpenRAM_bot_ConfigMem.Inst_frame6_bit13.Q
+ Tile_X0Y1_OpenRAM_bot.Inst_OpenRAM_bot_ConfigMem.Inst_frame6_bit12.Q VGND VGND VPWR
+ VPWR Tile_X0Y1_OpenRAM_bot.Inst_OpenRAM_bot_switch_matrix.W1BEG2 sky130_fd_sc_hd__mux4_1
XFILLER_112_195 VGND VGND VPWR VPWR sky130_fd_sc_hd__fill_1
XFILLER_112_162 VGND VGND VPWR VPWR sky130_fd_sc_hd__decap_3
XFILLER_58_227 VGND VGND VPWR VPWR sky130_fd_sc_hd__decap_3
X_0459_ _0106_ Tile_X0Y0_OpenRAM_top.Inst_OpenRAM_top_ConfigMem.Inst_frame1_bit1.Q
+ _0009_ _0105_ VGND VGND VPWR VPWR net377 sky130_fd_sc_hd__a2bb2o_1
XFILLER_132_38 VGND VGND VPWR VPWR sky130_fd_sc_hd__decap_3
XFILLER_26_113 VGND VGND VPWR VPWR sky130_fd_sc_hd__decap_3
XFILLER_25_36 VGND VGND VPWR VPWR sky130_fd_sc_hd__decap_3
XTAP_TAPCELL_ROW_151_977 VGND VPWR sky130_fd_sc_hd__tapvpwrvgnd_1
XFILLER_41_116 VGND VGND VPWR VPWR sky130_fd_sc_hd__decap_3
XFILLER_41_149 VGND VGND VPWR VPWR sky130_fd_sc_hd__decap_3
XFILLER_41_57 VGND VGND VPWR VPWR sky130_fd_sc_hd__decap_3
XFILLER_157_57 VGND VGND VPWR VPWR sky130_fd_sc_hd__decap_3
XFILLER_135_221 VGND VGND VPWR VPWR sky130_fd_sc_hd__decap_3
XFILLER_173_12 VGND VGND VPWR VPWR sky130_fd_sc_hd__decap_3
XFILLER_150_224 VGND VGND VPWR VPWR sky130_fd_sc_hd__decap_3
XFILLER_1_223 VGND VGND VPWR VPWR sky130_fd_sc_hd__fill_1
XFILLER_173_78 VGND VGND VPWR VPWR sky130_fd_sc_hd__decap_3
XFILLER_173_45 VGND VGND VPWR VPWR sky130_fd_sc_hd__decap_3
XFILLER_106_50 VGND VGND VPWR VPWR sky130_fd_sc_hd__decap_3
XFILLER_103_184 VGND VGND VPWR VPWR sky130_fd_sc_hd__decap_3
XFILLER_2_18 VGND VGND VPWR VPWR sky130_fd_sc_hd__decap_3
XFILLER_2_29 VGND VGND VPWR VPWR sky130_fd_sc_hd__fill_2
XFILLER_49_216 VGND VGND VPWR VPWR sky130_fd_sc_hd__decap_3
XFILLER_106_94 VGND VGND VPWR VPWR sky130_fd_sc_hd__decap_3
XFILLER_106_83 VGND VGND VPWR VPWR sky130_fd_sc_hd__fill_1
XFILLER_66_32 VGND VGND VPWR VPWR sky130_fd_sc_hd__decap_3
XFILLER_17_113 VGND VGND VPWR VPWR sky130_fd_sc_hd__decap_3
XFILLER_122_71 VGND VGND VPWR VPWR sky130_fd_sc_hd__decap_3
XFILLER_32_127 VGND VGND VPWR VPWR sky130_fd_sc_hd__decap_3
XFILLER_82_53 VGND VGND VPWR VPWR sky130_fd_sc_hd__fill_1
XFILLER_82_64 VGND VGND VPWR VPWR sky130_fd_sc_hd__decap_3
XFILLER_25_190 VGND VGND VPWR VPWR sky130_fd_sc_hd__decap_3
XFILLER_15_91 VGND VGND VPWR VPWR sky130_fd_sc_hd__decap_3
XFILLER_40_171 VGND VGND VPWR VPWR sky130_fd_sc_hd__decap_3
XFILLER_99_116 VGND VGND VPWR VPWR sky130_fd_sc_hd__decap_3
XFILLER_99_105 VGND VGND VPWR VPWR sky130_fd_sc_hd__decap_3
X_1500_ Tile_X0Y1_OpenRAM_bot.Inst_OpenRAM_bot_switch_matrix.WW4BEG6 VGND VGND VPWR
+ VPWR net666 sky130_fd_sc_hd__buf_1
XFILLER_147_90 VGND VGND VPWR VPWR sky130_fd_sc_hd__decap_3
XFILLER_99_138 VGND VGND VPWR VPWR sky130_fd_sc_hd__decap_3
X_1431_ Tile_X0Y1_OpenRAM_bot.Inst_OpenRAM_bot_switch_matrix.S2BEG1 VGND VGND VPWR
+ VPWR net591 sky130_fd_sc_hd__buf_4
X_1362_ Tile_X0Y0_OpenRAM_top.Inst_OpenRAM_top_switch_matrix.W2BEGb4 VGND VGND VPWR
+ VPWR net522 sky130_fd_sc_hd__clkbuf_2
X_0313_ net149 Tile_X0Y0_OpenRAM_top.Inst_OpenRAM_top_ConfigMem.Inst_frame0_bit31.Q
+ VGND VGND VPWR VPWR _0075_ sky130_fd_sc_hd__nand2_1
X_1293_ net303 VGND VGND VPWR VPWR net463 sky130_fd_sc_hd__clkbuf_2
Xinput190 Tile_X0Y1_E2MID[4] VGND VGND VPWR VPWR net190 sky130_fd_sc_hd__buf_1
XFILLER_55_219 VGND VGND VPWR VPWR sky130_fd_sc_hd__decap_3
X_0244_ Tile_X0Y1_OpenRAM_bot.Inst_OpenRAM_bot_ConfigMem.Inst_frame0_bit24.Q VGND
+ VGND VPWR VPWR _0017_ sky130_fd_sc_hd__inv_2
XFILLER_23_116 VGND VGND VPWR VPWR sky130_fd_sc_hd__decap_3
XFILLER_176_121 VGND VGND VPWR VPWR sky130_fd_sc_hd__decap_3
XFILLER_31_160 VGND VGND VPWR VPWR sky130_fd_sc_hd__decap_3
XFILLER_176_165 VGND VGND VPWR VPWR sky130_fd_sc_hd__decap_3
XFILLER_31_193 VGND VGND VPWR VPWR sky130_fd_sc_hd__decap_3
XFILLER_117_221 VGND VGND VPWR VPWR sky130_fd_sc_hd__decap_3
XFILLER_11_49 VGND VGND VPWR VPWR sky130_fd_sc_hd__decap_3
XFILLER_11_16 VGND VGND VPWR VPWR sky130_fd_sc_hd__decap_3
XFILLER_127_49 VGND VGND VPWR VPWR sky130_fd_sc_hd__decap_3
Xfanout302 net303 VGND VGND VPWR VPWR net302 sky130_fd_sc_hd__buf_2
Xfanout313 net314 VGND VGND VPWR VPWR net313 sky130_fd_sc_hd__clkbuf_2
Xfanout335 net337 VGND VGND VPWR VPWR net335 sky130_fd_sc_hd__clkbuf_4
Xfanout324 net325 VGND VGND VPWR VPWR net324 sky130_fd_sc_hd__buf_1
XFILLER_143_48 VGND VGND VPWR VPWR sky130_fd_sc_hd__decap_3
XFILLER_100_121 VGND VGND VPWR VPWR sky130_fd_sc_hd__decap_3
XFILLER_100_165 VGND VGND VPWR VPWR sky130_fd_sc_hd__fill_1
XFILLER_100_187 VGND VGND VPWR VPWR sky130_fd_sc_hd__decap_3
XFILLER_36_35 VGND VGND VPWR VPWR sky130_fd_sc_hd__decap_3
XFILLER_36_68 VGND VGND VPWR VPWR sky130_fd_sc_hd__fill_2
XFILLER_168_56 VGND VGND VPWR VPWR sky130_fd_sc_hd__decap_3
XFILLER_167_165 VGND VGND VPWR VPWR sky130_fd_sc_hd__decap_3
XFILLER_182_113 VGND VGND VPWR VPWR sky130_fd_sc_hd__fill_2
XFILLER_167_187 VGND VGND VPWR VPWR sky130_fd_sc_hd__decap_3
XFILLER_108_221 VGND VGND VPWR VPWR sky130_fd_sc_hd__decap_3
XFILLER_123_202 VGND VGND VPWR VPWR sky130_fd_sc_hd__decap_3
XFILLER_117_60 VGND VGND VPWR VPWR sky130_fd_sc_hd__decap_3
XFILLER_96_108 VGND VGND VPWR VPWR sky130_fd_sc_hd__decap_3
XFILLER_77_42 VGND VGND VPWR VPWR sky130_fd_sc_hd__decap_3
XFILLER_77_75 VGND VGND VPWR VPWR sky130_fd_sc_hd__fill_1
XFILLER_77_97 VGND VGND VPWR VPWR sky130_fd_sc_hd__decap_3
XFILLER_37_208 VGND VGND VPWR VPWR sky130_fd_sc_hd__decap_3
XFILLER_133_81 VGND VGND VPWR VPWR sky130_fd_sc_hd__decap_3
XTAP_TAPCELL_ROW_5_392 VGND VPWR sky130_fd_sc_hd__tapvpwrvgnd_1
XFILLER_93_30 VGND VGND VPWR VPWR sky130_fd_sc_hd__decap_3
XFILLER_93_74 VGND VGND VPWR VPWR sky130_fd_sc_hd__decap_3
XTAP_TAPCELL_ROW_28_483 VGND VPWR sky130_fd_sc_hd__tapvpwrvgnd_1
X_0931_ net120 net274 VGND VGND VPWR VPWR Tile_X0Y0_OpenRAM_top.Inst_OpenRAM_top_ConfigMem.Inst_frame7_bit15.Q
+ sky130_fd_sc_hd__dlxtp_1
XFILLER_13_193 VGND VGND VPWR VPWR sky130_fd_sc_hd__decap_3
XFILLER_9_131 VGND VGND VPWR VPWR sky130_fd_sc_hd__decap_3
XFILLER_173_113 VGND VGND VPWR VPWR sky130_fd_sc_hd__decap_3
XFILLER_173_102 VGND VGND VPWR VPWR sky130_fd_sc_hd__decap_3
X_0862_ net126 net292 VGND VGND VPWR VPWR Tile_X0Y0_OpenRAM_top.Inst_OpenRAM_top_ConfigMem.Inst_frame5_bit20.Q
+ sky130_fd_sc_hd__dlxtp_1
XFILLER_9_175 VGND VGND VPWR VPWR sky130_fd_sc_hd__decap_3
XFILLER_9_164 VGND VGND VPWR VPWR sky130_fd_sc_hd__decap_3
XFILLER_173_146 VGND VGND VPWR VPWR sky130_fd_sc_hd__decap_3
X_0793_ net131 net309 VGND VGND VPWR VPWR Tile_X0Y0_OpenRAM_top.Inst_OpenRAM_top_ConfigMem.Inst_frame3_bit25.Q
+ sky130_fd_sc_hd__dlxtp_1
XFILLER_114_224 VGND VGND VPWR VPWR sky130_fd_sc_hd__decap_3
XFILLER_87_108 VGND VGND VPWR VPWR sky130_fd_sc_hd__decap_3
X_1414_ net234 VGND VGND VPWR VPWR net566 sky130_fd_sc_hd__buf_4
XFILLER_87_119 VGND VGND VPWR VPWR sky130_fd_sc_hd__decap_3
XFILLER_3_72 VGND VGND VPWR VPWR sky130_fd_sc_hd__decap_3
X_1345_ clknet_1_0__leaf_Tile_X0Y1_UserCLK VGND VGND VPWR VPWR net505 sky130_fd_sc_hd__buf_2
XFILLER_95_130 VGND VGND VPWR VPWR sky130_fd_sc_hd__decap_3
X_1276_ net124 VGND VGND VPWR VPWR net427 sky130_fd_sc_hd__clkbuf_1
X_0227_ net1 VGND VGND VPWR VPWR _0000_ sky130_fd_sc_hd__inv_2
XFILLER_51_211 VGND VGND VPWR VPWR sky130_fd_sc_hd__decap_3
XTAP_TAPCELL_ROW_159_1007 VGND VPWR sky130_fd_sc_hd__tapvpwrvgnd_1
XFILLER_11_119 VGND VGND VPWR VPWR sky130_fd_sc_hd__decap_3
XFILLER_11_108 VGND VGND VPWR VPWR sky130_fd_sc_hd__decap_3
XFILLER_149_143 VGND VGND VPWR VPWR sky130_fd_sc_hd__decap_3
XFILLER_149_187 VGND VGND VPWR VPWR sky130_fd_sc_hd__fill_1
XFILLER_22_26 VGND VGND VPWR VPWR sky130_fd_sc_hd__fill_2
XFILLER_22_37 VGND VGND VPWR VPWR sky130_fd_sc_hd__decap_3
XFILLER_105_202 VGND VGND VPWR VPWR sky130_fd_sc_hd__decap_3
Xoutput450 net533 VGND VGND VPWR VPWR Tile_X0Y0_W6BEG[5] sky130_fd_sc_hd__buf_2
Xoutput461 net544 VGND VGND VPWR VPWR Tile_X0Y0_WW4BEG[15] sky130_fd_sc_hd__buf_2
XFILLER_78_108 VGND VGND VPWR VPWR sky130_fd_sc_hd__decap_3
Xoutput494 net577 VGND VGND VPWR VPWR Tile_X0Y1_FrameData_O[30] sky130_fd_sc_hd__buf_2
Xoutput483 net566 VGND VGND VPWR VPWR Tile_X0Y1_FrameData_O[20] sky130_fd_sc_hd__buf_2
Xoutput472 net555 VGND VGND VPWR VPWR Tile_X0Y1_FrameData_O[10] sky130_fd_sc_hd__buf_2
XFILLER_86_130 VGND VGND VPWR VPWR sky130_fd_sc_hd__decap_3
XFILLER_170_24 VGND VGND VPWR VPWR sky130_fd_sc_hd__decap_3
XFILLER_19_208 VGND VGND VPWR VPWR sky130_fd_sc_hd__decap_3
XFILLER_86_174 VGND VGND VPWR VPWR sky130_fd_sc_hd__decap_3
XFILLER_170_35 VGND VGND VPWR VPWR sky130_fd_sc_hd__decap_3
XFILLER_47_78 VGND VGND VPWR VPWR sky130_fd_sc_hd__decap_3
XFILLER_170_68 VGND VGND VPWR VPWR sky130_fd_sc_hd__decap_3
XFILLER_103_73 VGND VGND VPWR VPWR sky130_fd_sc_hd__fill_1
XFILLER_42_200 VGND VGND VPWR VPWR sky130_fd_sc_hd__decap_3
XFILLER_179_33 VGND VGND VPWR VPWR sky130_fd_sc_hd__decap_3
XFILLER_103_95 VGND VGND VPWR VPWR sky130_fd_sc_hd__decap_3
XFILLER_63_55 VGND VGND VPWR VPWR sky130_fd_sc_hd__fill_1
XFILLER_63_66 VGND VGND VPWR VPWR sky130_fd_sc_hd__decap_3
XFILLER_179_66 VGND VGND VPWR VPWR sky130_fd_sc_hd__decap_3
XFILLER_63_88 VGND VGND VPWR VPWR sky130_fd_sc_hd__decap_3
XFILLER_179_99 VGND VGND VPWR VPWR sky130_fd_sc_hd__decap_3
XFILLER_155_113 VGND VGND VPWR VPWR sky130_fd_sc_hd__decap_3
XFILLER_155_102 VGND VGND VPWR VPWR sky130_fd_sc_hd__decap_3
XFILLER_10_141 VGND VGND VPWR VPWR sky130_fd_sc_hd__decap_3
XFILLER_10_130 VGND VGND VPWR VPWR sky130_fd_sc_hd__decap_3
XFILLER_10_174 VGND VGND VPWR VPWR sky130_fd_sc_hd__decap_3
XFILLER_6_112 VGND VGND VPWR VPWR sky130_fd_sc_hd__decap_3
XFILLER_6_156 VGND VGND VPWR VPWR sky130_fd_sc_hd__decap_3
XFILLER_170_127 VGND VGND VPWR VPWR sky130_fd_sc_hd__decap_3
XFILLER_128_70 VGND VGND VPWR VPWR sky130_fd_sc_hd__fill_2
XFILLER_6_189 VGND VGND VPWR VPWR sky130_fd_sc_hd__decap_3
XFILLER_163_190 VGND VGND VPWR VPWR sky130_fd_sc_hd__decap_3
XFILLER_88_41 VGND VGND VPWR VPWR sky130_fd_sc_hd__decap_3
XFILLER_88_74 VGND VGND VPWR VPWR sky130_fd_sc_hd__decap_3
XFILLER_88_85 VGND VGND VPWR VPWR sky130_fd_sc_hd__fill_1
X_1130_ net242 net289 VGND VGND VPWR VPWR Tile_X0Y1_OpenRAM_bot.Inst_OpenRAM_bot_ConfigMem.Inst_frame5_bit28.Q
+ sky130_fd_sc_hd__dlxtp_1
XFILLER_77_196 VGND VGND VPWR VPWR sky130_fd_sc_hd__decap_3
XFILLER_92_133 VGND VGND VPWR VPWR sky130_fd_sc_hd__decap_3
X_1061_ net233 net313 VGND VGND VPWR VPWR Tile_X0Y1_OpenRAM_bot.Inst_OpenRAM_bot_ConfigMem.Inst_frame2_bit1.Q
+ sky130_fd_sc_hd__dlxtp_1
XFILLER_92_144 VGND VGND VPWR VPWR sky130_fd_sc_hd__decap_3
XFILLER_33_211 VGND VGND VPWR VPWR sky130_fd_sc_hd__decap_3
XFILLER_92_177 VGND VGND VPWR VPWR sky130_fd_sc_hd__decap_3
XFILLER_178_227 VGND VGND VPWR VPWR sky130_fd_sc_hd__decap_3
X_0914_ net114 net285 VGND VGND VPWR VPWR Tile_X0Y0_OpenRAM_top.Inst_OpenRAM_top_ConfigMem.Inst_frame6_bit0.Q
+ sky130_fd_sc_hd__dlxtp_1
XFILLER_146_135 VGND VGND VPWR VPWR sky130_fd_sc_hd__decap_3
X_0845_ net141 net302 VGND VGND VPWR VPWR Tile_X0Y0_OpenRAM_top.Inst_OpenRAM_top_ConfigMem.Inst_frame4_bit5.Q
+ sky130_fd_sc_hd__dlxtp_1
XFILLER_146_168 VGND VGND VPWR VPWR sky130_fd_sc_hd__decap_3
XFILLER_161_116 VGND VGND VPWR VPWR sky130_fd_sc_hd__decap_3
X_0776_ net115 net320 VGND VGND VPWR VPWR Tile_X0Y0_OpenRAM_top.Inst_OpenRAM_top_ConfigMem.Inst_frame2_bit10.Q
+ sky130_fd_sc_hd__dlxtp_1
XTAP_TAPCELL_ROW_165_1033 VGND VPWR sky130_fd_sc_hd__tapvpwrvgnd_1
XFILLER_68_141 VGND VGND VPWR VPWR sky130_fd_sc_hd__decap_3
XFILLER_68_174 VGND VGND VPWR VPWR sky130_fd_sc_hd__decap_3
XFILLER_83_111 VGND VGND VPWR VPWR sky130_fd_sc_hd__fill_1
XFILLER_83_122 VGND VGND VPWR VPWR sky130_fd_sc_hd__decap_3
X_1328_ Tile_X0Y0_OpenRAM_top.Inst_OpenRAM_top_switch_matrix.N2BEGb7 VGND VGND VPWR
+ VPWR net488 sky130_fd_sc_hd__buf_2
X_1259_ net136 VGND VGND VPWR VPWR net439 sky130_fd_sc_hd__clkbuf_1
XFILLER_83_155 VGND VGND VPWR VPWR sky130_fd_sc_hd__decap_3
XFILLER_140_27 VGND VGND VPWR VPWR sky130_fd_sc_hd__fill_1
XFILLER_24_200 VGND VGND VPWR VPWR sky130_fd_sc_hd__decap_3
XFILLER_169_205 VGND VGND VPWR VPWR sky130_fd_sc_hd__decap_3
XTAP_TAPCELL_ROW_106_796 VGND VPWR sky130_fd_sc_hd__tapvpwrvgnd_1
XFILLER_149_25 VGND VGND VPWR VPWR sky130_fd_sc_hd__decap_3
XFILLER_33_47 VGND VGND VPWR VPWR sky130_fd_sc_hd__decap_3
XFILLER_33_69 VGND VGND VPWR VPWR sky130_fd_sc_hd__decap_3
XFILLER_137_135 VGND VGND VPWR VPWR sky130_fd_sc_hd__decap_3
XTAP_TAPCELL_ROW_172_1059 VGND VPWR sky130_fd_sc_hd__tapvpwrvgnd_1
XFILLER_165_24 VGND VGND VPWR VPWR sky130_fd_sc_hd__decap_3
XFILLER_152_138 VGND VGND VPWR VPWR sky130_fd_sc_hd__fill_2
XFILLER_165_57 VGND VGND VPWR VPWR sky130_fd_sc_hd__fill_2
XFILLER_3_137 VGND VGND VPWR VPWR sky130_fd_sc_hd__decap_3
XFILLER_160_171 VGND VGND VPWR VPWR sky130_fd_sc_hd__decap_3
XFILLER_181_12 VGND VGND VPWR VPWR sky130_fd_sc_hd__decap_3
Xoutput291 net374 VGND VGND VPWR VPWR ADDR_B_SRAM1 sky130_fd_sc_hd__buf_2
XFILLER_59_152 VGND VGND VPWR VPWR sky130_fd_sc_hd__decap_3
XTAP_TAPCELL_ROW_129_888 VGND VPWR sky130_fd_sc_hd__tapvpwrvgnd_1
XFILLER_114_94 VGND VGND VPWR VPWR sky130_fd_sc_hd__decap_3
XFILLER_114_83 VGND VGND VPWR VPWR sky130_fd_sc_hd__fill_1
XFILLER_74_144 VGND VGND VPWR VPWR sky130_fd_sc_hd__decap_3
XFILLER_74_166 VGND VGND VPWR VPWR sky130_fd_sc_hd__decap_3
XFILLER_15_222 VGND VGND VPWR VPWR sky130_fd_sc_hd__fill_2
XFILLER_30_203 VGND VGND VPWR VPWR sky130_fd_sc_hd__decap_3
XFILLER_175_208 VGND VGND VPWR VPWR sky130_fd_sc_hd__decap_3
XTAP_TAPCELL_ROW_13_423 VGND VPWR sky130_fd_sc_hd__tapvpwrvgnd_1
XFILLER_88_9 VGND VGND VPWR VPWR sky130_fd_sc_hd__decap_3
XFILLER_128_124 VGND VGND VPWR VPWR sky130_fd_sc_hd__decap_3
XFILLER_139_91 VGND VGND VPWR VPWR sky130_fd_sc_hd__decap_3
XFILLER_128_168 VGND VGND VPWR VPWR sky130_fd_sc_hd__decap_3
XFILLER_143_116 VGND VGND VPWR VPWR sky130_fd_sc_hd__decap_3
XFILLER_99_51 VGND VGND VPWR VPWR sky130_fd_sc_hd__decap_3
X_0630_ Tile_X0Y1_OpenRAM_bot.Inst_OpenRAM_bot_switch_matrix.J_NS4_BEG12 net263 Tile_X0Y1_OpenRAM_bot.Inst_OpenRAM_bot_ConfigMem.Inst_frame8_bit24.Q
+ VGND VGND VPWR VPWR _0175_ sky130_fd_sc_hd__mux2_1
XFILLER_143_149 VGND VGND VPWR VPWR sky130_fd_sc_hd__decap_3
XFILLER_99_84 VGND VGND VPWR VPWR sky130_fd_sc_hd__decap_3
X_0561_ net33 net65 _0150_ _0086_ Tile_X0Y1_OpenRAM_bot.Inst_OpenRAM_bot_ConfigMem.Inst_frame4_bit2.Q
+ Tile_X0Y1_OpenRAM_bot.Inst_OpenRAM_bot_ConfigMem.Inst_frame4_bit3.Q VGND VGND VPWR
+ VPWR Tile_X0Y1_OpenRAM_bot.Inst_OpenRAM_bot_switch_matrix.WW4BEG9 sky130_fd_sc_hd__mux4_1
XFILLER_97_225 VGND VGND VPWR VPWR sky130_fd_sc_hd__fill_1
X_0492_ net101 Tile_X0Y0_OpenRAM_top.Inst_OpenRAM_top_ConfigMem.Inst_frame6_bit8.Q
+ VGND VGND VPWR VPWR _0132_ sky130_fd_sc_hd__nand2b_1
XFILLER_151_193 VGND VGND VPWR VPWR sky130_fd_sc_hd__fill_1
XFILLER_2_192 VGND VGND VPWR VPWR sky130_fd_sc_hd__decap_3
XFILLER_65_111 VGND VGND VPWR VPWR sky130_fd_sc_hd__fill_1
XFILLER_65_122 VGND VGND VPWR VPWR sky130_fd_sc_hd__decap_3
X_1113_ net226 net299 VGND VGND VPWR VPWR Tile_X0Y1_OpenRAM_bot.Inst_OpenRAM_bot_ConfigMem.Inst_frame4_bit13.Q
+ sky130_fd_sc_hd__dlxtp_1
XFILLER_65_155 VGND VGND VPWR VPWR sky130_fd_sc_hd__decap_3
XTAP_TAPCELL_ROW_36_515 VGND VPWR sky130_fd_sc_hd__tapvpwrvgnd_1
X_1044_ net231 net312 VGND VGND VPWR VPWR Tile_X0Y1_OpenRAM_bot.Inst_OpenRAM_bot_ConfigMem.Inst_frame2_bit18.Q
+ sky130_fd_sc_hd__dlxtp_1
XFILLER_65_188 VGND VGND VPWR VPWR sky130_fd_sc_hd__decap_3
XFILLER_80_136 VGND VGND VPWR VPWR sky130_fd_sc_hd__decap_3
XFILLER_80_147 VGND VGND VPWR VPWR sky130_fd_sc_hd__fill_2
XFILLER_21_203 VGND VGND VPWR VPWR sky130_fd_sc_hd__fill_1
XFILLER_21_225 VGND VGND VPWR VPWR sky130_fd_sc_hd__fill_1
XFILLER_9_60 VGND VGND VPWR VPWR sky130_fd_sc_hd__decap_3
XFILLER_119_113 VGND VGND VPWR VPWR sky130_fd_sc_hd__fill_2
XFILLER_9_93 VGND VGND VPWR VPWR sky130_fd_sc_hd__decap_3
XFILLER_134_116 VGND VGND VPWR VPWR sky130_fd_sc_hd__decap_3
X_0828_ net128 net301 VGND VGND VPWR VPWR Tile_X0Y0_OpenRAM_top.Inst_OpenRAM_top_ConfigMem.Inst_frame4_bit22.Q
+ sky130_fd_sc_hd__dlxtp_1
XFILLER_127_190 VGND VGND VPWR VPWR sky130_fd_sc_hd__decap_3
X_0759_ net133 net316 VGND VGND VPWR VPWR Tile_X0Y0_OpenRAM_top.Inst_OpenRAM_top_ConfigMem.Inst_frame2_bit27.Q
+ sky130_fd_sc_hd__dlxtp_1
XFILLER_142_171 VGND VGND VPWR VPWR sky130_fd_sc_hd__decap_3
XFILLER_142_193 VGND VGND VPWR VPWR sky130_fd_sc_hd__decap_3
XTAP_TAPCELL_ROW_59_607 VGND VPWR sky130_fd_sc_hd__tapvpwrvgnd_1
XFILLER_56_100 VGND VGND VPWR VPWR sky130_fd_sc_hd__decap_3
XFILLER_28_69 VGND VGND VPWR VPWR sky130_fd_sc_hd__decap_3
XFILLER_56_144 VGND VGND VPWR VPWR sky130_fd_sc_hd__decap_3
XTAP_TAPCELL_ROW_67_640 VGND VPWR sky130_fd_sc_hd__tapvpwrvgnd_1
XFILLER_44_35 VGND VGND VPWR VPWR sky130_fd_sc_hd__decap_3
XTAP_TAPCELL_ROW_82_698 VGND VPWR sky130_fd_sc_hd__tapvpwrvgnd_1
XFILLER_157_208 VGND VGND VPWR VPWR sky130_fd_sc_hd__decap_3
XFILLER_100_52 VGND VGND VPWR VPWR sky130_fd_sc_hd__decap_3
XFILLER_8_218 VGND VGND VPWR VPWR sky130_fd_sc_hd__decap_3
XFILLER_176_12 VGND VGND VPWR VPWR sky130_fd_sc_hd__decap_3
XFILLER_100_85 VGND VGND VPWR VPWR sky130_fd_sc_hd__decap_3
XTAP_TAPCELL_ROW_50_573 VGND VPWR sky130_fd_sc_hd__tapvpwrvgnd_1
XFILLER_176_56 VGND VGND VPWR VPWR sky130_fd_sc_hd__decap_3
XFILLER_60_67 VGND VGND VPWR VPWR sky130_fd_sc_hd__decap_3
XFILLER_60_78 VGND VGND VPWR VPWR sky130_fd_sc_hd__decap_3
XFILLER_125_116 VGND VGND VPWR VPWR sky130_fd_sc_hd__decap_3
XFILLER_125_105 VGND VGND VPWR VPWR sky130_fd_sc_hd__decap_3
XFILLER_5_18 VGND VGND VPWR VPWR sky130_fd_sc_hd__decap_3
XFILLER_69_21 VGND VGND VPWR VPWR sky130_fd_sc_hd__fill_1
XFILLER_133_160 VGND VGND VPWR VPWR sky130_fd_sc_hd__decap_3
XFILLER_109_94 VGND VGND VPWR VPWR sky130_fd_sc_hd__fill_1
XFILLER_69_54 VGND VGND VPWR VPWR sky130_fd_sc_hd__fill_2
XFILLER_79_214 VGND VGND VPWR VPWR sky130_fd_sc_hd__decap_3
XFILLER_133_193 VGND VGND VPWR VPWR sky130_fd_sc_hd__decap_3
XFILLER_79_225 VGND VGND VPWR VPWR sky130_fd_sc_hd__fill_1
XFILLER_47_122 VGND VGND VPWR VPWR sky130_fd_sc_hd__decap_3
XFILLER_85_53 VGND VGND VPWR VPWR sky130_fd_sc_hd__decap_3
XFILLER_85_75 VGND VGND VPWR VPWR sky130_fd_sc_hd__decap_3
XFILLER_18_80 VGND VGND VPWR VPWR sky130_fd_sc_hd__decap_3
XFILLER_141_81 VGND VGND VPWR VPWR sky130_fd_sc_hd__decap_3
XFILLER_47_199 VGND VGND VPWR VPWR sky130_fd_sc_hd__decap_3
XFILLER_62_125 VGND VGND VPWR VPWR sky130_fd_sc_hd__decap_3
XTAP_TAPCELL_ROW_73_665 VGND VPWR sky130_fd_sc_hd__tapvpwrvgnd_1
XFILLER_86_6 VGND VGND VPWR VPWR sky130_fd_sc_hd__decap_3
XFILLER_171_211 VGND VGND VPWR VPWR sky130_fd_sc_hd__decap_3
XPHY_EDGE_ROW_152_Right_152 VGND VGND VPWR VPWR sky130_fd_sc_hd__decap_3
X_0613_ net175 net217 net210 Tile_X0Y1_OpenRAM_bot.Inst_OpenRAM_bot_switch_matrix.J_NS4_BEG13
+ Tile_X0Y1_OpenRAM_bot.Inst_OpenRAM_bot_ConfigMem.Inst_frame2_bit22.Q Tile_X0Y1_OpenRAM_bot.Inst_OpenRAM_bot_ConfigMem.Inst_frame2_bit23.Q
+ VGND VGND VPWR VPWR net390 sky130_fd_sc_hd__mux4_1
XFILLER_131_108 VGND VGND VPWR VPWR sky130_fd_sc_hd__decap_3
XFILLER_124_171 VGND VGND VPWR VPWR sky130_fd_sc_hd__fill_2
X_0544_ net8 net40 net262 _0086_ Tile_X0Y1_OpenRAM_bot.Inst_OpenRAM_bot_ConfigMem.Inst_frame5_bit12.Q
+ Tile_X0Y1_OpenRAM_bot.Inst_OpenRAM_bot_ConfigMem.Inst_frame5_bit13.Q VGND VGND VPWR
+ VPWR Tile_X0Y1_OpenRAM_bot.Inst_OpenRAM_bot_switch_matrix.W2BEGb6 sky130_fd_sc_hd__mux4_1
X_0475_ Tile_X0Y0_OpenRAM_top.Inst_OpenRAM_top_switch_matrix.J_NS4_BEG5 Tile_X0Y0_OpenRAM_top.Inst_OpenRAM_top_switch_matrix.J_NS4_BEG9
+ Tile_X0Y0_OpenRAM_top.Inst_OpenRAM_top_switch_matrix.J_NS4_BEG13 net258 Tile_X0Y0_OpenRAM_top.Inst_OpenRAM_top_ConfigMem.Inst_frame7_bit7.Q
+ Tile_X0Y0_OpenRAM_top.Inst_OpenRAM_top_ConfigMem.Inst_frame7_bit8.Q VGND VGND VPWR
+ VPWR _0118_ sky130_fd_sc_hd__mux4_1
XFILLER_85_217 VGND VGND VPWR VPWR sky130_fd_sc_hd__decap_3
XTAP_TAPCELL_ROW_108_803 VGND VPWR sky130_fd_sc_hd__tapvpwrvgnd_1
XFILLER_38_100 VGND VGND VPWR VPWR sky130_fd_sc_hd__decap_3
XFILLER_38_111 VGND VGND VPWR VPWR sky130_fd_sc_hd__decap_3
XFILLER_85_228 VGND VGND VPWR VPWR sky130_fd_sc_hd__fill_2
XTAP_TAPCELL_ROW_96_757 VGND VPWR sky130_fd_sc_hd__tapvpwrvgnd_1
XFILLER_38_144 VGND VGND VPWR VPWR sky130_fd_sc_hd__decap_3
XFILLER_53_169 VGND VGND VPWR VPWR sky130_fd_sc_hd__decap_3
X_1027_ net247 net325 VGND VGND VPWR VPWR Tile_X0Y1_OpenRAM_bot.Inst_OpenRAM_bot_ConfigMem.Inst_frame1_bit3.Q
+ sky130_fd_sc_hd__dlxtp_1
XFILLER_14_27 VGND VGND VPWR VPWR sky130_fd_sc_hd__fill_1
XFILLER_139_219 VGND VGND VPWR VPWR sky130_fd_sc_hd__decap_3
XTAP_TAPCELL_ROW_131_894 VGND VPWR sky130_fd_sc_hd__tapvpwrvgnd_1
XFILLER_162_211 VGND VGND VPWR VPWR sky130_fd_sc_hd__fill_1
XFILLER_30_59 VGND VGND VPWR VPWR sky130_fd_sc_hd__decap_3
XFILLER_115_193 VGND VGND VPWR VPWR sky130_fd_sc_hd__decap_3
XFILLER_130_141 VGND VGND VPWR VPWR sky130_fd_sc_hd__decap_3
XFILLER_39_57 VGND VGND VPWR VPWR sky130_fd_sc_hd__decap_3
XFILLER_162_47 VGND VGND VPWR VPWR sky130_fd_sc_hd__decap_3
XFILLER_29_166 VGND VGND VPWR VPWR sky130_fd_sc_hd__fill_2
XFILLER_44_103 VGND VGND VPWR VPWR sky130_fd_sc_hd__decap_3
XTAP_TAPCELL_ROW_154_986 VGND VPWR sky130_fd_sc_hd__tapvpwrvgnd_1
XTAP_TAPCELL_ROW_114_828 VGND VPWR sky130_fd_sc_hd__tapvpwrvgnd_1
XFILLER_44_136 VGND VGND VPWR VPWR sky130_fd_sc_hd__decap_3
XFILLER_55_89 VGND VGND VPWR VPWR sky130_fd_sc_hd__decap_3
XTAP_TAPCELL_ROW_122_861 VGND VPWR sky130_fd_sc_hd__tapvpwrvgnd_1
XFILLER_111_51 VGND VGND VPWR VPWR sky130_fd_sc_hd__decap_3
XPHY_EDGE_ROW_9_Left_192 VGND VGND VPWR VPWR sky130_fd_sc_hd__decap_3
XFILLER_111_84 VGND VGND VPWR VPWR sky130_fd_sc_hd__decap_3
XFILLER_71_33 VGND VGND VPWR VPWR sky130_fd_sc_hd__decap_3
XFILLER_71_66 VGND VGND VPWR VPWR sky130_fd_sc_hd__fill_1
XFILLER_71_88 VGND VGND VPWR VPWR sky130_fd_sc_hd__decap_3
XFILLER_4_221 VGND VGND VPWR VPWR sky130_fd_sc_hd__decap_3
XFILLER_113_119 VGND VGND VPWR VPWR sky130_fd_sc_hd__decap_3
XFILLER_106_171 VGND VGND VPWR VPWR sky130_fd_sc_hd__decap_3
XFILLER_121_152 VGND VGND VPWR VPWR sky130_fd_sc_hd__decap_3
X_0260_ Tile_X0Y0_OpenRAM_top.Inst_OpenRAM_top_switch_matrix.N2BEGb0 net158 net349
+ net150 Tile_X0Y0_OpenRAM_top.Inst_OpenRAM_top_ConfigMem.Inst_frame0_bit9.Q Tile_X0Y0_OpenRAM_top.Inst_OpenRAM_top_ConfigMem.Inst_frame0_bit8.Q
+ VGND VGND VPWR VPWR Tile_X0Y0_OpenRAM_top.Inst_OpenRAM_top_switch_matrix.J_NS2_BEG0
+ sky130_fd_sc_hd__mux4_2
XFILLER_96_85 VGND VGND VPWR VPWR sky130_fd_sc_hd__fill_1
XFILLER_121_196 VGND VGND VPWR VPWR sky130_fd_sc_hd__decap_3
XFILLER_152_91 VGND VGND VPWR VPWR sky130_fd_sc_hd__decap_3
XFILLER_152_80 VGND VGND VPWR VPWR sky130_fd_sc_hd__decap_3
XTAP_TAPCELL_ROW_145_953 VGND VPWR sky130_fd_sc_hd__tapvpwrvgnd_1
XFILLER_35_158 VGND VGND VPWR VPWR sky130_fd_sc_hd__decap_3
XFILLER_50_106 VGND VGND VPWR VPWR sky130_fd_sc_hd__decap_3
XFILLER_84_3 VGND VGND VPWR VPWR sky130_fd_sc_hd__decap_3
XFILLER_144_200 VGND VGND VPWR VPWR sky130_fd_sc_hd__decap_3
XFILLER_6_50 VGND VGND VPWR VPWR sky130_fd_sc_hd__decap_3
XFILLER_104_119 VGND VGND VPWR VPWR sky130_fd_sc_hd__decap_3
XFILLER_6_94 VGND VGND VPWR VPWR sky130_fd_sc_hd__decap_3
XFILLER_6_83 VGND VGND VPWR VPWR sky130_fd_sc_hd__fill_1
XFILLER_116_29 VGND VGND VPWR VPWR sky130_fd_sc_hd__decap_3
XFILLER_112_141 VGND VGND VPWR VPWR sky130_fd_sc_hd__decap_3
X_0527_ net255 net3 _0063_ net35 Tile_X0Y1_OpenRAM_bot.Inst_OpenRAM_bot_ConfigMem.Inst_frame6_bit11.Q
+ Tile_X0Y1_OpenRAM_bot.Inst_OpenRAM_bot_ConfigMem.Inst_frame6_bit10.Q VGND VGND VPWR
+ VPWR Tile_X0Y1_OpenRAM_bot.Inst_OpenRAM_bot_switch_matrix.W1BEG1 sky130_fd_sc_hd__mux4_1
XFILLER_58_206 VGND VGND VPWR VPWR sky130_fd_sc_hd__decap_3
XFILLER_112_174 VGND VGND VPWR VPWR sky130_fd_sc_hd__decap_3
X_0458_ net70 Tile_X0Y0_OpenRAM_top.Inst_OpenRAM_top_ConfigMem.Inst_frame1_bit0.Q
+ VGND VGND VPWR VPWR _0106_ sky130_fd_sc_hd__nand2_1
X_0389_ Tile_X0Y0_OpenRAM_top.Inst_OpenRAM_top_switch_matrix.N1END0 net361 net146
+ net166 Tile_X0Y0_OpenRAM_top.Inst_OpenRAM_top_ConfigMem.Inst_frame0_bit0.Q Tile_X0Y0_OpenRAM_top.Inst_OpenRAM_top_ConfigMem.Inst_frame0_bit1.Q
+ VGND VGND VPWR VPWR Tile_X0Y0_OpenRAM_top.Inst_OpenRAM_top_switch_matrix.J_NS4_BEG12
+ sky130_fd_sc_hd__mux4_2
XFILLER_73_209 VGND VGND VPWR VPWR sky130_fd_sc_hd__decap_3
XFILLER_26_125 VGND VGND VPWR VPWR sky130_fd_sc_hd__fill_1
XFILLER_26_136 VGND VGND VPWR VPWR sky130_fd_sc_hd__decap_3
XFILLER_26_147 VGND VGND VPWR VPWR sky130_fd_sc_hd__decap_3
XFILLER_41_47 VGND VGND VPWR VPWR sky130_fd_sc_hd__decap_3
XFILLER_135_200 VGND VGND VPWR VPWR sky130_fd_sc_hd__decap_3
XFILLER_41_69 VGND VGND VPWR VPWR sky130_fd_sc_hd__decap_3
XFILLER_157_69 VGND VGND VPWR VPWR sky130_fd_sc_hd__decap_3
XFILLER_150_203 VGND VGND VPWR VPWR sky130_fd_sc_hd__decap_3
XFILLER_173_24 VGND VGND VPWR VPWR sky130_fd_sc_hd__decap_3
XFILLER_1_202 VGND VGND VPWR VPWR sky130_fd_sc_hd__decap_3
XFILLER_173_57 VGND VGND VPWR VPWR sky130_fd_sc_hd__decap_3
XFILLER_106_62 VGND VGND VPWR VPWR sky130_fd_sc_hd__decap_3
XFILLER_103_196 VGND VGND VPWR VPWR sky130_fd_sc_hd__decap_3
XFILLER_66_44 VGND VGND VPWR VPWR sky130_fd_sc_hd__decap_3
XFILLER_64_209 VGND VGND VPWR VPWR sky130_fd_sc_hd__decap_3
XFILLER_17_125 VGND VGND VPWR VPWR sky130_fd_sc_hd__fill_1
XFILLER_122_83 VGND VGND VPWR VPWR sky130_fd_sc_hd__fill_1
XFILLER_17_169 VGND VGND VPWR VPWR sky130_fd_sc_hd__fill_1
XFILLER_17_158 VGND VGND VPWR VPWR sky130_fd_sc_hd__decap_3
XFILLER_82_21 VGND VGND VPWR VPWR sky130_fd_sc_hd__decap_3
XFILLER_82_32 VGND VGND VPWR VPWR sky130_fd_sc_hd__decap_3
XFILLER_122_94 VGND VGND VPWR VPWR sky130_fd_sc_hd__decap_3
XFILLER_32_106 VGND VGND VPWR VPWR sky130_fd_sc_hd__decap_3
XFILLER_32_139 VGND VGND VPWR VPWR sky130_fd_sc_hd__fill_1
XFILLER_82_76 VGND VGND VPWR VPWR sky130_fd_sc_hd__decap_3
XFILLER_82_98 VGND VGND VPWR VPWR sky130_fd_sc_hd__decap_3
XFILLER_40_194 VGND VGND VPWR VPWR sky130_fd_sc_hd__fill_2
XFILLER_126_200 VGND VGND VPWR VPWR sky130_fd_sc_hd__decap_3
XFILLER_99_128 VGND VGND VPWR VPWR sky130_fd_sc_hd__decap_3
X_1430_ Tile_X0Y1_OpenRAM_bot.Inst_OpenRAM_bot_switch_matrix.S2BEG0 VGND VGND VPWR
+ VPWR net590 sky130_fd_sc_hd__clkbuf_2
X_1361_ Tile_X0Y0_OpenRAM_top.Inst_OpenRAM_top_switch_matrix.W2BEGb3 VGND VGND VPWR
+ VPWR net521 sky130_fd_sc_hd__buf_1
X_0312_ Tile_X0Y0_OpenRAM_top.Inst_OpenRAM_top_switch_matrix.N1END3 net91 Tile_X0Y0_OpenRAM_top.Inst_OpenRAM_top_ConfigMem.Inst_frame0_bit30.Q
+ VGND VGND VPWR VPWR _0074_ sky130_fd_sc_hd__mux2_1
X_1292_ net309 VGND VGND VPWR VPWR net462 sky130_fd_sc_hd__buf_1
XFILLER_163_90 VGND VGND VPWR VPWR sky130_fd_sc_hd__fill_1
X_0243_ Tile_X0Y0_OpenRAM_top.Inst_OpenRAM_top_ConfigMem.Inst_frame6_bit13.Q VGND
+ VGND VPWR VPWR _0016_ sky130_fd_sc_hd__inv_1
Xinput180 Tile_X0Y1_E2END[2] VGND VGND VPWR VPWR net180 sky130_fd_sc_hd__buf_2
Xinput191 Tile_X0Y1_E2MID[5] VGND VGND VPWR VPWR net191 sky130_fd_sc_hd__dlymetal6s2s_1
XFILLER_63_220 VGND VGND VPWR VPWR sky130_fd_sc_hd__decap_3
XFILLER_176_100 VGND VGND VPWR VPWR sky130_fd_sc_hd__decap_3
XFILLER_176_144 VGND VGND VPWR VPWR sky130_fd_sc_hd__decap_3
XFILLER_176_133 VGND VGND VPWR VPWR sky130_fd_sc_hd__decap_3
XFILLER_31_172 VGND VGND VPWR VPWR sky130_fd_sc_hd__decap_3
XFILLER_176_177 VGND VGND VPWR VPWR sky130_fd_sc_hd__decap_3
XFILLER_11_28 VGND VGND VPWR VPWR sky130_fd_sc_hd__decap_3
XFILLER_132_203 VGND VGND VPWR VPWR sky130_fd_sc_hd__fill_2
XFILLER_127_28 VGND VGND VPWR VPWR sky130_fd_sc_hd__decap_3
Xfanout314 net315 VGND VGND VPWR VPWR net314 sky130_fd_sc_hd__buf_1
Xfanout303 Tile_X0Y1_FrameStrobe[4] VGND VGND VPWR VPWR net303 sky130_fd_sc_hd__clkbuf_2
XTAP_TAPCELL_ROW_168_1042 VGND VPWR sky130_fd_sc_hd__tapvpwrvgnd_1
Xfanout336 net337 VGND VGND VPWR VPWR net336 sky130_fd_sc_hd__clkbuf_1
XFILLER_98_183 VGND VGND VPWR VPWR sky130_fd_sc_hd__decap_3
Xfanout325 Tile_X0Y1_FrameStrobe[1] VGND VGND VPWR VPWR net325 sky130_fd_sc_hd__clkbuf_4
XFILLER_100_133 VGND VGND VPWR VPWR sky130_fd_sc_hd__decap_3
XFILLER_100_144 VGND VGND VPWR VPWR sky130_fd_sc_hd__decap_3
XFILLER_46_209 VGND VGND VPWR VPWR sky130_fd_sc_hd__fill_2
XFILLER_36_25 VGND VGND VPWR VPWR sky130_fd_sc_hd__decap_3
XFILLER_36_47 VGND VGND VPWR VPWR sky130_fd_sc_hd__decap_3
XFILLER_168_24 VGND VGND VPWR VPWR sky130_fd_sc_hd__decap_3
XFILLER_167_122 VGND VGND VPWR VPWR sky130_fd_sc_hd__decap_3
XFILLER_167_100 VGND VGND VPWR VPWR sky130_fd_sc_hd__decap_3
XFILLER_168_35 VGND VGND VPWR VPWR sky130_fd_sc_hd__decap_3
XFILLER_22_172 VGND VGND VPWR VPWR sky130_fd_sc_hd__fill_1
XFILLER_22_194 VGND VGND VPWR VPWR sky130_fd_sc_hd__fill_2
XFILLER_168_68 VGND VGND VPWR VPWR sky130_fd_sc_hd__decap_3
XFILLER_167_199 VGND VGND VPWR VPWR sky130_fd_sc_hd__decap_3
XFILLER_108_200 VGND VGND VPWR VPWR sky130_fd_sc_hd__decap_3
XPHY_EDGE_ROW_99_Left_282 VGND VGND VPWR VPWR sky130_fd_sc_hd__decap_3
XFILLER_182_169 VGND VGND VPWR VPWR sky130_fd_sc_hd__fill_1
XFILLER_123_225 VGND VGND VPWR VPWR sky130_fd_sc_hd__decap_3
XFILLER_123_214 VGND VGND VPWR VPWR sky130_fd_sc_hd__decap_3
XFILLER_117_72 VGND VGND VPWR VPWR sky130_fd_sc_hd__decap_3
XFILLER_117_50 VGND VGND VPWR VPWR sky130_fd_sc_hd__decap_3
XFILLER_77_21 VGND VGND VPWR VPWR sky130_fd_sc_hd__decap_3
XFILLER_77_54 VGND VGND VPWR VPWR sky130_fd_sc_hd__fill_2
XFILLER_89_161 VGND VGND VPWR VPWR sky130_fd_sc_hd__decap_3
XFILLER_89_172 VGND VGND VPWR VPWR sky130_fd_sc_hd__decap_3
XFILLER_89_194 VGND VGND VPWR VPWR sky130_fd_sc_hd__decap_3
XTAP_TAPCELL_ROW_5_393 VGND VPWR sky130_fd_sc_hd__tapvpwrvgnd_1
XFILLER_93_42 VGND VGND VPWR VPWR sky130_fd_sc_hd__decap_3
XTAP_TAPCELL_ROW_28_484 VGND VPWR sky130_fd_sc_hd__tapvpwrvgnd_1
XFILLER_93_86 VGND VGND VPWR VPWR sky130_fd_sc_hd__decap_3
XFILLER_26_91 VGND VGND VPWR VPWR sky130_fd_sc_hd__decap_3
XFILLER_158_122 VGND VGND VPWR VPWR sky130_fd_sc_hd__decap_3
XFILLER_158_100 VGND VGND VPWR VPWR sky130_fd_sc_hd__fill_1
X_0930_ net121 net275 VGND VGND VPWR VPWR Tile_X0Y0_OpenRAM_top.Inst_OpenRAM_top_ConfigMem.Inst_frame7_bit16.Q
+ sky130_fd_sc_hd__dlxtp_1
XFILLER_158_144 VGND VGND VPWR VPWR sky130_fd_sc_hd__decap_3
XFILLER_13_172 VGND VGND VPWR VPWR sky130_fd_sc_hd__decap_3
XFILLER_13_161 VGND VGND VPWR VPWR sky130_fd_sc_hd__decap_3
XFILLER_9_143 VGND VGND VPWR VPWR sky130_fd_sc_hd__decap_3
X_0861_ net127 net292 VGND VGND VPWR VPWR Tile_X0Y0_OpenRAM_top.Inst_OpenRAM_top_ConfigMem.Inst_frame5_bit21.Q
+ sky130_fd_sc_hd__dlxtp_1
XFILLER_173_125 VGND VGND VPWR VPWR sky130_fd_sc_hd__decap_3
X_0792_ net132 net309 VGND VGND VPWR VPWR Tile_X0Y0_OpenRAM_top.Inst_OpenRAM_top_ConfigMem.Inst_frame3_bit26.Q
+ sky130_fd_sc_hd__dlxtp_1
XFILLER_9_187 VGND VGND VPWR VPWR sky130_fd_sc_hd__decap_3
XFILLER_173_169 VGND VGND VPWR VPWR sky130_fd_sc_hd__decap_3
XFILLER_173_158 VGND VGND VPWR VPWR sky130_fd_sc_hd__decap_3
X_1413_ net232 VGND VGND VPWR VPWR net564 sky130_fd_sc_hd__buf_6
X_1344_ Tile_X0Y0_OpenRAM_top.Inst_OpenRAM_top_switch_matrix.N4BEG3 VGND VGND VPWR
+ VPWR net495 sky130_fd_sc_hd__clkbuf_2
XFILLER_3_51 VGND VGND VPWR VPWR sky130_fd_sc_hd__decap_3
X_1275_ net123 VGND VGND VPWR VPWR net426 sky130_fd_sc_hd__clkbuf_1
XFILLER_3_84 VGND VGND VPWR VPWR sky130_fd_sc_hd__decap_3
XFILLER_95_153 VGND VGND VPWR VPWR sky130_fd_sc_hd__decap_3
XFILLER_95_197 VGND VGND VPWR VPWR sky130_fd_sc_hd__decap_3
XTAP_TAPCELL_ROW_159_1008 VGND VPWR sky130_fd_sc_hd__tapvpwrvgnd_1
XFILLER_149_155 VGND VGND VPWR VPWR sky130_fd_sc_hd__decap_3
XFILLER_164_103 VGND VGND VPWR VPWR sky130_fd_sc_hd__decap_3
XFILLER_164_136 VGND VGND VPWR VPWR sky130_fd_sc_hd__decap_3
XFILLER_138_38 VGND VGND VPWR VPWR sky130_fd_sc_hd__decap_3
XFILLER_164_158 VGND VGND VPWR VPWR sky130_fd_sc_hd__decap_3
XFILLER_172_180 VGND VGND VPWR VPWR sky130_fd_sc_hd__decap_3
XFILLER_154_26 VGND VGND VPWR VPWR sky130_fd_sc_hd__fill_2
Xoutput451 net534 VGND VGND VPWR VPWR Tile_X0Y0_W6BEG[6] sky130_fd_sc_hd__buf_2
Xoutput462 net545 VGND VGND VPWR VPWR Tile_X0Y0_WW4BEG[1] sky130_fd_sc_hd__buf_2
Xoutput440 net523 VGND VGND VPWR VPWR Tile_X0Y0_W2BEGb[5] sky130_fd_sc_hd__buf_2
XFILLER_0_9 VGND VGND VPWR VPWR sky130_fd_sc_hd__decap_3
Xoutput495 net578 VGND VGND VPWR VPWR Tile_X0Y1_FrameData_O[31] sky130_fd_sc_hd__buf_2
Xoutput484 net567 VGND VGND VPWR VPWR Tile_X0Y1_FrameData_O[21] sky130_fd_sc_hd__buf_2
Xoutput473 net556 VGND VGND VPWR VPWR Tile_X0Y1_FrameData_O[11] sky130_fd_sc_hd__buf_2
XFILLER_120_206 VGND VGND VPWR VPWR sky130_fd_sc_hd__decap_3
XFILLER_47_46 VGND VGND VPWR VPWR sky130_fd_sc_hd__decap_3
XFILLER_170_47 VGND VGND VPWR VPWR sky130_fd_sc_hd__decap_3
XPHY_EDGE_ROW_29_Right_29 VGND VGND VPWR VPWR sky130_fd_sc_hd__decap_3
XFILLER_86_186 VGND VGND VPWR VPWR sky130_fd_sc_hd__decap_3
XFILLER_103_30 VGND VGND VPWR VPWR sky130_fd_sc_hd__decap_3
XTAP_TAPCELL_ROW_181_1094 VGND VPWR sky130_fd_sc_hd__tapvpwrvgnd_1
XFILLER_103_63 VGND VGND VPWR VPWR sky130_fd_sc_hd__decap_3
XFILLER_103_52 VGND VGND VPWR VPWR sky130_fd_sc_hd__decap_3
XFILLER_179_12 VGND VGND VPWR VPWR sky130_fd_sc_hd__decap_3
XFILLER_179_45 VGND VGND VPWR VPWR sky130_fd_sc_hd__decap_3
XFILLER_179_78 VGND VGND VPWR VPWR sky130_fd_sc_hd__decap_3
XFILLER_8_29 VGND VGND VPWR VPWR sky130_fd_sc_hd__decap_3
XFILLER_8_18 VGND VGND VPWR VPWR sky130_fd_sc_hd__decap_3
XPHY_EDGE_ROW_38_Right_38 VGND VGND VPWR VPWR sky130_fd_sc_hd__decap_3
XFILLER_155_125 VGND VGND VPWR VPWR sky130_fd_sc_hd__decap_3
XFILLER_10_153 VGND VGND VPWR VPWR sky130_fd_sc_hd__decap_3
XFILLER_6_124 VGND VGND VPWR VPWR sky130_fd_sc_hd__decap_3
XFILLER_170_106 VGND VGND VPWR VPWR sky130_fd_sc_hd__decap_3
XFILLER_155_158 VGND VGND VPWR VPWR sky130_fd_sc_hd__decap_3
XFILLER_12_71 VGND VGND VPWR VPWR sky130_fd_sc_hd__decap_3
XFILLER_10_197 VGND VGND VPWR VPWR sky130_fd_sc_hd__decap_3
XFILLER_6_168 VGND VGND VPWR VPWR sky130_fd_sc_hd__decap_3
XFILLER_170_139 VGND VGND VPWR VPWR sky130_fd_sc_hd__fill_1
XFILLER_88_53 VGND VGND VPWR VPWR sky130_fd_sc_hd__decap_3
XFILLER_69_109 VGND VGND VPWR VPWR sky130_fd_sc_hd__decap_3
XFILLER_88_97 VGND VGND VPWR VPWR sky130_fd_sc_hd__decap_3
XFILLER_77_131 VGND VGND VPWR VPWR sky130_fd_sc_hd__decap_3
XFILLER_144_81 VGND VGND VPWR VPWR sky130_fd_sc_hd__decap_3
XPHY_EDGE_ROW_47_Right_47 VGND VGND VPWR VPWR sky130_fd_sc_hd__decap_3
XFILLER_19_7 VGND VGND VPWR VPWR sky130_fd_sc_hd__fill_1
X_1060_ net244 net312 VGND VGND VPWR VPWR Tile_X0Y1_OpenRAM_bot.Inst_OpenRAM_bot_ConfigMem.Inst_frame2_bit2.Q
+ sky130_fd_sc_hd__dlxtp_1
XFILLER_160_80 VGND VGND VPWR VPWR sky130_fd_sc_hd__decap_3
XFILLER_37_90 VGND VGND VPWR VPWR sky130_fd_sc_hd__decap_3
XFILLER_92_189 VGND VGND VPWR VPWR sky130_fd_sc_hd__decap_3
XFILLER_178_206 VGND VGND VPWR VPWR sky130_fd_sc_hd__decap_3
XFILLER_33_223 VGND VGND VPWR VPWR sky130_fd_sc_hd__fill_1
XPHY_EDGE_ROW_56_Right_56 VGND VGND VPWR VPWR sky130_fd_sc_hd__decap_3
X_0913_ net125 net285 VGND VGND VPWR VPWR Tile_X0Y0_OpenRAM_top.Inst_OpenRAM_top_ConfigMem.Inst_frame6_bit1.Q
+ sky130_fd_sc_hd__dlxtp_1
X_0844_ net142 net302 VGND VGND VPWR VPWR Tile_X0Y0_OpenRAM_top.Inst_OpenRAM_top_ConfigMem.Inst_frame4_bit6.Q
+ sky130_fd_sc_hd__dlxtp_1
XFILLER_161_128 VGND VGND VPWR VPWR sky130_fd_sc_hd__decap_3
X_0775_ net116 net320 VGND VGND VPWR VPWR Tile_X0Y0_OpenRAM_top.Inst_OpenRAM_top_ConfigMem.Inst_frame2_bit11.Q
+ sky130_fd_sc_hd__dlxtp_1
XFILLER_154_180 VGND VGND VPWR VPWR sky130_fd_sc_hd__decap_3
XFILLER_5_190 VGND VGND VPWR VPWR sky130_fd_sc_hd__decap_3
XPHY_EDGE_ROW_65_Right_65 VGND VGND VPWR VPWR sky130_fd_sc_hd__decap_3
XFILLER_124_29 VGND VGND VPWR VPWR sky130_fd_sc_hd__decap_3
XFILLER_124_18 VGND VGND VPWR VPWR sky130_fd_sc_hd__decap_3
XFILLER_102_228 VGND VGND VPWR VPWR sky130_fd_sc_hd__fill_2
XFILLER_68_120 VGND VGND VPWR VPWR sky130_fd_sc_hd__decap_3
XFILLER_68_153 VGND VGND VPWR VPWR sky130_fd_sc_hd__decap_3
XFILLER_68_186 VGND VGND VPWR VPWR sky130_fd_sc_hd__decap_3
XFILLER_68_197 VGND VGND VPWR VPWR sky130_fd_sc_hd__decap_3
X_1327_ Tile_X0Y0_OpenRAM_top.Inst_OpenRAM_top_switch_matrix.N2BEGb6 VGND VGND VPWR
+ VPWR net487 sky130_fd_sc_hd__buf_4
X_1258_ net125 VGND VGND VPWR VPWR net428 sky130_fd_sc_hd__clkbuf_2
XFILLER_17_38 VGND VGND VPWR VPWR sky130_fd_sc_hd__decap_3
XFILLER_83_134 VGND VGND VPWR VPWR sky130_fd_sc_hd__decap_3
X_1189_ net233 net281 VGND VGND VPWR VPWR Tile_X0Y1_OpenRAM_bot.Inst_OpenRAM_bot_ConfigMem.Inst_frame6_bit1.Q
+ sky130_fd_sc_hd__dlxtp_1
XFILLER_83_167 VGND VGND VPWR VPWR sky130_fd_sc_hd__fill_1
XFILLER_169_228 VGND VGND VPWR VPWR sky130_fd_sc_hd__fill_2
XFILLER_169_217 VGND VGND VPWR VPWR sky130_fd_sc_hd__decap_3
XPHY_EDGE_ROW_166_Right_166 VGND VGND VPWR VPWR sky130_fd_sc_hd__decap_3
XTAP_TAPCELL_ROW_106_797 VGND VPWR sky130_fd_sc_hd__tapvpwrvgnd_1
XPHY_EDGE_ROW_74_Right_74 VGND VGND VPWR VPWR sky130_fd_sc_hd__decap_3
XFILLER_149_37 VGND VGND VPWR VPWR sky130_fd_sc_hd__decap_3
XFILLER_137_169 VGND VGND VPWR VPWR sky130_fd_sc_hd__decap_3
XFILLER_137_147 VGND VGND VPWR VPWR sky130_fd_sc_hd__decap_3
XTAP_TAPCELL_ROW_30_490 VGND VPWR sky130_fd_sc_hd__tapvpwrvgnd_1
XFILLER_165_36 VGND VGND VPWR VPWR sky130_fd_sc_hd__decap_3
XFILLER_3_105 VGND VGND VPWR VPWR sky130_fd_sc_hd__decap_3
XFILLER_3_116 VGND VGND VPWR VPWR sky130_fd_sc_hd__decap_3
XFILLER_3_149 VGND VGND VPWR VPWR sky130_fd_sc_hd__decap_3
XPHY_EDGE_ROW_83_Right_83 VGND VGND VPWR VPWR sky130_fd_sc_hd__decap_3
XFILLER_160_150 VGND VGND VPWR VPWR sky130_fd_sc_hd__decap_3
XTAP_TAPCELL_ROW_7_400 VGND VPWR sky130_fd_sc_hd__tapvpwrvgnd_1
XFILLER_160_183 VGND VGND VPWR VPWR sky130_fd_sc_hd__decap_3
Xoutput292 net375 VGND VGND VPWR VPWR ADDR_B_SRAM2 sky130_fd_sc_hd__buf_2
XFILLER_181_57 VGND VGND VPWR VPWR sky130_fd_sc_hd__fill_2
XFILLER_59_164 VGND VGND VPWR VPWR sky130_fd_sc_hd__decap_3
XTAP_TAPCELL_ROW_129_889 VGND VPWR sky130_fd_sc_hd__tapvpwrvgnd_1
XFILLER_59_186 VGND VGND VPWR VPWR sky130_fd_sc_hd__fill_2
XFILLER_74_134 VGND VGND VPWR VPWR sky130_fd_sc_hd__decap_3
XFILLER_15_201 VGND VGND VPWR VPWR sky130_fd_sc_hd__decap_3
XFILLER_74_178 VGND VGND VPWR VPWR sky130_fd_sc_hd__decap_3
XFILLER_74_99 VGND VGND VPWR VPWR sky130_fd_sc_hd__fill_2
XPHY_EDGE_ROW_92_Right_92 VGND VGND VPWR VPWR sky130_fd_sc_hd__decap_3
XPHY_EDGE_ROW_133_Right_133 VGND VGND VPWR VPWR sky130_fd_sc_hd__decap_3
XFILLER_130_94 VGND VGND VPWR VPWR sky130_fd_sc_hd__decap_3
XFILLER_130_83 VGND VGND VPWR VPWR sky130_fd_sc_hd__fill_1
XTAP_TAPCELL_ROW_13_424 VGND VPWR sky130_fd_sc_hd__tapvpwrvgnd_1
XFILLER_30_215 VGND VGND VPWR VPWR sky130_fd_sc_hd__decap_3
XTAP_TAPCELL_ROW_53_582 VGND VPWR sky130_fd_sc_hd__tapvpwrvgnd_1
XFILLER_90_32 VGND VGND VPWR VPWR sky130_fd_sc_hd__decap_3
XFILLER_90_65 VGND VGND VPWR VPWR sky130_fd_sc_hd__decap_3
XFILLER_128_136 VGND VGND VPWR VPWR sky130_fd_sc_hd__decap_3
XFILLER_23_70 VGND VGND VPWR VPWR sky130_fd_sc_hd__fill_1
XFILLER_99_30 VGND VGND VPWR VPWR sky130_fd_sc_hd__decap_3
XFILLER_23_92 VGND VGND VPWR VPWR sky130_fd_sc_hd__decap_3
XFILLER_143_128 VGND VGND VPWR VPWR sky130_fd_sc_hd__decap_3
XFILLER_99_63 VGND VGND VPWR VPWR sky130_fd_sc_hd__decap_3
XFILLER_99_96 VGND VGND VPWR VPWR sky130_fd_sc_hd__decap_3
X_0560_ net339 net359 _0070_ net172 Tile_X0Y1_OpenRAM_bot.Inst_OpenRAM_bot_ConfigMem.Inst_frame1_bit20.Q
+ Tile_X0Y1_OpenRAM_bot.Inst_OpenRAM_bot_ConfigMem.Inst_frame1_bit21.Q VGND VGND VPWR
+ VPWR _0150_ sky130_fd_sc_hd__mux4_2
X_0491_ Tile_X0Y0_OpenRAM_top.Inst_OpenRAM_top_switch_matrix.J_NS4_BEG4 Tile_X0Y0_OpenRAM_top.Inst_OpenRAM_top_switch_matrix.J_NS4_BEG8
+ Tile_X0Y0_OpenRAM_top.Inst_OpenRAM_top_switch_matrix.J_NS4_BEG12 Tile_X0Y0_OpenRAM_top.Inst_OpenRAM_top_switch_matrix.J_NS2_BEG4
+ Tile_X0Y0_OpenRAM_top.Inst_OpenRAM_top_ConfigMem.Inst_frame6_bit8.Q Tile_X0Y0_OpenRAM_top.Inst_OpenRAM_top_ConfigMem.Inst_frame6_bit9.Q
+ VGND VGND VPWR VPWR _0131_ sky130_fd_sc_hd__mux4_1
XFILLER_2_171 VGND VGND VPWR VPWR sky130_fd_sc_hd__decap_3
XFILLER_171_90 VGND VGND VPWR VPWR sky130_fd_sc_hd__decap_3
X_1112_ net227 net297 VGND VGND VPWR VPWR Tile_X0Y1_OpenRAM_bot.Inst_OpenRAM_bot_ConfigMem.Inst_frame4_bit14.Q
+ sky130_fd_sc_hd__dlxtp_1
XTAP_TAPCELL_ROW_36_516 VGND VPWR sky130_fd_sc_hd__tapvpwrvgnd_1
X_1043_ net232 net312 VGND VGND VPWR VPWR Tile_X0Y1_OpenRAM_bot.Inst_OpenRAM_bot_ConfigMem.Inst_frame2_bit19.Q
+ sky130_fd_sc_hd__dlxtp_1
XFILLER_65_167 VGND VGND VPWR VPWR sky130_fd_sc_hd__fill_1
XTAP_TAPCELL_ROW_76_674 VGND VPWR sky130_fd_sc_hd__tapvpwrvgnd_1
XPHY_EDGE_ROW_100_Right_100 VGND VGND VPWR VPWR sky130_fd_sc_hd__decap_3
XFILLER_166_209 VGND VGND VPWR VPWR sky130_fd_sc_hd__decap_3
XFILLER_9_72 VGND VGND VPWR VPWR sky130_fd_sc_hd__decap_3
XFILLER_119_136 VGND VGND VPWR VPWR sky130_fd_sc_hd__decap_3
XFILLER_119_169 VGND VGND VPWR VPWR sky130_fd_sc_hd__fill_2
X_0827_ net129 net301 VGND VGND VPWR VPWR Tile_X0Y0_OpenRAM_top.Inst_OpenRAM_top_ConfigMem.Inst_frame4_bit23.Q
+ sky130_fd_sc_hd__dlxtp_1
X_0758_ net134 net317 VGND VGND VPWR VPWR Tile_X0Y0_OpenRAM_top.Inst_OpenRAM_top_ConfigMem.Inst_frame2_bit28.Q
+ sky130_fd_sc_hd__dlxtp_1
XFILLER_142_161 VGND VGND VPWR VPWR sky130_fd_sc_hd__decap_3
XFILLER_88_215 VGND VGND VPWR VPWR sky130_fd_sc_hd__decap_3
X_0689_ Tile_X0Y1_OpenRAM_bot.Inst_OpenRAM_bot_ConfigMem.Inst_frame3_bit12.Q _0218_
+ _0219_ Tile_X0Y1_OpenRAM_bot.Inst_OpenRAM_bot_ConfigMem.Inst_frame3_bit15.Q VGND
+ VGND VPWR VPWR _0226_ sky130_fd_sc_hd__o31ai_1
XTAP_TAPCELL_ROW_99_766 VGND VPWR sky130_fd_sc_hd__tapvpwrvgnd_1
XTAP_TAPCELL_ROW_59_608 VGND VPWR sky130_fd_sc_hd__tapvpwrvgnd_1
XFILLER_28_15 VGND VGND VPWR VPWR sky130_fd_sc_hd__fill_1
XTAP_TAPCELL_ROW_67_641 VGND VPWR sky130_fd_sc_hd__tapvpwrvgnd_1
XFILLER_71_104 VGND VGND VPWR VPWR sky130_fd_sc_hd__decap_3
XFILLER_44_47 VGND VGND VPWR VPWR sky130_fd_sc_hd__decap_3
XFILLER_71_159 VGND VGND VPWR VPWR sky130_fd_sc_hd__fill_1
XFILLER_44_69 VGND VGND VPWR VPWR sky130_fd_sc_hd__decap_3
XTAP_TAPCELL_ROW_82_699 VGND VPWR sky130_fd_sc_hd__tapvpwrvgnd_1
XFILLER_100_64 VGND VGND VPWR VPWR sky130_fd_sc_hd__decap_3
XFILLER_165_220 VGND VGND VPWR VPWR sky130_fd_sc_hd__decap_3
XFILLER_60_46 VGND VGND VPWR VPWR sky130_fd_sc_hd__decap_3
XFILLER_176_35 VGND VGND VPWR VPWR sky130_fd_sc_hd__decap_3
XFILLER_176_24 VGND VGND VPWR VPWR sky130_fd_sc_hd__decap_3
XFILLER_176_68 VGND VGND VPWR VPWR sky130_fd_sc_hd__decap_3
XFILLER_118_180 VGND VGND VPWR VPWR sky130_fd_sc_hd__decap_3
XFILLER_109_51 VGND VGND VPWR VPWR sky130_fd_sc_hd__decap_3
XPHY_EDGE_ROW_26_Left_209 VGND VGND VPWR VPWR sky130_fd_sc_hd__decap_3
XFILLER_69_66 VGND VGND VPWR VPWR sky130_fd_sc_hd__decap_3
XFILLER_133_172 VGND VGND VPWR VPWR sky130_fd_sc_hd__decap_3
XFILLER_94_218 VGND VGND VPWR VPWR sky130_fd_sc_hd__decap_3
XFILLER_47_134 VGND VGND VPWR VPWR sky130_fd_sc_hd__fill_1
XFILLER_47_156 VGND VGND VPWR VPWR sky130_fd_sc_hd__decap_3
XFILLER_47_178 VGND VGND VPWR VPWR sky130_fd_sc_hd__decap_3
XFILLER_85_98 VGND VGND VPWR VPWR sky130_fd_sc_hd__fill_2
XTAP_TAPCELL_ROW_125_870 VGND VPWR sky130_fd_sc_hd__tapvpwrvgnd_1
XPHY_EDGE_ROW_35_Left_218 VGND VGND VPWR VPWR sky130_fd_sc_hd__decap_3
XFILLER_62_137 VGND VGND VPWR VPWR sky130_fd_sc_hd__decap_3
XFILLER_141_93 VGND VGND VPWR VPWR sky130_fd_sc_hd__decap_3
XFILLER_62_159 VGND VGND VPWR VPWR sky130_fd_sc_hd__decap_3
XFILLER_148_209 VGND VGND VPWR VPWR sky130_fd_sc_hd__decap_3
XFILLER_34_91 VGND VGND VPWR VPWR sky130_fd_sc_hd__fill_2
XFILLER_79_6 VGND VGND VPWR VPWR sky130_fd_sc_hd__decap_3
XFILLER_116_128 VGND VGND VPWR VPWR sky130_fd_sc_hd__decap_3
XPHY_EDGE_ROW_44_Left_227 VGND VGND VPWR VPWR sky130_fd_sc_hd__decap_3
XFILLER_171_223 VGND VGND VPWR VPWR sky130_fd_sc_hd__fill_1
X_0612_ net174 net216 net209 Tile_X0Y1_OpenRAM_bot.Inst_OpenRAM_bot_switch_matrix.J_NS4_BEG12
+ Tile_X0Y1_OpenRAM_bot.Inst_OpenRAM_bot_ConfigMem.Inst_frame2_bit20.Q Tile_X0Y1_OpenRAM_bot.Inst_OpenRAM_bot_ConfigMem.Inst_frame2_bit21.Q
+ VGND VGND VPWR VPWR net389 sky130_fd_sc_hd__mux4_2
XFILLER_124_150 VGND VGND VPWR VPWR sky130_fd_sc_hd__decap_3
XFILLER_124_194 VGND VGND VPWR VPWR sky130_fd_sc_hd__fill_2
X_0543_ net7 net39 net261 _0085_ Tile_X0Y1_OpenRAM_bot.Inst_OpenRAM_bot_ConfigMem.Inst_frame5_bit10.Q
+ Tile_X0Y1_OpenRAM_bot.Inst_OpenRAM_bot_ConfigMem.Inst_frame5_bit11.Q VGND VGND VPWR
+ VPWR Tile_X0Y1_OpenRAM_bot.Inst_OpenRAM_bot_switch_matrix.W2BEGb5 sky130_fd_sc_hd__mux4_1
X_0474_ _0013_ _0113_ _0117_ VGND VGND VPWR VPWR Tile_X0Y0_OpenRAM_top.Inst_OpenRAM_top_switch_matrix.N4BEG0
+ sky130_fd_sc_hd__o21a_1
XTAP_TAPCELL_ROW_148_962 VGND VPWR sky130_fd_sc_hd__tapvpwrvgnd_1
XTAP_TAPCELL_ROW_108_804 VGND VPWR sky130_fd_sc_hd__tapvpwrvgnd_1
XFILLER_38_156 VGND VGND VPWR VPWR sky130_fd_sc_hd__decap_3
XPHY_EDGE_ROW_53_Left_236 VGND VGND VPWR VPWR sky130_fd_sc_hd__decap_3
XFILLER_53_104 VGND VGND VPWR VPWR sky130_fd_sc_hd__decap_3
X_1026_ net248 net325 VGND VGND VPWR VPWR Tile_X0Y1_OpenRAM_bot.Inst_OpenRAM_bot_ConfigMem.Inst_frame1_bit4.Q
+ sky130_fd_sc_hd__dlxtp_1
XTAP_TAPCELL_ROW_131_895 VGND VPWR sky130_fd_sc_hd__tapvpwrvgnd_1
XPHY_EDGE_ROW_62_Left_245 VGND VGND VPWR VPWR sky130_fd_sc_hd__decap_3
XFILLER_107_128 VGND VGND VPWR VPWR sky130_fd_sc_hd__decap_3
XFILLER_30_27 VGND VGND VPWR VPWR sky130_fd_sc_hd__fill_1
XFILLER_30_38 VGND VGND VPWR VPWR sky130_fd_sc_hd__decap_3
XFILLER_122_109 VGND VGND VPWR VPWR sky130_fd_sc_hd__decap_3
XFILLER_100_9 VGND VGND VPWR VPWR sky130_fd_sc_hd__decap_3
XFILLER_115_161 VGND VGND VPWR VPWR sky130_fd_sc_hd__decap_3
XFILLER_162_15 VGND VGND VPWR VPWR sky130_fd_sc_hd__fill_1
XFILLER_130_131 VGND VGND VPWR VPWR sky130_fd_sc_hd__decap_3
XFILLER_162_59 VGND VGND VPWR VPWR sky130_fd_sc_hd__decap_3
XPHY_EDGE_ROW_71_Left_254 VGND VGND VPWR VPWR sky130_fd_sc_hd__decap_3
XFILLER_76_229 VGND VGND VPWR VPWR sky130_fd_sc_hd__fill_1
XFILLER_29_134 VGND VGND VPWR VPWR sky130_fd_sc_hd__fill_2
XTAP_TAPCELL_ROW_154_987 VGND VPWR sky130_fd_sc_hd__tapvpwrvgnd_1
XTAP_TAPCELL_ROW_114_829 VGND VPWR sky130_fd_sc_hd__tapvpwrvgnd_1
XFILLER_29_189 VGND VGND VPWR VPWR sky130_fd_sc_hd__fill_1
XFILLER_55_46 VGND VGND VPWR VPWR sky130_fd_sc_hd__decap_3
XFILLER_55_57 VGND VGND VPWR VPWR sky130_fd_sc_hd__decap_3
XFILLER_111_30 VGND VGND VPWR VPWR sky130_fd_sc_hd__decap_3
XFILLER_44_159 VGND VGND VPWR VPWR sky130_fd_sc_hd__fill_1
XFILLER_111_63 VGND VGND VPWR VPWR sky130_fd_sc_hd__decap_3
XFILLER_71_45 VGND VGND VPWR VPWR sky130_fd_sc_hd__decap_3
XPHY_EDGE_ROW_80_Left_263 VGND VGND VPWR VPWR sky130_fd_sc_hd__decap_3
XFILLER_153_201 VGND VGND VPWR VPWR sky130_fd_sc_hd__decap_3
XFILLER_4_200 VGND VGND VPWR VPWR sky130_fd_sc_hd__decap_3
XFILLER_113_109 VGND VGND VPWR VPWR sky130_fd_sc_hd__decap_3
XFILLER_106_150 VGND VGND VPWR VPWR sky130_fd_sc_hd__decap_3
XFILLER_136_71 VGND VGND VPWR VPWR sky130_fd_sc_hd__decap_3
XFILLER_121_164 VGND VGND VPWR VPWR sky130_fd_sc_hd__decap_3
XFILLER_35_137 VGND VGND VPWR VPWR sky130_fd_sc_hd__decap_3
XFILLER_50_118 VGND VGND VPWR VPWR sky130_fd_sc_hd__decap_3
XTAP_TAPCELL_ROW_61_614 VGND VPWR sky130_fd_sc_hd__tapvpwrvgnd_1
XFILLER_43_192 VGND VGND VPWR VPWR sky130_fd_sc_hd__decap_3
XFILLER_77_3 VGND VGND VPWR VPWR sky130_fd_sc_hd__decap_3
XFILLER_6_62 VGND VGND VPWR VPWR sky130_fd_sc_hd__decap_3
XFILLER_116_19 VGND VGND VPWR VPWR sky130_fd_sc_hd__decap_3
XFILLER_112_131 VGND VGND VPWR VPWR sky130_fd_sc_hd__decap_3
X_0526_ net254 net2 _0091_ net34 Tile_X0Y1_OpenRAM_bot.Inst_OpenRAM_bot_ConfigMem.Inst_frame6_bit9.Q
+ Tile_X0Y1_OpenRAM_bot.Inst_OpenRAM_bot_ConfigMem.Inst_frame6_bit8.Q VGND VGND VPWR
+ VPWR Tile_X0Y1_OpenRAM_bot.Inst_OpenRAM_bot_switch_matrix.W1BEG0 sky130_fd_sc_hd__mux4_1
XFILLER_112_186 VGND VGND VPWR VPWR sky130_fd_sc_hd__decap_3
XFILLER_112_153 VGND VGND VPWR VPWR sky130_fd_sc_hd__decap_3
XFILLER_58_218 VGND VGND VPWR VPWR sky130_fd_sc_hd__decap_3
X_0457_ net78 net259 Tile_X0Y0_OpenRAM_top.Inst_OpenRAM_top_ConfigMem.Inst_frame1_bit1.Q
+ VGND VGND VPWR VPWR _0105_ sky130_fd_sc_hd__mux2_1
XFILLER_112_197 VGND VGND VPWR VPWR sky130_fd_sc_hd__decap_3
XFILLER_132_29 VGND VGND VPWR VPWR sky130_fd_sc_hd__decap_3
X_0388_ net12 net44 Tile_X0Y0_OpenRAM_top.Inst_OpenRAM_top_switch_matrix.J_NS4_BEG13
+ Tile_X0Y0_OpenRAM_top.Inst_OpenRAM_top_switch_matrix.J_NS2_BEG5 Tile_X0Y0_OpenRAM_top.Inst_OpenRAM_top_ConfigMem.Inst_frame4_bit0.Q
+ Tile_X0Y0_OpenRAM_top.Inst_OpenRAM_top_ConfigMem.Inst_frame4_bit1.Q VGND VGND VPWR
+ VPWR Tile_X0Y0_OpenRAM_top.Inst_OpenRAM_top_switch_matrix.WW4BEG2 sky130_fd_sc_hd__mux4_1
XTAP_TAPCELL_ROW_84_706 VGND VPWR sky130_fd_sc_hd__tapvpwrvgnd_1
XFILLER_25_27 VGND VGND VPWR VPWR sky130_fd_sc_hd__decap_3
XFILLER_179_131 VGND VGND VPWR VPWR sky130_fd_sc_hd__decap_3
X_1009_ net235 net322 VGND VGND VPWR VPWR Tile_X0Y1_OpenRAM_bot.Inst_OpenRAM_bot_ConfigMem.Inst_frame1_bit21.Q
+ sky130_fd_sc_hd__dlxtp_1
XFILLER_179_164 VGND VGND VPWR VPWR sky130_fd_sc_hd__decap_3
XFILLER_179_153 VGND VGND VPWR VPWR sky130_fd_sc_hd__decap_3
XFILLER_179_197 VGND VGND VPWR VPWR sky130_fd_sc_hd__decap_3
XFILLER_179_175 VGND VGND VPWR VPWR sky130_fd_sc_hd__decap_3
XFILLER_157_26 VGND VGND VPWR VPWR sky130_fd_sc_hd__fill_2
XFILLER_135_212 VGND VGND VPWR VPWR sky130_fd_sc_hd__decap_3
XFILLER_150_215 VGND VGND VPWR VPWR sky130_fd_sc_hd__decap_3
XFILLER_9_6 VGND VGND VPWR VPWR sky130_fd_sc_hd__decap_3
XFILLER_1_214 VGND VGND VPWR VPWR sky130_fd_sc_hd__decap_3
XFILLER_1_225 VGND VGND VPWR VPWR sky130_fd_sc_hd__fill_2
XFILLER_173_69 VGND VGND VPWR VPWR sky130_fd_sc_hd__decap_3
XFILLER_173_36 VGND VGND VPWR VPWR sky130_fd_sc_hd__decap_3
XFILLER_103_142 VGND VGND VPWR VPWR sky130_fd_sc_hd__fill_1
XFILLER_106_41 VGND VGND VPWR VPWR sky130_fd_sc_hd__decap_3
XFILLER_103_175 VGND VGND VPWR VPWR sky130_fd_sc_hd__decap_3
XFILLER_103_164 VGND VGND VPWR VPWR sky130_fd_sc_hd__decap_3
XFILLER_106_85 VGND VGND VPWR VPWR sky130_fd_sc_hd__decap_3
XFILLER_106_74 VGND VGND VPWR VPWR sky130_fd_sc_hd__decap_3
XFILLER_66_12 VGND VGND VPWR VPWR sky130_fd_sc_hd__fill_2
XFILLER_181_3 VGND VGND VPWR VPWR sky130_fd_sc_hd__decap_3
XFILLER_66_56 VGND VGND VPWR VPWR sky130_fd_sc_hd__decap_3
XFILLER_66_78 VGND VGND VPWR VPWR sky130_fd_sc_hd__decap_3
XFILLER_66_89 VGND VGND VPWR VPWR sky130_fd_sc_hd__decap_3
XFILLER_32_118 VGND VGND VPWR VPWR sky130_fd_sc_hd__decap_3
XFILLER_82_44 VGND VGND VPWR VPWR sky130_fd_sc_hd__decap_3
XTAP_TAPCELL_ROW_110_810 VGND VPWR sky130_fd_sc_hd__tapvpwrvgnd_1
XFILLER_25_181 VGND VGND VPWR VPWR sky130_fd_sc_hd__decap_3
XFILLER_82_88 VGND VGND VPWR VPWR sky130_fd_sc_hd__fill_1
XFILLER_15_60 VGND VGND VPWR VPWR sky130_fd_sc_hd__decap_3
XFILLER_40_162 VGND VGND VPWR VPWR sky130_fd_sc_hd__decap_3
XFILLER_147_70 VGND VGND VPWR VPWR sky130_fd_sc_hd__decap_3
XFILLER_31_81 VGND VGND VPWR VPWR sky130_fd_sc_hd__decap_3
XPHY_EDGE_ROW_118_Left_301 VGND VGND VPWR VPWR sky130_fd_sc_hd__decap_3
X_1360_ Tile_X0Y0_OpenRAM_top.Inst_OpenRAM_top_switch_matrix.W2BEGb2 VGND VGND VPWR
+ VPWR net520 sky130_fd_sc_hd__buf_1
X_0311_ net68 net94 Tile_X0Y0_OpenRAM_top.Inst_OpenRAM_top_switch_matrix.J_NS4_BEG14
+ _0069_ Tile_X0Y0_OpenRAM_top.Inst_OpenRAM_top_ConfigMem.Inst_frame8_bit16.Q Tile_X0Y0_OpenRAM_top.Inst_OpenRAM_top_ConfigMem.Inst_frame8_bit17.Q
+ VGND VGND VPWR VPWR Tile_X0Y0_OpenRAM_top.Inst_OpenRAM_top_switch_matrix.N1BEG2
+ sky130_fd_sc_hd__mux4_1
X_1291_ net318 VGND VGND VPWR VPWR net461 sky130_fd_sc_hd__buf_1
Xinput170 Tile_X0Y0_S4END[4] VGND VGND VPWR VPWR net170 sky130_fd_sc_hd__clkbuf_4
X_0242_ Tile_X0Y0_OpenRAM_top.Inst_OpenRAM_top_ConfigMem.Inst_frame6_bit10.Q VGND
+ VGND VPWR VPWR _0015_ sky130_fd_sc_hd__inv_1
Xinput181 Tile_X0Y1_E2END[3] VGND VGND VPWR VPWR net181 sky130_fd_sc_hd__buf_2
XTAP_TAPCELL_ROW_133_902 VGND VPWR sky130_fd_sc_hd__tapvpwrvgnd_1
Xinput192 Tile_X0Y1_E2MID[6] VGND VGND VPWR VPWR net192 sky130_fd_sc_hd__clkbuf_2
XPHY_EDGE_ROW_127_Left_310 VGND VGND VPWR VPWR sky130_fd_sc_hd__decap_3
XFILLER_23_107 VGND VGND VPWR VPWR sky130_fd_sc_hd__decap_3
XFILLER_176_112 VGND VGND VPWR VPWR sky130_fd_sc_hd__decap_3
XFILLER_31_140 VGND VGND VPWR VPWR sky130_fd_sc_hd__decap_3
XFILLER_176_156 VGND VGND VPWR VPWR sky130_fd_sc_hd__decap_3
XFILLER_31_184 VGND VGND VPWR VPWR sky130_fd_sc_hd__decap_3
XFILLER_176_189 VGND VGND VPWR VPWR sky130_fd_sc_hd__decap_3
Xfanout304 net305 VGND VGND VPWR VPWR net304 sky130_fd_sc_hd__buf_2
XTAP_TAPCELL_ROW_168_1043 VGND VPWR sky130_fd_sc_hd__tapvpwrvgnd_1
Xfanout337 net338 VGND VGND VPWR VPWR net337 sky130_fd_sc_hd__dlymetal6s2s_1
Xfanout326 net329 VGND VGND VPWR VPWR net326 sky130_fd_sc_hd__clkbuf_2
XFILLER_98_162 VGND VGND VPWR VPWR sky130_fd_sc_hd__decap_3
Xfanout315 net316 VGND VGND VPWR VPWR net315 sky130_fd_sc_hd__clkbuf_2
XFILLER_143_39 VGND VGND VPWR VPWR sky130_fd_sc_hd__decap_3
XFILLER_100_112 VGND VGND VPWR VPWR sky130_fd_sc_hd__decap_3
XFILLER_98_195 VGND VGND VPWR VPWR sky130_fd_sc_hd__fill_1
X_1489_ Tile_X0Y1_OpenRAM_bot.Inst_OpenRAM_bot_switch_matrix.W6BEG7 VGND VGND VPWR
+ VPWR net651 sky130_fd_sc_hd__buf_1
X_0509_ net254 net357 _0091_ net170 Tile_X0Y1_OpenRAM_bot.Inst_OpenRAM_bot_ConfigMem.Inst_frame0_bit0.Q
+ Tile_X0Y1_OpenRAM_bot.Inst_OpenRAM_bot_ConfigMem.Inst_frame0_bit1.Q VGND VGND VPWR
+ VPWR Tile_X0Y1_OpenRAM_bot.Inst_OpenRAM_bot_switch_matrix.J_NS4_BEG12 sky130_fd_sc_hd__mux4_2
XFILLER_100_156 VGND VGND VPWR VPWR sky130_fd_sc_hd__decap_3
XFILLER_100_178 VGND VGND VPWR VPWR sky130_fd_sc_hd__decap_3
XFILLER_54_221 VGND VGND VPWR VPWR sky130_fd_sc_hd__decap_3
XFILLER_36_59 VGND VGND VPWR VPWR sky130_fd_sc_hd__decap_3
XFILLER_52_25 VGND VGND VPWR VPWR sky130_fd_sc_hd__decap_3
XFILLER_52_47 VGND VGND VPWR VPWR sky130_fd_sc_hd__decap_3
XFILLER_168_47 VGND VGND VPWR VPWR sky130_fd_sc_hd__decap_3
XFILLER_167_178 VGND VGND VPWR VPWR sky130_fd_sc_hd__decap_3
XFILLER_108_212 VGND VGND VPWR VPWR sky130_fd_sc_hd__decap_3
XFILLER_7_3 VGND VGND VPWR VPWR sky130_fd_sc_hd__decap_3
XFILLER_117_84 VGND VGND VPWR VPWR sky130_fd_sc_hd__fill_2
XFILLER_77_33 VGND VGND VPWR VPWR sky130_fd_sc_hd__decap_3
XFILLER_77_66 VGND VGND VPWR VPWR sky130_fd_sc_hd__decap_3
XFILLER_77_88 VGND VGND VPWR VPWR sky130_fd_sc_hd__decap_3
XFILLER_45_210 VGND VGND VPWR VPWR sky130_fd_sc_hd__decap_3
XFILLER_93_21 VGND VGND VPWR VPWR sky130_fd_sc_hd__decap_3
XFILLER_93_54 VGND VGND VPWR VPWR sky130_fd_sc_hd__fill_2
XFILLER_93_65 VGND VGND VPWR VPWR sky130_fd_sc_hd__decap_3
XFILLER_93_98 VGND VGND VPWR VPWR sky130_fd_sc_hd__decap_3
XFILLER_26_70 VGND VGND VPWR VPWR sky130_fd_sc_hd__decap_3
XTAP_TAPCELL_ROW_28_485 VGND VPWR sky130_fd_sc_hd__tapvpwrvgnd_1
XFILLER_158_134 VGND VGND VPWR VPWR sky130_fd_sc_hd__decap_3
XFILLER_13_184 VGND VGND VPWR VPWR sky130_fd_sc_hd__decap_3
XFILLER_9_122 VGND VGND VPWR VPWR sky130_fd_sc_hd__decap_3
XFILLER_9_111 VGND VGND VPWR VPWR sky130_fd_sc_hd__fill_1
XFILLER_158_189 VGND VGND VPWR VPWR sky130_fd_sc_hd__decap_3
XFILLER_158_167 VGND VGND VPWR VPWR sky130_fd_sc_hd__decap_3
X_0860_ net128 net295 VGND VGND VPWR VPWR Tile_X0Y0_OpenRAM_top.Inst_OpenRAM_top_ConfigMem.Inst_frame5_bit22.Q
+ sky130_fd_sc_hd__dlxtp_1
XFILLER_9_155 VGND VGND VPWR VPWR sky130_fd_sc_hd__decap_3
XFILLER_42_80 VGND VGND VPWR VPWR sky130_fd_sc_hd__decap_3
XFILLER_173_137 VGND VGND VPWR VPWR sky130_fd_sc_hd__decap_3
XFILLER_158_80 VGND VGND VPWR VPWR sky130_fd_sc_hd__decap_3
X_0791_ net133 net309 VGND VGND VPWR VPWR Tile_X0Y0_OpenRAM_top.Inst_OpenRAM_top_ConfigMem.Inst_frame3_bit27.Q
+ sky130_fd_sc_hd__dlxtp_1
XFILLER_9_199 VGND VGND VPWR VPWR sky130_fd_sc_hd__decap_3
XFILLER_158_91 VGND VGND VPWR VPWR sky130_fd_sc_hd__decap_3
XFILLER_181_181 VGND VGND VPWR VPWR sky130_fd_sc_hd__fill_2
XFILLER_114_215 VGND VGND VPWR VPWR sky130_fd_sc_hd__decap_3
X_1412_ net231 VGND VGND VPWR VPWR net563 sky130_fd_sc_hd__buf_4
XFILLER_3_30 VGND VGND VPWR VPWR sky130_fd_sc_hd__decap_3
X_1343_ Tile_X0Y0_OpenRAM_top.Inst_OpenRAM_top_switch_matrix.N4BEG2 VGND VGND VPWR
+ VPWR net494 sky130_fd_sc_hd__buf_1
XFILLER_3_63 VGND VGND VPWR VPWR sky130_fd_sc_hd__decap_3
X_1274_ net122 VGND VGND VPWR VPWR net425 sky130_fd_sc_hd__clkbuf_1
XFILLER_3_96 VGND VGND VPWR VPWR sky130_fd_sc_hd__decap_3
XPHY_EDGE_ROW_147_Right_147 VGND VGND VPWR VPWR sky130_fd_sc_hd__decap_3
XFILLER_36_232 VGND VGND VPWR VPWR sky130_fd_sc_hd__fill_2
XFILLER_51_202 VGND VGND VPWR VPWR sky130_fd_sc_hd__decap_3
XTAP_TAPCELL_ROW_159_1009 VGND VPWR sky130_fd_sc_hd__tapvpwrvgnd_1
XFILLER_149_134 VGND VGND VPWR VPWR sky130_fd_sc_hd__decap_3
XFILLER_149_178 VGND VGND VPWR VPWR sky130_fd_sc_hd__decap_3
XFILLER_149_167 VGND VGND VPWR VPWR sky130_fd_sc_hd__fill_1
X_0989_ net253 net333 VGND VGND VPWR VPWR Tile_X0Y1_OpenRAM_bot.Inst_OpenRAM_bot_ConfigMem.Inst_frame0_bit9.Q
+ sky130_fd_sc_hd__dlxtp_1
XFILLER_172_192 VGND VGND VPWR VPWR sky130_fd_sc_hd__decap_3
Xoutput452 net535 VGND VGND VPWR VPWR Tile_X0Y0_W6BEG[7] sky130_fd_sc_hd__buf_2
Xoutput441 net524 VGND VGND VPWR VPWR Tile_X0Y0_W2BEGb[6] sky130_fd_sc_hd__buf_2
Xoutput430 net513 VGND VGND VPWR VPWR Tile_X0Y0_W2BEG[3] sky130_fd_sc_hd__buf_2
Xoutput485 net568 VGND VGND VPWR VPWR Tile_X0Y1_FrameData_O[22] sky130_fd_sc_hd__buf_2
Xoutput474 net557 VGND VGND VPWR VPWR Tile_X0Y1_FrameData_O[12] sky130_fd_sc_hd__buf_2
Xoutput496 net579 VGND VGND VPWR VPWR Tile_X0Y1_FrameData_O[3] sky130_fd_sc_hd__buf_2
XFILLER_154_38 VGND VGND VPWR VPWR sky130_fd_sc_hd__decap_3
Xoutput463 net546 VGND VGND VPWR VPWR Tile_X0Y0_WW4BEG[2] sky130_fd_sc_hd__buf_2
XFILLER_86_121 VGND VGND VPWR VPWR sky130_fd_sc_hd__decap_3
XFILLER_170_15 VGND VGND VPWR VPWR sky130_fd_sc_hd__decap_3
XPHY_EDGE_ROW_114_Right_114 VGND VGND VPWR VPWR sky130_fd_sc_hd__decap_3
XFILLER_170_59 VGND VGND VPWR VPWR sky130_fd_sc_hd__decap_3
XTAP_TAPCELL_ROW_181_1095 VGND VPWR sky130_fd_sc_hd__tapvpwrvgnd_1
XFILLER_179_24 VGND VGND VPWR VPWR sky130_fd_sc_hd__decap_3
XFILLER_103_86 VGND VGND VPWR VPWR sky130_fd_sc_hd__decap_3
XFILLER_63_46 VGND VGND VPWR VPWR sky130_fd_sc_hd__decap_3
XFILLER_63_57 VGND VGND VPWR VPWR sky130_fd_sc_hd__decap_3
XFILLER_179_57 VGND VGND VPWR VPWR sky130_fd_sc_hd__decap_3
XFILLER_63_79 VGND VGND VPWR VPWR sky130_fd_sc_hd__decap_3
XFILLER_10_121 VGND VGND VPWR VPWR sky130_fd_sc_hd__decap_3
XFILLER_10_165 VGND VGND VPWR VPWR sky130_fd_sc_hd__decap_3
XFILLER_6_103 VGND VGND VPWR VPWR sky130_fd_sc_hd__decap_3
XFILLER_12_50 VGND VGND VPWR VPWR sky130_fd_sc_hd__decap_3
XFILLER_6_147 VGND VGND VPWR VPWR sky130_fd_sc_hd__decap_3
XFILLER_6_136 VGND VGND VPWR VPWR sky130_fd_sc_hd__decap_3
XFILLER_170_118 VGND VGND VPWR VPWR sky130_fd_sc_hd__decap_3
XFILLER_128_61 VGND VGND VPWR VPWR sky130_fd_sc_hd__decap_3
XFILLER_12_94 VGND VGND VPWR VPWR sky130_fd_sc_hd__decap_3
XFILLER_12_83 VGND VGND VPWR VPWR sky130_fd_sc_hd__fill_1
XFILLER_88_21 VGND VGND VPWR VPWR sky130_fd_sc_hd__decap_3
XFILLER_163_181 VGND VGND VPWR VPWR sky130_fd_sc_hd__decap_3
XFILLER_128_94 VGND VGND VPWR VPWR sky130_fd_sc_hd__decap_3
XFILLER_88_32 VGND VGND VPWR VPWR sky130_fd_sc_hd__decap_3
XFILLER_88_65 VGND VGND VPWR VPWR sky130_fd_sc_hd__decap_3
XFILLER_144_60 VGND VGND VPWR VPWR sky130_fd_sc_hd__decap_3
XFILLER_77_143 VGND VGND VPWR VPWR sky130_fd_sc_hd__fill_1
XFILLER_77_165 VGND VGND VPWR VPWR sky130_fd_sc_hd__decap_3
XFILLER_18_221 VGND VGND VPWR VPWR sky130_fd_sc_hd__decap_3
XFILLER_178_218 VGND VGND VPWR VPWR sky130_fd_sc_hd__decap_3
XFILLER_169_90 VGND VGND VPWR VPWR sky130_fd_sc_hd__decap_3
X_0912_ net136 net284 VGND VGND VPWR VPWR Tile_X0Y0_OpenRAM_top.Inst_OpenRAM_top_ConfigMem.Inst_frame6_bit2.Q
+ sky130_fd_sc_hd__dlxtp_1
X_0843_ net143 net302 VGND VGND VPWR VPWR Tile_X0Y0_OpenRAM_top.Inst_OpenRAM_top_ConfigMem.Inst_frame4_bit7.Q
+ sky130_fd_sc_hd__dlxtp_1
X_0774_ net117 net318 VGND VGND VPWR VPWR Tile_X0Y0_OpenRAM_top.Inst_OpenRAM_top_ConfigMem.Inst_frame2_bit12.Q
+ sky130_fd_sc_hd__dlxtp_1
XFILLER_161_107 VGND VGND VPWR VPWR sky130_fd_sc_hd__decap_3
XFILLER_154_192 VGND VGND VPWR VPWR sky130_fd_sc_hd__decap_3
XFILLER_102_218 VGND VGND VPWR VPWR sky130_fd_sc_hd__decap_3
XFILLER_68_132 VGND VGND VPWR VPWR sky130_fd_sc_hd__decap_3
X_1326_ Tile_X0Y0_OpenRAM_top.Inst_OpenRAM_top_switch_matrix.N2BEGb5 VGND VGND VPWR
+ VPWR net486 sky130_fd_sc_hd__buf_4
XFILLER_68_165 VGND VGND VPWR VPWR sky130_fd_sc_hd__decap_3
XFILLER_83_102 VGND VGND VPWR VPWR sky130_fd_sc_hd__decap_3
XFILLER_83_113 VGND VGND VPWR VPWR sky130_fd_sc_hd__decap_3
X_1257_ net114 VGND VGND VPWR VPWR net417 sky130_fd_sc_hd__buf_1
XFILLER_83_146 VGND VGND VPWR VPWR sky130_fd_sc_hd__decap_3
X_1188_ net244 net281 VGND VGND VPWR VPWR Tile_X0Y1_OpenRAM_bot.Inst_OpenRAM_bot_ConfigMem.Inst_frame6_bit2.Q
+ sky130_fd_sc_hd__dlxtp_1
XFILLER_149_16 VGND VGND VPWR VPWR sky130_fd_sc_hd__decap_3
XFILLER_149_49 VGND VGND VPWR VPWR sky130_fd_sc_hd__decap_3
XTAP_TAPCELL_ROW_22_458 VGND VPWR sky130_fd_sc_hd__tapvpwrvgnd_1
XFILLER_137_126 VGND VGND VPWR VPWR sky130_fd_sc_hd__decap_3
XFILLER_137_159 VGND VGND VPWR VPWR sky130_fd_sc_hd__decap_3
XTAP_TAPCELL_ROW_30_491 VGND VPWR sky130_fd_sc_hd__tapvpwrvgnd_1
XFILLER_165_15 VGND VGND VPWR VPWR sky130_fd_sc_hd__decap_3
XFILLER_152_118 VGND VGND VPWR VPWR sky130_fd_sc_hd__decap_3
XFILLER_116_7 VGND VGND VPWR VPWR sky130_fd_sc_hd__fill_1
XFILLER_145_192 VGND VGND VPWR VPWR sky130_fd_sc_hd__decap_3
XFILLER_3_128 VGND VGND VPWR VPWR sky130_fd_sc_hd__decap_3
XFILLER_160_162 VGND VGND VPWR VPWR sky130_fd_sc_hd__decap_3
XTAP_TAPCELL_ROW_7_401 VGND VPWR sky130_fd_sc_hd__tapvpwrvgnd_1
XFILLER_160_195 VGND VGND VPWR VPWR sky130_fd_sc_hd__fill_1
Xoutput293 net376 VGND VGND VPWR VPWR ADDR_B_SRAM3 sky130_fd_sc_hd__buf_2
XFILLER_58_24 VGND VGND VPWR VPWR sky130_fd_sc_hd__decap_3
XFILLER_58_35 VGND VGND VPWR VPWR sky130_fd_sc_hd__decap_3
Xoutput282 net365 VGND VGND VPWR VPWR ADDR_A_SRAM0 sky130_fd_sc_hd__buf_2
XFILLER_59_143 VGND VGND VPWR VPWR sky130_fd_sc_hd__decap_3
XFILLER_114_41 VGND VGND VPWR VPWR sky130_fd_sc_hd__decap_3
XFILLER_114_85 VGND VGND VPWR VPWR sky130_fd_sc_hd__decap_3
XFILLER_15_213 VGND VGND VPWR VPWR sky130_fd_sc_hd__decap_3
XTAP_TAPCELL_ROW_53_583 VGND VPWR sky130_fd_sc_hd__tapvpwrvgnd_1
XTAP_TAPCELL_ROW_13_425 VGND VPWR sky130_fd_sc_hd__tapvpwrvgnd_1
XFILLER_90_77 VGND VGND VPWR VPWR sky130_fd_sc_hd__decap_3
XFILLER_128_115 VGND VGND VPWR VPWR sky130_fd_sc_hd__decap_3
XFILLER_139_60 VGND VGND VPWR VPWR sky130_fd_sc_hd__decap_3
XFILLER_128_159 VGND VGND VPWR VPWR sky130_fd_sc_hd__decap_3
XFILLER_143_107 VGND VGND VPWR VPWR sky130_fd_sc_hd__decap_3
XFILLER_99_42 VGND VGND VPWR VPWR sky130_fd_sc_hd__decap_3
XFILLER_99_75 VGND VGND VPWR VPWR sky130_fd_sc_hd__decap_3
XFILLER_151_140 VGND VGND VPWR VPWR sky130_fd_sc_hd__fill_1
X_0490_ _0130_ _0129_ _0127_ _0128_ Tile_X0Y0_OpenRAM_top.Inst_OpenRAM_top_ConfigMem.Inst_frame7_bit13.Q
+ Tile_X0Y0_OpenRAM_top.Inst_OpenRAM_top_ConfigMem.Inst_frame7_bit14.Q VGND VGND VPWR
+ VPWR Tile_X0Y0_OpenRAM_top.Inst_OpenRAM_top_switch_matrix.N4BEG3 sky130_fd_sc_hd__mux4_1
XFILLER_97_216 VGND VGND VPWR VPWR sky130_fd_sc_hd__decap_3
XFILLER_151_184 VGND VGND VPWR VPWR sky130_fd_sc_hd__decap_3
XFILLER_2_183 VGND VGND VPWR VPWR sky130_fd_sc_hd__decap_3
XFILLER_65_102 VGND VGND VPWR VPWR sky130_fd_sc_hd__decap_3
XFILLER_65_113 VGND VGND VPWR VPWR sky130_fd_sc_hd__decap_3
X_1111_ net228 net297 VGND VGND VPWR VPWR Tile_X0Y1_OpenRAM_bot.Inst_OpenRAM_bot_ConfigMem.Inst_frame4_bit15.Q
+ sky130_fd_sc_hd__dlxtp_1
XFILLER_65_146 VGND VGND VPWR VPWR sky130_fd_sc_hd__decap_3
XTAP_TAPCELL_ROW_36_517 VGND VPWR sky130_fd_sc_hd__tapvpwrvgnd_1
X_1042_ net234 net315 VGND VGND VPWR VPWR Tile_X0Y1_OpenRAM_bot.Inst_OpenRAM_bot_ConfigMem.Inst_frame2_bit20.Q
+ sky130_fd_sc_hd__dlxtp_1
XTAP_TAPCELL_ROW_76_675 VGND VPWR sky130_fd_sc_hd__tapvpwrvgnd_1
XPHY_EDGE_ROW_100_Left_283 VGND VGND VPWR VPWR sky130_fd_sc_hd__decap_3
XFILLER_21_216 VGND VGND VPWR VPWR sky130_fd_sc_hd__decap_3
XFILLER_9_51 VGND VGND VPWR VPWR sky130_fd_sc_hd__decap_3
XFILLER_174_221 VGND VGND VPWR VPWR sky130_fd_sc_hd__decap_3
XFILLER_119_104 VGND VGND VPWR VPWR sky130_fd_sc_hd__decap_3
XFILLER_9_84 VGND VGND VPWR VPWR sky130_fd_sc_hd__decap_3
X_0826_ net130 net300 VGND VGND VPWR VPWR Tile_X0Y0_OpenRAM_top.Inst_OpenRAM_top_ConfigMem.Inst_frame4_bit24.Q
+ sky130_fd_sc_hd__dlxtp_1
XFILLER_127_181 VGND VGND VPWR VPWR sky130_fd_sc_hd__decap_3
X_0757_ net135 net317 VGND VGND VPWR VPWR Tile_X0Y0_OpenRAM_top.Inst_OpenRAM_top_ConfigMem.Inst_frame2_bit29.Q
+ sky130_fd_sc_hd__dlxtp_1
XFILLER_135_29 VGND VGND VPWR VPWR sky130_fd_sc_hd__decap_3
X_0688_ _0214_ _0220_ _0222_ _0224_ VGND VGND VPWR VPWR _0225_ sky130_fd_sc_hd__o211a_1
XFILLER_88_227 VGND VGND VPWR VPWR sky130_fd_sc_hd__decap_3
XTAP_TAPCELL_ROW_99_767 VGND VPWR sky130_fd_sc_hd__tapvpwrvgnd_1
XTAP_TAPCELL_ROW_59_609 VGND VPWR sky130_fd_sc_hd__tapvpwrvgnd_1
XFILLER_56_113 VGND VGND VPWR VPWR sky130_fd_sc_hd__decap_3
X_1309_ Tile_X0Y0_OpenRAM_top.Inst_OpenRAM_top_switch_matrix.N1BEG0 VGND VGND VPWR
+ VPWR net469 sky130_fd_sc_hd__buf_1
XFILLER_178_9 VGND VGND VPWR VPWR sky130_fd_sc_hd__decap_3
XFILLER_56_157 VGND VGND VPWR VPWR sky130_fd_sc_hd__decap_3
XFILLER_44_26 VGND VGND VPWR VPWR sky130_fd_sc_hd__fill_2
XFILLER_64_190 VGND VGND VPWR VPWR sky130_fd_sc_hd__decap_3
XFILLER_100_21 VGND VGND VPWR VPWR sky130_fd_sc_hd__decap_3
XFILLER_12_227 VGND VGND VPWR VPWR sky130_fd_sc_hd__decap_3
XFILLER_100_32 VGND VGND VPWR VPWR sky130_fd_sc_hd__decap_3
XFILLER_8_209 VGND VGND VPWR VPWR sky130_fd_sc_hd__decap_3
XFILLER_100_76 VGND VGND VPWR VPWR sky130_fd_sc_hd__decap_3
XFILLER_176_47 VGND VGND VPWR VPWR sky130_fd_sc_hd__decap_3
XFILLER_60_58 VGND VGND VPWR VPWR sky130_fd_sc_hd__decap_3
XFILLER_109_30 VGND VGND VPWR VPWR sky130_fd_sc_hd__decap_3
XFILLER_180_224 VGND VGND VPWR VPWR sky130_fd_sc_hd__decap_3
XFILLER_118_192 VGND VGND VPWR VPWR sky130_fd_sc_hd__decap_3
XFILLER_109_63 VGND VGND VPWR VPWR sky130_fd_sc_hd__decap_3
XFILLER_107_3 VGND VGND VPWR VPWR sky130_fd_sc_hd__fill_2
XFILLER_133_140 VGND VGND VPWR VPWR sky130_fd_sc_hd__fill_2
XFILLER_69_34 VGND VGND VPWR VPWR sky130_fd_sc_hd__decap_3
XFILLER_79_205 VGND VGND VPWR VPWR sky130_fd_sc_hd__decap_3
XFILLER_133_184 VGND VGND VPWR VPWR sky130_fd_sc_hd__decap_3
XFILLER_47_113 VGND VGND VPWR VPWR sky130_fd_sc_hd__decap_3
XFILLER_85_33 VGND VGND VPWR VPWR sky130_fd_sc_hd__decap_3
XTAP_TAPCELL_ROW_117_838 VGND VPWR sky130_fd_sc_hd__tapvpwrvgnd_1
XFILLER_141_72 VGND VGND VPWR VPWR sky130_fd_sc_hd__decap_3
XTAP_TAPCELL_ROW_125_871 VGND VPWR sky130_fd_sc_hd__tapvpwrvgnd_1
XFILLER_70_160 VGND VGND VPWR VPWR sky130_fd_sc_hd__decap_3
XFILLER_34_70 VGND VGND VPWR VPWR sky130_fd_sc_hd__fill_1
XFILLER_70_193 VGND VGND VPWR VPWR sky130_fd_sc_hd__decap_3
XFILLER_93_9 VGND VGND VPWR VPWR sky130_fd_sc_hd__decap_3
XFILLER_7_231 VGND VGND VPWR VPWR sky130_fd_sc_hd__decap_3
XFILLER_7_220 VGND VGND VPWR VPWR sky130_fd_sc_hd__decap_3
XFILLER_171_202 VGND VGND VPWR VPWR sky130_fd_sc_hd__decap_3
XFILLER_109_181 VGND VGND VPWR VPWR sky130_fd_sc_hd__decap_3
X_0611_ net215 net208 net196 _0145_ Tile_X0Y1_OpenRAM_bot.Inst_OpenRAM_bot_ConfigMem.Inst_frame2_bit18.Q
+ Tile_X0Y1_OpenRAM_bot.Inst_OpenRAM_bot_ConfigMem.Inst_frame2_bit19.Q VGND VGND VPWR
+ VPWR net388 sky130_fd_sc_hd__mux4_2
XFILLER_50_80 VGND VGND VPWR VPWR sky130_fd_sc_hd__decap_3
XFILLER_50_91 VGND VGND VPWR VPWR sky130_fd_sc_hd__decap_3
XFILLER_166_91 VGND VGND VPWR VPWR sky130_fd_sc_hd__fill_1
X_0542_ net6 net38 net260 _0084_ Tile_X0Y1_OpenRAM_bot.Inst_OpenRAM_bot_ConfigMem.Inst_frame5_bit8.Q
+ Tile_X0Y1_OpenRAM_bot.Inst_OpenRAM_bot_ConfigMem.Inst_frame5_bit9.Q VGND VGND VPWR
+ VPWR Tile_X0Y1_OpenRAM_bot.Inst_OpenRAM_bot_switch_matrix.W2BEGb4 sky130_fd_sc_hd__mux4_1
XFILLER_124_162 VGND VGND VPWR VPWR sky130_fd_sc_hd__decap_3
X_0473_ _0114_ _0115_ _0116_ Tile_X0Y0_OpenRAM_top.Inst_OpenRAM_top_ConfigMem.Inst_frame7_bit5.Q
+ Tile_X0Y0_OpenRAM_top.Inst_OpenRAM_top_ConfigMem.Inst_frame7_bit6.Q VGND VGND VPWR
+ VPWR _0117_ sky130_fd_sc_hd__a221o_1
XTAP_TAPCELL_ROW_148_963 VGND VPWR sky130_fd_sc_hd__tapvpwrvgnd_1
XFILLER_85_208 VGND VGND VPWR VPWR sky130_fd_sc_hd__decap_3
XTAP_TAPCELL_ROW_108_805 VGND VPWR sky130_fd_sc_hd__tapvpwrvgnd_1
XFILLER_38_135 VGND VGND VPWR VPWR sky130_fd_sc_hd__decap_3
XFILLER_38_179 VGND VGND VPWR VPWR sky130_fd_sc_hd__fill_2
XFILLER_53_138 VGND VGND VPWR VPWR sky130_fd_sc_hd__fill_1
XFILLER_46_190 VGND VGND VPWR VPWR sky130_fd_sc_hd__decap_3
X_1025_ net249 net325 VGND VGND VPWR VPWR Tile_X0Y1_OpenRAM_bot.Inst_OpenRAM_bot_ConfigMem.Inst_frame1_bit5.Q
+ sky130_fd_sc_hd__dlxtp_1
XTAP_TAPCELL_ROW_131_896 VGND VPWR sky130_fd_sc_hd__tapvpwrvgnd_1
XFILLER_14_29 VGND VGND VPWR VPWR sky130_fd_sc_hd__decap_3
X_0809_ net145 net311 VGND VGND VPWR VPWR Tile_X0Y0_OpenRAM_top.Inst_OpenRAM_top_ConfigMem.Inst_frame3_bit9.Q
+ sky130_fd_sc_hd__dlxtp_1
XFILLER_162_27 VGND VGND VPWR VPWR sky130_fd_sc_hd__fill_1
XFILLER_29_157 VGND VGND VPWR VPWR sky130_fd_sc_hd__decap_3
XFILLER_176_6 VGND VGND VPWR VPWR sky130_fd_sc_hd__decap_3
XTAP_TAPCELL_ROW_154_988 VGND VPWR sky130_fd_sc_hd__tapvpwrvgnd_1
XFILLER_44_127 VGND VGND VPWR VPWR sky130_fd_sc_hd__decap_3
XFILLER_55_69 VGND VGND VPWR VPWR sky130_fd_sc_hd__fill_2
XFILLER_37_190 VGND VGND VPWR VPWR sky130_fd_sc_hd__decap_3
XFILLER_111_42 VGND VGND VPWR VPWR sky130_fd_sc_hd__decap_3
XFILLER_111_97 VGND VGND VPWR VPWR sky130_fd_sc_hd__fill_2
XFILLER_111_75 VGND VGND VPWR VPWR sky130_fd_sc_hd__decap_3
XFILLER_71_24 VGND VGND VPWR VPWR sky130_fd_sc_hd__decap_3
XFILLER_71_57 VGND VGND VPWR VPWR sky130_fd_sc_hd__decap_3
XFILLER_71_79 VGND VGND VPWR VPWR sky130_fd_sc_hd__decap_3
XFILLER_4_212 VGND VGND VPWR VPWR sky130_fd_sc_hd__decap_3
XFILLER_20_61 VGND VGND VPWR VPWR sky130_fd_sc_hd__decap_3
XFILLER_136_50 VGND VGND VPWR VPWR sky130_fd_sc_hd__decap_3
XFILLER_106_162 VGND VGND VPWR VPWR sky130_fd_sc_hd__decap_3
XFILLER_20_94 VGND VGND VPWR VPWR sky130_fd_sc_hd__decap_3
XFILLER_20_83 VGND VGND VPWR VPWR sky130_fd_sc_hd__fill_1
XFILLER_136_83 VGND VGND VPWR VPWR sky130_fd_sc_hd__fill_1
XFILLER_121_143 VGND VGND VPWR VPWR sky130_fd_sc_hd__decap_3
XFILLER_96_76 VGND VGND VPWR VPWR sky130_fd_sc_hd__decap_3
XFILLER_121_187 VGND VGND VPWR VPWR sky130_fd_sc_hd__decap_3
XFILLER_29_70 VGND VGND VPWR VPWR sky130_fd_sc_hd__decap_3
XFILLER_152_71 VGND VGND VPWR VPWR sky130_fd_sc_hd__decap_3
XFILLER_35_105 VGND VGND VPWR VPWR sky130_fd_sc_hd__decap_3
XFILLER_35_116 VGND VGND VPWR VPWR sky130_fd_sc_hd__decap_3
XFILLER_90_222 VGND VGND VPWR VPWR sky130_fd_sc_hd__decap_3
XFILLER_35_149 VGND VGND VPWR VPWR sky130_fd_sc_hd__decap_3
XFILLER_45_91 VGND VGND VPWR VPWR sky130_fd_sc_hd__decap_3
XTAP_TAPCELL_ROW_61_615 VGND VPWR sky130_fd_sc_hd__tapvpwrvgnd_1
XFILLER_91_6 VGND VGND VPWR VPWR sky130_fd_sc_hd__decap_3
XFILLER_129_210 VGND VGND VPWR VPWR sky130_fd_sc_hd__decap_3
XFILLER_61_90 VGND VGND VPWR VPWR sky130_fd_sc_hd__decap_3
XFILLER_177_90 VGND VGND VPWR VPWR sky130_fd_sc_hd__decap_3
XFILLER_144_224 VGND VGND VPWR VPWR sky130_fd_sc_hd__decap_3
XFILLER_6_41 VGND VGND VPWR VPWR sky130_fd_sc_hd__decap_3
XFILLER_6_85 VGND VGND VPWR VPWR sky130_fd_sc_hd__decap_3
XFILLER_6_74 VGND VGND VPWR VPWR sky130_fd_sc_hd__decap_3
XFILLER_112_110 VGND VGND VPWR VPWR sky130_fd_sc_hd__decap_3
X_0525_ net177 net178 net186 _0087_ Tile_X0Y1_OpenRAM_bot.Inst_OpenRAM_bot_ConfigMem.Inst_frame7_bit27.Q
+ Tile_X0Y1_OpenRAM_bot.Inst_OpenRAM_bot_ConfigMem.Inst_frame7_bit26.Q VGND VGND VPWR
+ VPWR Tile_X0Y1_OpenRAM_bot.Inst_OpenRAM_bot_switch_matrix.S2BEG7 sky130_fd_sc_hd__mux4_1
X_0456_ _0104_ Tile_X0Y0_OpenRAM_top.Inst_OpenRAM_top_ConfigMem.Inst_frame2_bit31.Q
+ _0008_ _0103_ VGND VGND VPWR VPWR net372 sky130_fd_sc_hd__a2bb2o_2
XFILLER_112_165 VGND VGND VPWR VPWR sky130_fd_sc_hd__decap_3
X_0387_ net11 net43 Tile_X0Y0_OpenRAM_top.Inst_OpenRAM_top_switch_matrix.J_NS4_BEG14
+ Tile_X0Y0_OpenRAM_top.Inst_OpenRAM_top_switch_matrix.J_NS2_BEG6 Tile_X0Y0_OpenRAM_top.Inst_OpenRAM_top_ConfigMem.Inst_frame5_bit30.Q
+ Tile_X0Y0_OpenRAM_top.Inst_OpenRAM_top_ConfigMem.Inst_frame5_bit31.Q VGND VGND VPWR
+ VPWR Tile_X0Y0_OpenRAM_top.Inst_OpenRAM_top_switch_matrix.WW4BEG1 sky130_fd_sc_hd__mux4_1
XTAP_TAPCELL_ROW_84_707 VGND VPWR sky130_fd_sc_hd__tapvpwrvgnd_1
XFILLER_26_116 VGND VGND VPWR VPWR sky130_fd_sc_hd__decap_3
XFILLER_19_190 VGND VGND VPWR VPWR sky130_fd_sc_hd__decap_3
XTAP_TAPCELL_ROW_92_740 VGND VPWR sky130_fd_sc_hd__tapvpwrvgnd_1
XFILLER_25_39 VGND VGND VPWR VPWR sky130_fd_sc_hd__decap_3
X_1008_ net236 net323 VGND VGND VPWR VPWR Tile_X0Y1_OpenRAM_bot.Inst_OpenRAM_bot_ConfigMem.Inst_frame1_bit22.Q
+ sky130_fd_sc_hd__dlxtp_1
XFILLER_41_119 VGND VGND VPWR VPWR sky130_fd_sc_hd__decap_3
XFILLER_41_38 VGND VGND VPWR VPWR sky130_fd_sc_hd__decap_3
XFILLER_173_15 VGND VGND VPWR VPWR sky130_fd_sc_hd__decap_3
XFILLER_150_227 VGND VGND VPWR VPWR sky130_fd_sc_hd__decap_3
XFILLER_173_48 VGND VGND VPWR VPWR sky130_fd_sc_hd__decap_3
XFILLER_106_20 VGND VGND VPWR VPWR sky130_fd_sc_hd__decap_3
XFILLER_103_110 VGND VGND VPWR VPWR sky130_fd_sc_hd__fill_2
XFILLER_106_53 VGND VGND VPWR VPWR sky130_fd_sc_hd__decap_3
XFILLER_49_219 VGND VGND VPWR VPWR sky130_fd_sc_hd__decap_3
XFILLER_103_187 VGND VGND VPWR VPWR sky130_fd_sc_hd__decap_3
XFILLER_66_24 VGND VGND VPWR VPWR sky130_fd_sc_hd__decap_3
XFILLER_66_35 VGND VGND VPWR VPWR sky130_fd_sc_hd__decap_3
XFILLER_106_97 VGND VGND VPWR VPWR sky130_fd_sc_hd__decap_3
XFILLER_174_3 VGND VGND VPWR VPWR sky130_fd_sc_hd__decap_3
XFILLER_122_41 VGND VGND VPWR VPWR sky130_fd_sc_hd__decap_3
XFILLER_17_116 VGND VGND VPWR VPWR sky130_fd_sc_hd__decap_3
XFILLER_72_200 VGND VGND VPWR VPWR sky130_fd_sc_hd__decap_3
XFILLER_122_74 VGND VGND VPWR VPWR sky130_fd_sc_hd__decap_3
XFILLER_72_233 VGND VGND VPWR VPWR sky130_fd_sc_hd__fill_1
XFILLER_82_12 VGND VGND VPWR VPWR sky130_fd_sc_hd__decap_3
XFILLER_122_85 VGND VGND VPWR VPWR sky130_fd_sc_hd__decap_3
XTAP_TAPCELL_ROW_110_811 VGND VPWR sky130_fd_sc_hd__tapvpwrvgnd_1
XFILLER_25_193 VGND VGND VPWR VPWR sky130_fd_sc_hd__decap_3
XFILLER_82_67 VGND VGND VPWR VPWR sky130_fd_sc_hd__decap_3
XFILLER_15_94 VGND VGND VPWR VPWR sky130_fd_sc_hd__decap_3
XFILLER_40_174 VGND VGND VPWR VPWR sky130_fd_sc_hd__decap_3
XFILLER_126_224 VGND VGND VPWR VPWR sky130_fd_sc_hd__fill_1
XFILLER_99_108 VGND VGND VPWR VPWR sky130_fd_sc_hd__decap_3
XFILLER_147_93 VGND VGND VPWR VPWR sky130_fd_sc_hd__decap_3
XPHY_EDGE_ROW_128_Right_128 VGND VGND VPWR VPWR sky130_fd_sc_hd__decap_3
XFILLER_99_119 VGND VGND VPWR VPWR sky130_fd_sc_hd__decap_3
X_0310_ Tile_X0Y0_OpenRAM_top.Inst_OpenRAM_top_switch_matrix.N1END2 net363 net148
+ net168 Tile_X0Y0_OpenRAM_top.Inst_OpenRAM_top_ConfigMem.Inst_frame0_bit4.Q Tile_X0Y0_OpenRAM_top.Inst_OpenRAM_top_ConfigMem.Inst_frame0_bit5.Q
+ VGND VGND VPWR VPWR Tile_X0Y0_OpenRAM_top.Inst_OpenRAM_top_switch_matrix.J_NS4_BEG14
+ sky130_fd_sc_hd__mux4_2
XFILLER_163_81 VGND VGND VPWR VPWR sky130_fd_sc_hd__decap_3
X_1290_ net328 VGND VGND VPWR VPWR net460 sky130_fd_sc_hd__buf_1
Xinput171 Tile_X0Y0_S4END[5] VGND VGND VPWR VPWR net171 sky130_fd_sc_hd__clkbuf_4
Xinput160 Tile_X0Y0_S2MID[2] VGND VGND VPWR VPWR net160 sky130_fd_sc_hd__buf_2
X_0241_ Tile_X0Y0_OpenRAM_top.Inst_OpenRAM_top_ConfigMem.Inst_frame7_bit9.Q VGND VGND
+ VPWR VPWR _0014_ sky130_fd_sc_hd__inv_1
XTAP_TAPCELL_ROW_133_903 VGND VPWR sky130_fd_sc_hd__tapvpwrvgnd_1
Xinput193 Tile_X0Y1_E2MID[7] VGND VGND VPWR VPWR net193 sky130_fd_sc_hd__buf_1
Xinput182 Tile_X0Y1_E2END[4] VGND VGND VPWR VPWR net182 sky130_fd_sc_hd__clkbuf_2
XFILLER_63_211 VGND VGND VPWR VPWR sky130_fd_sc_hd__decap_3
XFILLER_23_119 VGND VGND VPWR VPWR sky130_fd_sc_hd__decap_3
XFILLER_16_171 VGND VGND VPWR VPWR sky130_fd_sc_hd__decap_3
XFILLER_176_124 VGND VGND VPWR VPWR sky130_fd_sc_hd__decap_3
XFILLER_31_163 VGND VGND VPWR VPWR sky130_fd_sc_hd__decap_3
XFILLER_176_168 VGND VGND VPWR VPWR sky130_fd_sc_hd__decap_3
XFILLER_31_196 VGND VGND VPWR VPWR sky130_fd_sc_hd__decap_3
XFILLER_117_202 VGND VGND VPWR VPWR sky130_fd_sc_hd__fill_1
XFILLER_11_19 VGND VGND VPWR VPWR sky130_fd_sc_hd__decap_3
Xfanout305 net306 VGND VGND VPWR VPWR net305 sky130_fd_sc_hd__clkbuf_2
Xfanout327 net329 VGND VGND VPWR VPWR net327 sky130_fd_sc_hd__clkbuf_2
X_0508_ _0144_ _0143_ Tile_X0Y0_OpenRAM_top.Inst_OpenRAM_top_ConfigMem.Inst_frame6_bit17.Q
+ VGND VGND VPWR VPWR Tile_X0Y0_OpenRAM_top.Inst_OpenRAM_top_switch_matrix.S4BEG3
+ sky130_fd_sc_hd__mux2_1
Xfanout316 net321 VGND VGND VPWR VPWR net316 sky130_fd_sc_hd__clkbuf_2
Xfanout338 Tile_X0Y1_FrameStrobe[0] VGND VGND VPWR VPWR net338 sky130_fd_sc_hd__clkbuf_2
XTAP_TAPCELL_ROW_168_1044 VGND VPWR sky130_fd_sc_hd__tapvpwrvgnd_1
XFILLER_100_124 VGND VGND VPWR VPWR sky130_fd_sc_hd__decap_3
X_1488_ Tile_X0Y1_OpenRAM_bot.Inst_OpenRAM_bot_switch_matrix.W6BEG6 VGND VGND VPWR
+ VPWR net650 sky130_fd_sc_hd__buf_1
X_0439_ net66 net108 net101 Tile_X0Y0_OpenRAM_top.Inst_OpenRAM_top_switch_matrix.J_NS4_BEG12
+ Tile_X0Y0_OpenRAM_top.Inst_OpenRAM_top_ConfigMem.Inst_frame2_bit12.Q Tile_X0Y0_OpenRAM_top.Inst_OpenRAM_top_ConfigMem.Inst_frame2_bit13.Q
+ VGND VGND VPWR VPWR net406 sky130_fd_sc_hd__mux4_2
XFILLER_54_200 VGND VGND VPWR VPWR sky130_fd_sc_hd__decap_3
XFILLER_36_38 VGND VGND VPWR VPWR sky130_fd_sc_hd__decap_3
XFILLER_14_119 VGND VGND VPWR VPWR sky130_fd_sc_hd__decap_3
XFILLER_168_15 VGND VGND VPWR VPWR sky130_fd_sc_hd__decap_3
XFILLER_167_113 VGND VGND VPWR VPWR sky130_fd_sc_hd__decap_3
XFILLER_22_130 VGND VGND VPWR VPWR sky130_fd_sc_hd__fill_1
XFILLER_22_185 VGND VGND VPWR VPWR sky130_fd_sc_hd__decap_3
XFILLER_168_59 VGND VGND VPWR VPWR sky130_fd_sc_hd__decap_3
XFILLER_108_224 VGND VGND VPWR VPWR sky130_fd_sc_hd__decap_3
XFILLER_175_190 VGND VGND VPWR VPWR sky130_fd_sc_hd__decap_3
XFILLER_123_205 VGND VGND VPWR VPWR sky130_fd_sc_hd__decap_3
XFILLER_117_63 VGND VGND VPWR VPWR sky130_fd_sc_hd__decap_3
XFILLER_117_41 VGND VGND VPWR VPWR sky130_fd_sc_hd__decap_3
XFILLER_77_12 VGND VGND VPWR VPWR sky130_fd_sc_hd__decap_3
XFILLER_77_45 VGND VGND VPWR VPWR sky130_fd_sc_hd__decap_3
XFILLER_89_152 VGND VGND VPWR VPWR sky130_fd_sc_hd__decap_3
XFILLER_133_84 VGND VGND VPWR VPWR sky130_fd_sc_hd__decap_3
XFILLER_93_33 VGND VGND VPWR VPWR sky130_fd_sc_hd__decap_3
XFILLER_45_222 VGND VGND VPWR VPWR sky130_fd_sc_hd__fill_2
XFILLER_93_77 VGND VGND VPWR VPWR sky130_fd_sc_hd__decap_3
XFILLER_26_82 VGND VGND VPWR VPWR sky130_fd_sc_hd__fill_2
XFILLER_9_134 VGND VGND VPWR VPWR sky130_fd_sc_hd__decap_3
XFILLER_173_105 VGND VGND VPWR VPWR sky130_fd_sc_hd__decap_3
XFILLER_13_196 VGND VGND VPWR VPWR sky130_fd_sc_hd__decap_3
XFILLER_9_167 VGND VGND VPWR VPWR sky130_fd_sc_hd__fill_1
XFILLER_173_116 VGND VGND VPWR VPWR sky130_fd_sc_hd__decap_3
X_0790_ net134 net311 VGND VGND VPWR VPWR Tile_X0Y0_OpenRAM_top.Inst_OpenRAM_top_ConfigMem.Inst_frame3_bit28.Q
+ sky130_fd_sc_hd__dlxtp_1
XFILLER_9_178 VGND VGND VPWR VPWR sky130_fd_sc_hd__decap_3
XFILLER_173_149 VGND VGND VPWR VPWR sky130_fd_sc_hd__decap_3
XFILLER_114_227 VGND VGND VPWR VPWR sky130_fd_sc_hd__decap_3
X_1411_ net230 VGND VGND VPWR VPWR net562 sky130_fd_sc_hd__buf_4
XFILLER_174_91 VGND VGND VPWR VPWR sky130_fd_sc_hd__decap_3
XFILLER_174_80 VGND VGND VPWR VPWR sky130_fd_sc_hd__decap_3
X_1342_ Tile_X0Y0_OpenRAM_top.Inst_OpenRAM_top_switch_matrix.N4BEG1 VGND VGND VPWR
+ VPWR net493 sky130_fd_sc_hd__buf_1
XFILLER_3_42 VGND VGND VPWR VPWR sky130_fd_sc_hd__decap_3
XFILLER_95_111 VGND VGND VPWR VPWR sky130_fd_sc_hd__fill_1
XFILLER_95_122 VGND VGND VPWR VPWR sky130_fd_sc_hd__fill_1
X_1273_ net121 VGND VGND VPWR VPWR net424 sky130_fd_sc_hd__buf_1
XFILLER_3_75 VGND VGND VPWR VPWR sky130_fd_sc_hd__decap_3
XFILLER_95_133 VGND VGND VPWR VPWR sky130_fd_sc_hd__decap_3
XFILLER_51_214 VGND VGND VPWR VPWR sky130_fd_sc_hd__decap_3
XFILLER_149_146 VGND VGND VPWR VPWR sky130_fd_sc_hd__decap_3
XFILLER_22_29 VGND VGND VPWR VPWR sky130_fd_sc_hd__decap_3
XFILLER_138_29 VGND VGND VPWR VPWR sky130_fd_sc_hd__decap_3
X_0988_ net223 net333 VGND VGND VPWR VPWR Tile_X0Y1_OpenRAM_bot.Inst_OpenRAM_bot_ConfigMem.Inst_frame0_bit10.Q
+ sky130_fd_sc_hd__dlxtp_1
Xoutput420 net503 VGND VGND VPWR VPWR Tile_X0Y0_N4BEG[8] sky130_fd_sc_hd__buf_2
XFILLER_172_171 VGND VGND VPWR VPWR sky130_fd_sc_hd__decap_3
XFILLER_105_205 VGND VGND VPWR VPWR sky130_fd_sc_hd__decap_3
Xoutput453 net536 VGND VGND VPWR VPWR Tile_X0Y0_W6BEG[8] sky130_fd_sc_hd__buf_2
Xoutput442 net525 VGND VGND VPWR VPWR Tile_X0Y0_W2BEGb[7] sky130_fd_sc_hd__buf_2
Xoutput431 net514 VGND VGND VPWR VPWR Tile_X0Y0_W2BEG[4] sky130_fd_sc_hd__buf_2
Xoutput486 net569 VGND VGND VPWR VPWR Tile_X0Y1_FrameData_O[23] sky130_fd_sc_hd__buf_2
Xoutput475 net558 VGND VGND VPWR VPWR Tile_X0Y1_FrameData_O[13] sky130_fd_sc_hd__buf_2
Xoutput464 net547 VGND VGND VPWR VPWR Tile_X0Y0_WW4BEG[3] sky130_fd_sc_hd__buf_2
Xoutput497 net580 VGND VGND VPWR VPWR Tile_X0Y1_FrameData_O[4] sky130_fd_sc_hd__buf_2
XFILLER_86_133 VGND VGND VPWR VPWR sky130_fd_sc_hd__fill_1
XFILLER_170_38 VGND VGND VPWR VPWR sky130_fd_sc_hd__decap_3
XFILLER_170_27 VGND VGND VPWR VPWR sky130_fd_sc_hd__fill_1
XFILLER_27_200 VGND VGND VPWR VPWR sky130_fd_sc_hd__decap_3
XFILLER_86_177 VGND VGND VPWR VPWR sky130_fd_sc_hd__decap_3
XFILLER_103_21 VGND VGND VPWR VPWR sky130_fd_sc_hd__decap_3
XTAP_TAPCELL_ROW_181_1096 VGND VPWR sky130_fd_sc_hd__tapvpwrvgnd_1
XFILLER_42_203 VGND VGND VPWR VPWR sky130_fd_sc_hd__decap_3
XFILLER_103_98 VGND VGND VPWR VPWR sky130_fd_sc_hd__decap_3
XFILLER_179_36 VGND VGND VPWR VPWR sky130_fd_sc_hd__decap_3
XFILLER_63_69 VGND VGND VPWR VPWR sky130_fd_sc_hd__fill_1
XFILLER_179_69 VGND VGND VPWR VPWR sky130_fd_sc_hd__decap_3
XFILLER_10_100 VGND VGND VPWR VPWR sky130_fd_sc_hd__decap_3
XFILLER_155_105 VGND VGND VPWR VPWR sky130_fd_sc_hd__decap_3
XPHY_EDGE_ROW_146_Left_329 VGND VGND VPWR VPWR sky130_fd_sc_hd__decap_3
XFILLER_10_133 VGND VGND VPWR VPWR sky130_fd_sc_hd__decap_3
XFILLER_155_116 VGND VGND VPWR VPWR sky130_fd_sc_hd__decap_3
XFILLER_10_177 VGND VGND VPWR VPWR sky130_fd_sc_hd__decap_3
XFILLER_10_144 VGND VGND VPWR VPWR sky130_fd_sc_hd__decap_3
XFILLER_6_115 VGND VGND VPWR VPWR sky130_fd_sc_hd__decap_3
XFILLER_155_149 VGND VGND VPWR VPWR sky130_fd_sc_hd__decap_3
XFILLER_12_62 VGND VGND VPWR VPWR sky130_fd_sc_hd__decap_3
XFILLER_6_159 VGND VGND VPWR VPWR sky130_fd_sc_hd__decap_3
XFILLER_163_193 VGND VGND VPWR VPWR sky130_fd_sc_hd__decap_3
XFILLER_88_44 VGND VGND VPWR VPWR sky130_fd_sc_hd__decap_3
XFILLER_88_77 VGND VGND VPWR VPWR sky130_fd_sc_hd__decap_3
XPHY_EDGE_ROW_155_Left_338 VGND VGND VPWR VPWR sky130_fd_sc_hd__decap_3
XFILLER_77_100 VGND VGND VPWR VPWR sky130_fd_sc_hd__decap_3
XFILLER_77_122 VGND VGND VPWR VPWR sky130_fd_sc_hd__decap_3
XFILLER_144_72 VGND VGND VPWR VPWR sky130_fd_sc_hd__decap_3
XFILLER_18_200 VGND VGND VPWR VPWR sky130_fd_sc_hd__decap_3
XFILLER_77_199 VGND VGND VPWR VPWR sky130_fd_sc_hd__decap_3
XFILLER_92_136 VGND VGND VPWR VPWR sky130_fd_sc_hd__decap_3
XFILLER_92_147 VGND VGND VPWR VPWR sky130_fd_sc_hd__decap_3
XFILLER_37_81 VGND VGND VPWR VPWR sky130_fd_sc_hd__decap_3
XFILLER_33_214 VGND VGND VPWR VPWR sky130_fd_sc_hd__decap_3
XFILLER_33_225 VGND VGND VPWR VPWR sky130_fd_sc_hd__decap_3
XTAP_TAPCELL_ROW_16_434 VGND VPWR sky130_fd_sc_hd__tapvpwrvgnd_1
XPHY_EDGE_ROW_164_Left_347 VGND VGND VPWR VPWR sky130_fd_sc_hd__decap_3
X_0911_ net139 net284 VGND VGND VPWR VPWR Tile_X0Y0_OpenRAM_top.Inst_OpenRAM_top_ConfigMem.Inst_frame6_bit3.Q
+ sky130_fd_sc_hd__dlxtp_1
XFILLER_146_138 VGND VGND VPWR VPWR sky130_fd_sc_hd__fill_2
X_0842_ net144 net302 VGND VGND VPWR VPWR Tile_X0Y0_OpenRAM_top.Inst_OpenRAM_top_ConfigMem.Inst_frame4_bit8.Q
+ sky130_fd_sc_hd__dlxtp_1
X_0773_ net118 net318 VGND VGND VPWR VPWR Tile_X0Y0_OpenRAM_top.Inst_OpenRAM_top_ConfigMem.Inst_frame2_bit13.Q
+ sky130_fd_sc_hd__dlxtp_1
XPHY_EDGE_ROW_180_Right_180 VGND VGND VPWR VPWR sky130_fd_sc_hd__decap_3
XFILLER_161_119 VGND VGND VPWR VPWR sky130_fd_sc_hd__decap_3
XFILLER_154_171 VGND VGND VPWR VPWR sky130_fd_sc_hd__decap_3
XFILLER_5_181 VGND VGND VPWR VPWR sky130_fd_sc_hd__decap_3
XPHY_EDGE_ROW_173_Left_356 VGND VGND VPWR VPWR sky130_fd_sc_hd__decap_3
XFILLER_68_111 VGND VGND VPWR VPWR sky130_fd_sc_hd__decap_3
XFILLER_68_144 VGND VGND VPWR VPWR sky130_fd_sc_hd__decap_3
X_1325_ Tile_X0Y0_OpenRAM_top.Inst_OpenRAM_top_switch_matrix.N2BEGb4 VGND VGND VPWR
+ VPWR net485 sky130_fd_sc_hd__clkbuf_2
XTAP_TAPCELL_ROW_39_526 VGND VPWR sky130_fd_sc_hd__tapvpwrvgnd_1
XFILLER_68_177 VGND VGND VPWR VPWR sky130_fd_sc_hd__decap_3
X_1256_ clknet_1_1__leaf_Tile_X0Y1_UserCLK VGND VGND VPWR VPWR net382 sky130_fd_sc_hd__buf_2
XFILLER_83_125 VGND VGND VPWR VPWR sky130_fd_sc_hd__decap_3
X_1187_ net247 net281 VGND VGND VPWR VPWR Tile_X0Y1_OpenRAM_bot.Inst_OpenRAM_bot_ConfigMem.Inst_frame6_bit3.Q
+ sky130_fd_sc_hd__dlxtp_1
XFILLER_83_158 VGND VGND VPWR VPWR sky130_fd_sc_hd__decap_3
XPHY_EDGE_ROW_182_Left_365 VGND VGND VPWR VPWR sky130_fd_sc_hd__decap_3
XFILLER_24_203 VGND VGND VPWR VPWR sky130_fd_sc_hd__decap_3
XFILLER_169_208 VGND VGND VPWR VPWR sky130_fd_sc_hd__decap_3
XFILLER_149_28 VGND VGND VPWR VPWR sky130_fd_sc_hd__decap_3
XTAP_TAPCELL_ROW_22_459 VGND VPWR sky130_fd_sc_hd__tapvpwrvgnd_1
XFILLER_137_138 VGND VGND VPWR VPWR sky130_fd_sc_hd__decap_3
XFILLER_165_27 VGND VGND VPWR VPWR sky130_fd_sc_hd__decap_3
XTAP_TAPCELL_ROW_30_492 VGND VPWR sky130_fd_sc_hd__tapvpwrvgnd_1
XFILLER_165_49 VGND VGND VPWR VPWR sky130_fd_sc_hd__decap_3
XFILLER_160_141 VGND VGND VPWR VPWR sky130_fd_sc_hd__decap_3
XFILLER_160_130 VGND VGND VPWR VPWR sky130_fd_sc_hd__decap_3
XFILLER_181_15 VGND VGND VPWR VPWR sky130_fd_sc_hd__decap_3
XFILLER_160_174 VGND VGND VPWR VPWR sky130_fd_sc_hd__decap_3
Xoutput294 net377 VGND VGND VPWR VPWR ADDR_B_SRAM4 sky130_fd_sc_hd__buf_2
XFILLER_59_111 VGND VGND VPWR VPWR sky130_fd_sc_hd__fill_1
Xoutput283 net366 VGND VGND VPWR VPWR ADDR_A_SRAM1 sky130_fd_sc_hd__buf_2
XFILLER_59_122 VGND VGND VPWR VPWR sky130_fd_sc_hd__decap_3
XFILLER_59_155 VGND VGND VPWR VPWR sky130_fd_sc_hd__decap_3
XFILLER_74_147 VGND VGND VPWR VPWR sky130_fd_sc_hd__decap_3
XFILLER_114_97 VGND VGND VPWR VPWR sky130_fd_sc_hd__decap_3
XFILLER_74_169 VGND VGND VPWR VPWR sky130_fd_sc_hd__decap_3
XFILLER_15_225 VGND VGND VPWR VPWR sky130_fd_sc_hd__decap_3
XFILLER_82_191 VGND VGND VPWR VPWR sky130_fd_sc_hd__decap_3
XFILLER_90_12 VGND VGND VPWR VPWR sky130_fd_sc_hd__fill_1
XFILLER_130_85 VGND VGND VPWR VPWR sky130_fd_sc_hd__decap_3
XFILLER_130_74 VGND VGND VPWR VPWR sky130_fd_sc_hd__decap_3
XFILLER_30_206 VGND VGND VPWR VPWR sky130_fd_sc_hd__decap_3
XTAP_TAPCELL_ROW_53_584 VGND VPWR sky130_fd_sc_hd__tapvpwrvgnd_1
XFILLER_128_127 VGND VGND VPWR VPWR sky130_fd_sc_hd__decap_3
XFILLER_139_72 VGND VGND VPWR VPWR sky130_fd_sc_hd__decap_3
XFILLER_99_21 VGND VGND VPWR VPWR sky130_fd_sc_hd__decap_3
XFILLER_143_119 VGND VGND VPWR VPWR sky130_fd_sc_hd__decap_3
XFILLER_139_94 VGND VGND VPWR VPWR sky130_fd_sc_hd__decap_3
XFILLER_99_54 VGND VGND VPWR VPWR sky130_fd_sc_hd__fill_2
XFILLER_136_171 VGND VGND VPWR VPWR sky130_fd_sc_hd__decap_3
XFILLER_99_87 VGND VGND VPWR VPWR sky130_fd_sc_hd__decap_3
XFILLER_155_93 VGND VGND VPWR VPWR sky130_fd_sc_hd__decap_3
XFILLER_2_162 VGND VGND VPWR VPWR sky130_fd_sc_hd__decap_3
XFILLER_2_195 VGND VGND VPWR VPWR sky130_fd_sc_hd__fill_1
X_1110_ net229 net296 VGND VGND VPWR VPWR Tile_X0Y1_OpenRAM_bot.Inst_OpenRAM_bot_ConfigMem.Inst_frame4_bit16.Q
+ sky130_fd_sc_hd__dlxtp_1
XFILLER_171_81 VGND VGND VPWR VPWR sky130_fd_sc_hd__decap_3
X_1041_ net235 net315 VGND VGND VPWR VPWR Tile_X0Y1_OpenRAM_bot.Inst_OpenRAM_bot_ConfigMem.Inst_frame2_bit21.Q
+ sky130_fd_sc_hd__dlxtp_1
XFILLER_65_158 VGND VGND VPWR VPWR sky130_fd_sc_hd__fill_2
XFILLER_65_169 VGND VGND VPWR VPWR sky130_fd_sc_hd__decap_3
XTAP_TAPCELL_ROW_76_676 VGND VPWR sky130_fd_sc_hd__tapvpwrvgnd_1
XFILLER_80_139 VGND VGND VPWR VPWR sky130_fd_sc_hd__fill_1
XFILLER_73_191 VGND VGND VPWR VPWR sky130_fd_sc_hd__decap_3
XFILLER_9_30 VGND VGND VPWR VPWR sky130_fd_sc_hd__decap_3
XFILLER_9_63 VGND VGND VPWR VPWR sky130_fd_sc_hd__decap_3
XFILLER_174_200 VGND VGND VPWR VPWR sky130_fd_sc_hd__decap_3
XFILLER_119_127 VGND VGND VPWR VPWR sky130_fd_sc_hd__decap_3
XFILLER_9_96 VGND VGND VPWR VPWR sky130_fd_sc_hd__decap_3
XFILLER_134_119 VGND VGND VPWR VPWR sky130_fd_sc_hd__decap_3
X_0825_ net131 net300 VGND VGND VPWR VPWR Tile_X0Y0_OpenRAM_top.Inst_OpenRAM_top_ConfigMem.Inst_frame4_bit25.Q
+ sky130_fd_sc_hd__dlxtp_1
X_0756_ net137 net318 VGND VGND VPWR VPWR Tile_X0Y0_OpenRAM_top.Inst_OpenRAM_top_ConfigMem.Inst_frame2_bit30.Q
+ sky130_fd_sc_hd__dlxtp_1
XFILLER_127_193 VGND VGND VPWR VPWR sky130_fd_sc_hd__fill_2
XFILLER_142_141 VGND VGND VPWR VPWR sky130_fd_sc_hd__decap_3
X_0687_ _0223_ Tile_X0Y1_OpenRAM_bot.Inst_OpenRAM_bot_ConfigMem.Inst_frame3_bit13.Q
+ VGND VGND VPWR VPWR _0224_ sky130_fd_sc_hd__nand2b_1
XFILLER_142_174 VGND VGND VPWR VPWR sky130_fd_sc_hd__decap_3
XTAP_TAPCELL_ROW_99_768 VGND VPWR sky130_fd_sc_hd__tapvpwrvgnd_1
X_1308_ Tile_X0Y1_FrameStrobe[19] VGND VGND VPWR VPWR net459 sky130_fd_sc_hd__buf_6
X_1239_ net228 net267 VGND VGND VPWR VPWR Tile_X0Y1_OpenRAM_bot.Inst_OpenRAM_bot_ConfigMem.Inst_frame8_bit15.Q
+ sky130_fd_sc_hd__dlxtp_1
XFILLER_44_38 VGND VGND VPWR VPWR sky130_fd_sc_hd__decap_3
XFILLER_100_55 VGND VGND VPWR VPWR sky130_fd_sc_hd__decap_3
XFILLER_165_211 VGND VGND VPWR VPWR sky130_fd_sc_hd__decap_3
XTAP_TAPCELL_ROW_102_780 VGND VPWR sky130_fd_sc_hd__tapvpwrvgnd_1
XFILLER_100_88 VGND VGND VPWR VPWR sky130_fd_sc_hd__fill_1
XFILLER_60_26 VGND VGND VPWR VPWR sky130_fd_sc_hd__fill_2
XFILLER_176_15 VGND VGND VPWR VPWR sky130_fd_sc_hd__decap_3
XFILLER_180_203 VGND VGND VPWR VPWR sky130_fd_sc_hd__decap_3
XFILLER_176_59 VGND VGND VPWR VPWR sky130_fd_sc_hd__decap_3
XFILLER_125_119 VGND VGND VPWR VPWR sky130_fd_sc_hd__decap_3
XFILLER_125_108 VGND VGND VPWR VPWR sky130_fd_sc_hd__decap_3
XFILLER_118_171 VGND VGND VPWR VPWR sky130_fd_sc_hd__decap_3
XFILLER_69_57 VGND VGND VPWR VPWR sky130_fd_sc_hd__decap_3
XFILLER_133_163 VGND VGND VPWR VPWR sky130_fd_sc_hd__decap_3
XFILLER_79_217 VGND VGND VPWR VPWR sky130_fd_sc_hd__decap_3
XFILLER_133_196 VGND VGND VPWR VPWR sky130_fd_sc_hd__fill_1
XFILLER_125_30 VGND VGND VPWR VPWR sky130_fd_sc_hd__decap_3
XFILLER_85_12 VGND VGND VPWR VPWR sky130_fd_sc_hd__decap_3
XFILLER_94_209 VGND VGND VPWR VPWR sky130_fd_sc_hd__decap_3
XFILLER_47_125 VGND VGND VPWR VPWR sky130_fd_sc_hd__decap_3
XTAP_TAPCELL_ROW_117_839 VGND VPWR sky130_fd_sc_hd__tapvpwrvgnd_1
XFILLER_47_147 VGND VGND VPWR VPWR sky130_fd_sc_hd__decap_3
XFILLER_47_169 VGND VGND VPWR VPWR sky130_fd_sc_hd__decap_3
XFILLER_85_78 VGND VGND VPWR VPWR sky130_fd_sc_hd__decap_3
XFILLER_85_89 VGND VGND VPWR VPWR sky130_fd_sc_hd__fill_2
XFILLER_141_40 VGND VGND VPWR VPWR sky130_fd_sc_hd__decap_3
XFILLER_18_83 VGND VGND VPWR VPWR sky130_fd_sc_hd__fill_1
XFILLER_62_128 VGND VGND VPWR VPWR sky130_fd_sc_hd__decap_3
XFILLER_141_84 VGND VGND VPWR VPWR sky130_fd_sc_hd__decap_3
XTAP_TAPCELL_ROW_125_872 VGND VPWR sky130_fd_sc_hd__tapvpwrvgnd_1
XFILLER_156_200 VGND VGND VPWR VPWR sky130_fd_sc_hd__decap_3
XFILLER_86_9 VGND VGND VPWR VPWR sky130_fd_sc_hd__decap_3
XFILLER_116_119 VGND VGND VPWR VPWR sky130_fd_sc_hd__decap_3
XFILLER_171_225 VGND VGND VPWR VPWR sky130_fd_sc_hd__decap_3
XFILLER_171_214 VGND VGND VPWR VPWR sky130_fd_sc_hd__decap_3
X_0610_ net214 net207 net195 _0146_ Tile_X0Y1_OpenRAM_bot.Inst_OpenRAM_bot_ConfigMem.Inst_frame2_bit16.Q
+ Tile_X0Y1_OpenRAM_bot.Inst_OpenRAM_bot_ConfigMem.Inst_frame2_bit17.Q VGND VGND VPWR
+ VPWR net387 sky130_fd_sc_hd__mux4_2
XFILLER_124_141 VGND VGND VPWR VPWR sky130_fd_sc_hd__decap_3
XFILLER_124_130 VGND VGND VPWR VPWR sky130_fd_sc_hd__decap_3
XFILLER_109_193 VGND VGND VPWR VPWR sky130_fd_sc_hd__decap_3
X_0541_ net5 net37 net260 _0084_ Tile_X0Y1_OpenRAM_bot.Inst_OpenRAM_bot_ConfigMem.Inst_frame5_bit6.Q
+ Tile_X0Y1_OpenRAM_bot.Inst_OpenRAM_bot_ConfigMem.Inst_frame5_bit7.Q VGND VGND VPWR
+ VPWR Tile_X0Y1_OpenRAM_bot.Inst_OpenRAM_bot_switch_matrix.W2BEGb3 sky130_fd_sc_hd__mux4_1
X_0472_ net96 Tile_X0Y0_OpenRAM_top.Inst_OpenRAM_top_switch_matrix.J_NS4_BEG0 Tile_X0Y0_OpenRAM_top.Inst_OpenRAM_top_ConfigMem.Inst_frame7_bit4.Q
+ VGND VGND VPWR VPWR _0116_ sky130_fd_sc_hd__mux2_1
XTAP_TAPCELL_ROW_148_964 VGND VPWR sky130_fd_sc_hd__tapvpwrvgnd_1
XFILLER_38_103 VGND VGND VPWR VPWR sky130_fd_sc_hd__fill_2
XFILLER_59_90 VGND VGND VPWR VPWR sky130_fd_sc_hd__decap_3
XFILLER_38_114 VGND VGND VPWR VPWR sky130_fd_sc_hd__decap_3
XFILLER_93_220 VGND VGND VPWR VPWR sky130_fd_sc_hd__decap_3
XFILLER_38_147 VGND VGND VPWR VPWR sky130_fd_sc_hd__decap_3
X_1024_ net250 net325 VGND VGND VPWR VPWR Tile_X0Y1_OpenRAM_bot.Inst_OpenRAM_bot_ConfigMem.Inst_frame1_bit6.Q
+ sky130_fd_sc_hd__dlxtp_1
XTAP_TAPCELL_ROW_131_897 VGND VPWR sky130_fd_sc_hd__tapvpwrvgnd_1
XFILLER_147_211 VGND VGND VPWR VPWR sky130_fd_sc_hd__fill_1
XFILLER_30_29 VGND VGND VPWR VPWR sky130_fd_sc_hd__decap_3
X_0808_ net115 net310 VGND VGND VPWR VPWR Tile_X0Y0_OpenRAM_top.Inst_OpenRAM_top_ConfigMem.Inst_frame3_bit10.Q
+ sky130_fd_sc_hd__dlxtp_1
X_0739_ net120 net328 VGND VGND VPWR VPWR Tile_X0Y0_OpenRAM_top.Inst_OpenRAM_top_ConfigMem.Inst_frame1_bit15.Q
+ sky130_fd_sc_hd__dlxtp_1
XFILLER_130_100 VGND VGND VPWR VPWR sky130_fd_sc_hd__decap_3
XFILLER_115_152 VGND VGND VPWR VPWR sky130_fd_sc_hd__decap_3
XFILLER_130_144 VGND VGND VPWR VPWR sky130_fd_sc_hd__decap_3
XFILLER_130_122 VGND VGND VPWR VPWR sky130_fd_sc_hd__decap_3
XFILLER_115_196 VGND VGND VPWR VPWR sky130_fd_sc_hd__decap_3
XFILLER_76_209 VGND VGND VPWR VPWR sky130_fd_sc_hd__decap_3
XFILLER_29_169 VGND VGND VPWR VPWR sky130_fd_sc_hd__fill_2
XTAP_TAPCELL_ROW_154_989 VGND VPWR sky130_fd_sc_hd__tapvpwrvgnd_1
XFILLER_44_106 VGND VGND VPWR VPWR sky130_fd_sc_hd__decap_3
XFILLER_111_21 VGND VGND VPWR VPWR sky130_fd_sc_hd__decap_3
XFILLER_44_139 VGND VGND VPWR VPWR sky130_fd_sc_hd__fill_1
XFILLER_111_54 VGND VGND VPWR VPWR sky130_fd_sc_hd__fill_2
XFILLER_111_87 VGND VGND VPWR VPWR sky130_fd_sc_hd__decap_3
XFILLER_52_194 VGND VGND VPWR VPWR sky130_fd_sc_hd__fill_2
XFILLER_71_36 VGND VGND VPWR VPWR sky130_fd_sc_hd__decap_3
XFILLER_138_211 VGND VGND VPWR VPWR sky130_fd_sc_hd__fill_2
XFILLER_138_200 VGND VGND VPWR VPWR sky130_fd_sc_hd__decap_3
XPHY_EDGE_ROW_109_Right_109 VGND VGND VPWR VPWR sky130_fd_sc_hd__decap_3
XFILLER_153_225 VGND VGND VPWR VPWR sky130_fd_sc_hd__decap_3
XFILLER_4_224 VGND VGND VPWR VPWR sky130_fd_sc_hd__decap_3
XFILLER_106_141 VGND VGND VPWR VPWR sky130_fd_sc_hd__decap_3
XFILLER_136_62 VGND VGND VPWR VPWR sky130_fd_sc_hd__decap_3
XFILLER_106_174 VGND VGND VPWR VPWR sky130_fd_sc_hd__fill_1
XFILLER_121_111 VGND VGND VPWR VPWR sky130_fd_sc_hd__fill_1
XFILLER_121_155 VGND VGND VPWR VPWR sky130_fd_sc_hd__decap_3
XFILLER_29_60 VGND VGND VPWR VPWR sky130_fd_sc_hd__decap_3
XFILLER_152_94 VGND VGND VPWR VPWR sky130_fd_sc_hd__decap_3
XFILLER_152_83 VGND VGND VPWR VPWR sky130_fd_sc_hd__fill_1
XFILLER_43_161 VGND VGND VPWR VPWR sky130_fd_sc_hd__decap_3
XFILLER_45_81 VGND VGND VPWR VPWR sky130_fd_sc_hd__decap_3
XFILLER_50_109 VGND VGND VPWR VPWR sky130_fd_sc_hd__decap_3
XTAP_TAPCELL_ROW_61_616 VGND VPWR sky130_fd_sc_hd__tapvpwrvgnd_1
XFILLER_43_183 VGND VGND VPWR VPWR sky130_fd_sc_hd__decap_3
XFILLER_84_6 VGND VGND VPWR VPWR sky130_fd_sc_hd__decap_3
XFILLER_129_222 VGND VGND VPWR VPWR sky130_fd_sc_hd__fill_2
XFILLER_144_203 VGND VGND VPWR VPWR sky130_fd_sc_hd__decap_3
XFILLER_6_53 VGND VGND VPWR VPWR sky130_fd_sc_hd__decap_3
XFILLER_112_100 VGND VGND VPWR VPWR sky130_fd_sc_hd__decap_3
XFILLER_6_97 VGND VGND VPWR VPWR sky130_fd_sc_hd__decap_3
XFILLER_112_122 VGND VGND VPWR VPWR sky130_fd_sc_hd__decap_3
X_0524_ net176 net187 net179 _0086_ Tile_X0Y1_OpenRAM_bot.Inst_OpenRAM_bot_ConfigMem.Inst_frame7_bit24.Q
+ Tile_X0Y1_OpenRAM_bot.Inst_OpenRAM_bot_ConfigMem.Inst_frame7_bit25.Q VGND VGND VPWR
+ VPWR Tile_X0Y1_OpenRAM_bot.Inst_OpenRAM_bot_switch_matrix.S2BEG6 sky130_fd_sc_hd__mux4_1
X_0455_ net73 Tile_X0Y0_OpenRAM_top.Inst_OpenRAM_top_ConfigMem.Inst_frame2_bit30.Q
+ VGND VGND VPWR VPWR _0104_ sky130_fd_sc_hd__nand2_1
XFILLER_112_177 VGND VGND VPWR VPWR sky130_fd_sc_hd__decap_3
XFILLER_112_144 VGND VGND VPWR VPWR sky130_fd_sc_hd__decap_3
XFILLER_58_209 VGND VGND VPWR VPWR sky130_fd_sc_hd__decap_3
X_0386_ net10 net42 Tile_X0Y0_OpenRAM_top.Inst_OpenRAM_top_switch_matrix.J_NS4_BEG15
+ Tile_X0Y0_OpenRAM_top.Inst_OpenRAM_top_switch_matrix.J_NS2_BEG7 Tile_X0Y0_OpenRAM_top.Inst_OpenRAM_top_ConfigMem.Inst_frame5_bit28.Q
+ Tile_X0Y0_OpenRAM_top.Inst_OpenRAM_top_ConfigMem.Inst_frame5_bit29.Q VGND VGND VPWR
+ VPWR Tile_X0Y0_OpenRAM_top.Inst_OpenRAM_top_switch_matrix.WW4BEG0 sky130_fd_sc_hd__mux4_1
XTAP_TAPCELL_ROW_84_708 VGND VPWR sky130_fd_sc_hd__tapvpwrvgnd_1
XFILLER_26_139 VGND VGND VPWR VPWR sky130_fd_sc_hd__fill_1
XTAP_TAPCELL_ROW_92_741 VGND VPWR sky130_fd_sc_hd__tapvpwrvgnd_1
XFILLER_179_122 VGND VGND VPWR VPWR sky130_fd_sc_hd__decap_3
XFILLER_179_111 VGND VGND VPWR VPWR sky130_fd_sc_hd__fill_1
X_1007_ net237 net323 VGND VGND VPWR VPWR Tile_X0Y1_OpenRAM_bot.Inst_OpenRAM_bot_ConfigMem.Inst_frame1_bit23.Q
+ sky130_fd_sc_hd__dlxtp_1
XFILLER_179_144 VGND VGND VPWR VPWR sky130_fd_sc_hd__decap_3
XFILLER_179_188 VGND VGND VPWR VPWR sky130_fd_sc_hd__decap_3
XFILLER_135_225 VGND VGND VPWR VPWR sky130_fd_sc_hd__decap_3
XFILLER_135_203 VGND VGND VPWR VPWR sky130_fd_sc_hd__decap_3
XFILLER_150_206 VGND VGND VPWR VPWR sky130_fd_sc_hd__decap_3
XFILLER_1_205 VGND VGND VPWR VPWR sky130_fd_sc_hd__decap_3
XFILLER_173_27 VGND VGND VPWR VPWR sky130_fd_sc_hd__decap_3
XFILLER_106_32 VGND VGND VPWR VPWR sky130_fd_sc_hd__decap_3
XFILLER_103_155 VGND VGND VPWR VPWR sky130_fd_sc_hd__decap_3
XFILLER_106_65 VGND VGND VPWR VPWR sky130_fd_sc_hd__decap_3
XFILLER_103_199 VGND VGND VPWR VPWR sky130_fd_sc_hd__decap_3
XFILLER_66_47 VGND VGND VPWR VPWR sky130_fd_sc_hd__decap_3
XFILLER_122_97 VGND VGND VPWR VPWR sky130_fd_sc_hd__decap_3
XFILLER_32_109 VGND VGND VPWR VPWR sky130_fd_sc_hd__decap_3
XFILLER_82_24 VGND VGND VPWR VPWR sky130_fd_sc_hd__decap_3
XFILLER_82_35 VGND VGND VPWR VPWR sky130_fd_sc_hd__decap_3
XTAP_TAPCELL_ROW_150_970 VGND VPWR sky130_fd_sc_hd__tapvpwrvgnd_1
XFILLER_25_161 VGND VGND VPWR VPWR sky130_fd_sc_hd__decap_3
XFILLER_25_172 VGND VGND VPWR VPWR sky130_fd_sc_hd__decap_3
XFILLER_82_79 VGND VGND VPWR VPWR sky130_fd_sc_hd__decap_3
XTAP_TAPCELL_ROW_110_812 VGND VPWR sky130_fd_sc_hd__tapvpwrvgnd_1
XFILLER_40_197 VGND VGND VPWR VPWR sky130_fd_sc_hd__decap_3
XFILLER_31_50 VGND VGND VPWR VPWR sky130_fd_sc_hd__decap_3
XFILLER_31_72 VGND VGND VPWR VPWR sky130_fd_sc_hd__decap_3
XFILLER_141_228 VGND VGND VPWR VPWR sky130_fd_sc_hd__fill_2
X_0240_ Tile_X0Y0_OpenRAM_top.Inst_OpenRAM_top_ConfigMem.Inst_frame7_bit6.Q VGND VGND
+ VPWR VPWR _0013_ sky130_fd_sc_hd__inv_1
XFILLER_163_60 VGND VGND VPWR VPWR sky130_fd_sc_hd__decap_3
Xinput172 Tile_X0Y0_S4END[6] VGND VGND VPWR VPWR net172 sky130_fd_sc_hd__clkbuf_4
Xinput150 Tile_X0Y0_S2END[0] VGND VGND VPWR VPWR net150 sky130_fd_sc_hd__clkbuf_2
Xinput161 Tile_X0Y0_S2MID[3] VGND VGND VPWR VPWR net161 sky130_fd_sc_hd__buf_2
XTAP_TAPCELL_ROW_133_904 VGND VPWR sky130_fd_sc_hd__tapvpwrvgnd_1
Xinput183 Tile_X0Y1_E2END[5] VGND VGND VPWR VPWR net183 sky130_fd_sc_hd__clkbuf_2
Xinput194 Tile_X0Y1_E6END[0] VGND VGND VPWR VPWR net194 sky130_fd_sc_hd__buf_1
XFILLER_56_91 VGND VGND VPWR VPWR sky130_fd_sc_hd__decap_3
XFILLER_63_223 VGND VGND VPWR VPWR sky130_fd_sc_hd__fill_1
XFILLER_16_150 VGND VGND VPWR VPWR sky130_fd_sc_hd__decap_3
XFILLER_176_103 VGND VGND VPWR VPWR sky130_fd_sc_hd__decap_3
XFILLER_31_131 VGND VGND VPWR VPWR sky130_fd_sc_hd__decap_3
XFILLER_176_147 VGND VGND VPWR VPWR sky130_fd_sc_hd__decap_3
XFILLER_176_136 VGND VGND VPWR VPWR sky130_fd_sc_hd__decap_3
XFILLER_31_175 VGND VGND VPWR VPWR sky130_fd_sc_hd__decap_3
XFILLER_82_3 VGND VGND VPWR VPWR sky130_fd_sc_hd__decap_3
XFILLER_117_225 VGND VGND VPWR VPWR sky130_fd_sc_hd__decap_3
XFILLER_98_131 VGND VGND VPWR VPWR sky130_fd_sc_hd__decap_3
Xfanout328 net329 VGND VGND VPWR VPWR net328 sky130_fd_sc_hd__buf_2
X_0507_ net69 net95 Tile_X0Y0_OpenRAM_top.Inst_OpenRAM_top_switch_matrix.J_NS4_BEG7
+ Tile_X0Y0_OpenRAM_top.Inst_OpenRAM_top_switch_matrix.J_NS4_BEG15 Tile_X0Y0_OpenRAM_top.Inst_OpenRAM_top_ConfigMem.Inst_frame6_bit18.Q
+ Tile_X0Y0_OpenRAM_top.Inst_OpenRAM_top_ConfigMem.Inst_frame6_bit19.Q VGND VGND VPWR
+ VPWR _0144_ sky130_fd_sc_hd__mux4_1
Xfanout317 net321 VGND VGND VPWR VPWR net317 sky130_fd_sc_hd__buf_2
XFILLER_98_153 VGND VGND VPWR VPWR sky130_fd_sc_hd__decap_3
Xfanout306 net307 VGND VGND VPWR VPWR net306 sky130_fd_sc_hd__clkbuf_2
XTAP_TAPCELL_ROW_168_1045 VGND VPWR sky130_fd_sc_hd__tapvpwrvgnd_1
XFILLER_98_186 VGND VGND VPWR VPWR sky130_fd_sc_hd__decap_3
X_1487_ Tile_X0Y1_OpenRAM_bot.Inst_OpenRAM_bot_switch_matrix.W6BEG5 VGND VGND VPWR
+ VPWR net649 sky130_fd_sc_hd__buf_1
X_0438_ net107 net100 net88 Tile_X0Y0_OpenRAM_top.Inst_OpenRAM_top_switch_matrix.J_NS4_BEG11
+ Tile_X0Y0_OpenRAM_top.Inst_OpenRAM_top_ConfigMem.Inst_frame2_bit10.Q Tile_X0Y0_OpenRAM_top.Inst_OpenRAM_top_ConfigMem.Inst_frame2_bit11.Q
+ VGND VGND VPWR VPWR net405 sky130_fd_sc_hd__mux4_2
XFILLER_100_147 VGND VGND VPWR VPWR sky130_fd_sc_hd__decap_3
XFILLER_100_136 VGND VGND VPWR VPWR sky130_fd_sc_hd__decap_3
XFILLER_39_220 VGND VGND VPWR VPWR sky130_fd_sc_hd__decap_3
X_0369_ Tile_X0Y0_OpenRAM_top.Inst_OpenRAM_top_switch_matrix.N1END3 net13 net149 net45
+ Tile_X0Y0_OpenRAM_top.Inst_OpenRAM_top_ConfigMem.Inst_frame6_bit27.Q Tile_X0Y0_OpenRAM_top.Inst_OpenRAM_top_ConfigMem.Inst_frame6_bit26.Q
+ VGND VGND VPWR VPWR Tile_X0Y0_OpenRAM_top.Inst_OpenRAM_top_switch_matrix.W1BEG3
+ sky130_fd_sc_hd__mux4_1
XFILLER_100_169 VGND VGND VPWR VPWR sky130_fd_sc_hd__decap_3
XFILLER_54_212 VGND VGND VPWR VPWR sky130_fd_sc_hd__decap_3
XPHY_EDGE_ROW_59_Left_242 VGND VGND VPWR VPWR sky130_fd_sc_hd__decap_3
XFILLER_167_103 VGND VGND VPWR VPWR sky130_fd_sc_hd__decap_3
XFILLER_168_38 VGND VGND VPWR VPWR sky130_fd_sc_hd__decap_3
XFILLER_168_27 VGND VGND VPWR VPWR sky130_fd_sc_hd__fill_1
XFILLER_167_125 VGND VGND VPWR VPWR sky130_fd_sc_hd__decap_3
XFILLER_139_7 VGND VGND VPWR VPWR sky130_fd_sc_hd__fill_2
XFILLER_22_153 VGND VGND VPWR VPWR sky130_fd_sc_hd__decap_3
XFILLER_167_169 VGND VGND VPWR VPWR sky130_fd_sc_hd__decap_3
XFILLER_22_197 VGND VGND VPWR VPWR sky130_fd_sc_hd__fill_2
XFILLER_182_139 VGND VGND VPWR VPWR sky130_fd_sc_hd__fill_1
XFILLER_108_203 VGND VGND VPWR VPWR sky130_fd_sc_hd__decap_3
XFILLER_123_217 VGND VGND VPWR VPWR sky130_fd_sc_hd__decap_3
XFILLER_117_20 VGND VGND VPWR VPWR sky130_fd_sc_hd__decap_3
XPHY_EDGE_ROW_68_Left_251 VGND VGND VPWR VPWR sky130_fd_sc_hd__decap_3
XFILLER_123_228 VGND VGND VPWR VPWR sky130_fd_sc_hd__fill_2
XFILLER_117_53 VGND VGND VPWR VPWR sky130_fd_sc_hd__decap_3
XFILLER_117_75 VGND VGND VPWR VPWR sky130_fd_sc_hd__decap_3
XFILLER_77_24 VGND VGND VPWR VPWR sky130_fd_sc_hd__decap_3
XFILLER_89_164 VGND VGND VPWR VPWR sky130_fd_sc_hd__decap_3
XFILLER_77_57 VGND VGND VPWR VPWR sky130_fd_sc_hd__decap_3
XFILLER_89_175 VGND VGND VPWR VPWR sky130_fd_sc_hd__decap_3
XFILLER_89_197 VGND VGND VPWR VPWR sky130_fd_sc_hd__decap_3
XFILLER_133_52 VGND VGND VPWR VPWR sky130_fd_sc_hd__decap_3
XFILLER_93_12 VGND VGND VPWR VPWR sky130_fd_sc_hd__decap_3
XFILLER_93_45 VGND VGND VPWR VPWR sky130_fd_sc_hd__decap_3
XPHY_EDGE_ROW_77_Left_260 VGND VGND VPWR VPWR sky130_fd_sc_hd__decap_3
XFILLER_93_89 VGND VGND VPWR VPWR sky130_fd_sc_hd__decap_3
XPHY_EDGE_ROW_161_Right_161 VGND VGND VPWR VPWR sky130_fd_sc_hd__decap_3
XFILLER_26_94 VGND VGND VPWR VPWR sky130_fd_sc_hd__decap_3
XFILLER_158_125 VGND VGND VPWR VPWR sky130_fd_sc_hd__decap_3
XFILLER_13_175 VGND VGND VPWR VPWR sky130_fd_sc_hd__decap_3
XFILLER_13_164 VGND VGND VPWR VPWR sky130_fd_sc_hd__decap_3
XFILLER_9_113 VGND VGND VPWR VPWR sky130_fd_sc_hd__decap_3
XFILLER_9_102 VGND VGND VPWR VPWR sky130_fd_sc_hd__decap_3
XFILLER_158_147 VGND VGND VPWR VPWR sky130_fd_sc_hd__decap_3
XFILLER_9_146 VGND VGND VPWR VPWR sky130_fd_sc_hd__decap_3
XFILLER_42_71 VGND VGND VPWR VPWR sky130_fd_sc_hd__decap_3
XFILLER_173_128 VGND VGND VPWR VPWR sky130_fd_sc_hd__decap_3
XFILLER_158_71 VGND VGND VPWR VPWR sky130_fd_sc_hd__decap_3
XFILLER_166_180 VGND VGND VPWR VPWR sky130_fd_sc_hd__decap_3
XFILLER_181_172 VGND VGND VPWR VPWR sky130_fd_sc_hd__decap_3
X_1410_ net229 VGND VGND VPWR VPWR net561 sky130_fd_sc_hd__buf_6
XFILLER_3_21 VGND VGND VPWR VPWR sky130_fd_sc_hd__decap_3
X_1341_ Tile_X0Y0_OpenRAM_top.Inst_OpenRAM_top_switch_matrix.N4BEG0 VGND VGND VPWR
+ VPWR net492 sky130_fd_sc_hd__buf_1
XFILLER_3_54 VGND VGND VPWR VPWR sky130_fd_sc_hd__fill_2
X_1272_ net120 VGND VGND VPWR VPWR net423 sky130_fd_sc_hd__clkbuf_2
XFILLER_3_87 VGND VGND VPWR VPWR sky130_fd_sc_hd__decap_3
XFILLER_95_156 VGND VGND VPWR VPWR sky130_fd_sc_hd__decap_3
XFILLER_95_167 VGND VGND VPWR VPWR sky130_fd_sc_hd__fill_1
XFILLER_149_125 VGND VGND VPWR VPWR sky130_fd_sc_hd__decap_3
XFILLER_149_158 VGND VGND VPWR VPWR sky130_fd_sc_hd__decap_3
XFILLER_164_139 VGND VGND VPWR VPWR sky130_fd_sc_hd__fill_1
XFILLER_164_106 VGND VGND VPWR VPWR sky130_fd_sc_hd__decap_3
XFILLER_138_19 VGND VGND VPWR VPWR sky130_fd_sc_hd__decap_3
X_0987_ net224 net332 VGND VGND VPWR VPWR Tile_X0Y1_OpenRAM_bot.Inst_OpenRAM_bot_ConfigMem.Inst_frame0_bit11.Q
+ sky130_fd_sc_hd__dlxtp_1
Xoutput410 net493 VGND VGND VPWR VPWR Tile_X0Y0_N4BEG[13] sky130_fd_sc_hd__buf_2
XFILLER_172_150 VGND VGND VPWR VPWR sky130_fd_sc_hd__decap_3
Xoutput421 net504 VGND VGND VPWR VPWR Tile_X0Y0_N4BEG[9] sky130_fd_sc_hd__buf_2
XFILLER_172_183 VGND VGND VPWR VPWR sky130_fd_sc_hd__decap_3
Xoutput443 net526 VGND VGND VPWR VPWR Tile_X0Y0_W6BEG[0] sky130_fd_sc_hd__buf_2
Xoutput432 net515 VGND VGND VPWR VPWR Tile_X0Y0_W2BEG[5] sky130_fd_sc_hd__buf_2
XFILLER_105_228 VGND VGND VPWR VPWR sky130_fd_sc_hd__fill_2
Xoutput487 net570 VGND VGND VPWR VPWR Tile_X0Y1_FrameData_O[24] sky130_fd_sc_hd__buf_2
Xoutput476 net559 VGND VGND VPWR VPWR Tile_X0Y1_FrameData_O[14] sky130_fd_sc_hd__buf_2
XFILLER_154_29 VGND VGND VPWR VPWR sky130_fd_sc_hd__decap_3
Xoutput454 net537 VGND VGND VPWR VPWR Tile_X0Y0_W6BEG[9] sky130_fd_sc_hd__buf_2
Xoutput465 net548 VGND VGND VPWR VPWR Tile_X0Y0_WW4BEG[4] sky130_fd_sc_hd__buf_2
XFILLER_120_209 VGND VGND VPWR VPWR sky130_fd_sc_hd__fill_1
Xoutput498 net581 VGND VGND VPWR VPWR Tile_X0Y1_FrameData_O[5] sky130_fd_sc_hd__buf_2
XFILLER_86_112 VGND VGND VPWR VPWR sky130_fd_sc_hd__decap_3
XFILLER_47_49 VGND VGND VPWR VPWR sky130_fd_sc_hd__decap_3
XFILLER_86_189 VGND VGND VPWR VPWR sky130_fd_sc_hd__fill_1
XFILLER_103_33 VGND VGND VPWR VPWR sky130_fd_sc_hd__decap_3
XFILLER_27_212 VGND VGND VPWR VPWR sky130_fd_sc_hd__decap_3
XFILLER_103_66 VGND VGND VPWR VPWR sky130_fd_sc_hd__fill_1
XFILLER_103_55 VGND VGND VPWR VPWR sky130_fd_sc_hd__fill_1
XTAP_TAPCELL_ROW_181_1097 VGND VPWR sky130_fd_sc_hd__tapvpwrvgnd_1
XFILLER_179_15 VGND VGND VPWR VPWR sky130_fd_sc_hd__decap_3
XFILLER_179_48 VGND VGND VPWR VPWR sky130_fd_sc_hd__decap_3
XFILLER_10_112 VGND VGND VPWR VPWR sky130_fd_sc_hd__decap_3
XFILLER_155_128 VGND VGND VPWR VPWR sky130_fd_sc_hd__decap_3
XFILLER_10_156 VGND VGND VPWR VPWR sky130_fd_sc_hd__decap_3
XFILLER_148_180 VGND VGND VPWR VPWR sky130_fd_sc_hd__decap_3
XFILLER_6_127 VGND VGND VPWR VPWR sky130_fd_sc_hd__decap_3
XFILLER_170_109 VGND VGND VPWR VPWR sky130_fd_sc_hd__decap_3
XFILLER_128_52 VGND VGND VPWR VPWR sky130_fd_sc_hd__decap_3
XFILLER_12_85 VGND VGND VPWR VPWR sky130_fd_sc_hd__decap_3
XFILLER_12_74 VGND VGND VPWR VPWR sky130_fd_sc_hd__decap_3
XFILLER_88_12 VGND VGND VPWR VPWR sky130_fd_sc_hd__decap_3
XFILLER_128_85 VGND VGND VPWR VPWR sky130_fd_sc_hd__decap_3
XFILLER_88_56 VGND VGND VPWR VPWR sky130_fd_sc_hd__decap_3
XFILLER_144_51 VGND VGND VPWR VPWR sky130_fd_sc_hd__decap_3
XFILLER_77_134 VGND VGND VPWR VPWR sky130_fd_sc_hd__decap_3
XFILLER_77_156 VGND VGND VPWR VPWR sky130_fd_sc_hd__decap_3
XFILLER_18_212 VGND VGND VPWR VPWR sky130_fd_sc_hd__decap_3
XFILLER_37_60 VGND VGND VPWR VPWR sky130_fd_sc_hd__decap_3
XFILLER_160_50 VGND VGND VPWR VPWR sky130_fd_sc_hd__decap_3
XPHY_EDGE_ROW_16_Right_16 VGND VGND VPWR VPWR sky130_fd_sc_hd__decap_3
XFILLER_37_93 VGND VGND VPWR VPWR sky130_fd_sc_hd__decap_3
XFILLER_160_83 VGND VGND VPWR VPWR sky130_fd_sc_hd__fill_1
XFILLER_178_209 VGND VGND VPWR VPWR sky130_fd_sc_hd__decap_3
XTAP_TAPCELL_ROW_16_435 VGND VPWR sky130_fd_sc_hd__tapvpwrvgnd_1
X_0910_ net140 net282 VGND VGND VPWR VPWR Tile_X0Y0_OpenRAM_top.Inst_OpenRAM_top_ConfigMem.Inst_frame6_bit4.Q
+ sky130_fd_sc_hd__dlxtp_1
XFILLER_169_81 VGND VGND VPWR VPWR sky130_fd_sc_hd__decap_3
X_0841_ net145 net302 VGND VGND VPWR VPWR Tile_X0Y0_OpenRAM_top.Inst_OpenRAM_top_ConfigMem.Inst_frame4_bit9.Q
+ sky130_fd_sc_hd__dlxtp_1
X_0772_ net119 net318 VGND VGND VPWR VPWR Tile_X0Y0_OpenRAM_top.Inst_OpenRAM_top_ConfigMem.Inst_frame2_bit14.Q
+ sky130_fd_sc_hd__dlxtp_1
XPHY_EDGE_ROW_25_Right_25 VGND VGND VPWR VPWR sky130_fd_sc_hd__decap_3
XFILLER_154_150 VGND VGND VPWR VPWR sky130_fd_sc_hd__decap_3
XFILLER_154_183 VGND VGND VPWR VPWR sky130_fd_sc_hd__decap_3
XFILLER_102_209 VGND VGND VPWR VPWR sky130_fd_sc_hd__decap_3
XFILLER_5_193 VGND VGND VPWR VPWR sky130_fd_sc_hd__decap_3
XFILLER_68_123 VGND VGND VPWR VPWR sky130_fd_sc_hd__decap_3
X_1324_ Tile_X0Y0_OpenRAM_top.Inst_OpenRAM_top_switch_matrix.N2BEGb3 VGND VGND VPWR
+ VPWR net484 sky130_fd_sc_hd__buf_4
XFILLER_68_156 VGND VGND VPWR VPWR sky130_fd_sc_hd__decap_3
XFILLER_68_189 VGND VGND VPWR VPWR sky130_fd_sc_hd__decap_3
XPHY_EDGE_ROW_34_Right_34 VGND VGND VPWR VPWR sky130_fd_sc_hd__decap_3
XTAP_TAPCELL_ROW_39_527 VGND VPWR sky130_fd_sc_hd__tapvpwrvgnd_1
X_1255_ clknet_1_0__leaf_Tile_X0Y1_UserCLK VGND VGND VPWR VPWR net381 sky130_fd_sc_hd__buf_2
XFILLER_83_137 VGND VGND VPWR VPWR sky130_fd_sc_hd__decap_3
X_1186_ net248 net281 VGND VGND VPWR VPWR Tile_X0Y1_OpenRAM_bot.Inst_OpenRAM_bot_ConfigMem.Inst_frame6_bit4.Q
+ sky130_fd_sc_hd__dlxtp_1
XTAP_TAPCELL_ROW_47_560 VGND VPWR sky130_fd_sc_hd__tapvpwrvgnd_1
XFILLER_91_181 VGND VGND VPWR VPWR sky130_fd_sc_hd__decap_3
XFILLER_177_220 VGND VGND VPWR VPWR sky130_fd_sc_hd__decap_3
XFILLER_137_117 VGND VGND VPWR VPWR sky130_fd_sc_hd__decap_3
XPHY_EDGE_ROW_43_Right_43 VGND VGND VPWR VPWR sky130_fd_sc_hd__decap_3
XFILLER_3_108 VGND VGND VPWR VPWR sky130_fd_sc_hd__decap_3
XTAP_TAPCELL_ROW_30_493 VGND VPWR sky130_fd_sc_hd__tapvpwrvgnd_1
XFILLER_165_39 VGND VGND VPWR VPWR sky130_fd_sc_hd__decap_3
XFILLER_145_172 VGND VGND VPWR VPWR sky130_fd_sc_hd__fill_2
XFILLER_3_119 VGND VGND VPWR VPWR sky130_fd_sc_hd__decap_3
XFILLER_160_153 VGND VGND VPWR VPWR sky130_fd_sc_hd__decap_3
XFILLER_160_186 VGND VGND VPWR VPWR sky130_fd_sc_hd__decap_3
Xoutput295 net378 VGND VGND VPWR VPWR ADDR_B_SRAM5 sky130_fd_sc_hd__buf_2
Xoutput284 net367 VGND VGND VPWR VPWR ADDR_A_SRAM2 sky130_fd_sc_hd__buf_2
XFILLER_58_59 VGND VGND VPWR VPWR sky130_fd_sc_hd__fill_1
XFILLER_114_32 VGND VGND VPWR VPWR sky130_fd_sc_hd__decap_3
XPHY_EDGE_ROW_52_Right_52 VGND VGND VPWR VPWR sky130_fd_sc_hd__decap_3
XFILLER_59_167 VGND VGND VPWR VPWR sky130_fd_sc_hd__fill_1
XFILLER_74_137 VGND VGND VPWR VPWR sky130_fd_sc_hd__decap_3
XFILLER_15_204 VGND VGND VPWR VPWR sky130_fd_sc_hd__decap_3
XFILLER_82_170 VGND VGND VPWR VPWR sky130_fd_sc_hd__decap_3
XFILLER_130_97 VGND VGND VPWR VPWR sky130_fd_sc_hd__decap_3
XFILLER_30_218 VGND VGND VPWR VPWR sky130_fd_sc_hd__decap_3
XFILLER_90_35 VGND VGND VPWR VPWR sky130_fd_sc_hd__decap_3
XTAP_TAPCELL_ROW_53_585 VGND VPWR sky130_fd_sc_hd__tapvpwrvgnd_1
XPHY_EDGE_ROW_61_Right_61 VGND VGND VPWR VPWR sky130_fd_sc_hd__decap_3
XFILLER_90_68 VGND VGND VPWR VPWR sky130_fd_sc_hd__decap_3
XFILLER_23_51 VGND VGND VPWR VPWR sky130_fd_sc_hd__fill_1
XFILLER_139_51 VGND VGND VPWR VPWR sky130_fd_sc_hd__decap_3
XFILLER_128_139 VGND VGND VPWR VPWR sky130_fd_sc_hd__fill_1
XFILLER_23_95 VGND VGND VPWR VPWR sky130_fd_sc_hd__decap_3
XFILLER_136_150 VGND VGND VPWR VPWR sky130_fd_sc_hd__decap_3
XFILLER_99_33 VGND VGND VPWR VPWR sky130_fd_sc_hd__decap_3
XFILLER_99_66 VGND VGND VPWR VPWR sky130_fd_sc_hd__decap_3
XFILLER_99_99 VGND VGND VPWR VPWR sky130_fd_sc_hd__decap_3
XFILLER_2_130 VGND VGND VPWR VPWR sky130_fd_sc_hd__decap_3
XPHY_EDGE_ROW_70_Right_70 VGND VGND VPWR VPWR sky130_fd_sc_hd__decap_3
XFILLER_171_60 VGND VGND VPWR VPWR sky130_fd_sc_hd__decap_3
XFILLER_17_7 VGND VGND VPWR VPWR sky130_fd_sc_hd__fill_1
XFILLER_65_137 VGND VGND VPWR VPWR sky130_fd_sc_hd__decap_3
XFILLER_171_93 VGND VGND VPWR VPWR sky130_fd_sc_hd__decap_3
X_1040_ net236 net313 VGND VGND VPWR VPWR Tile_X0Y1_OpenRAM_bot.Inst_OpenRAM_bot_ConfigMem.Inst_frame2_bit22.Q
+ sky130_fd_sc_hd__dlxtp_1
XTAP_TAPCELL_ROW_76_677 VGND VPWR sky130_fd_sc_hd__tapvpwrvgnd_1
XFILLER_64_91 VGND VGND VPWR VPWR sky130_fd_sc_hd__decap_3
XPHY_EDGE_ROW_14_Left_197 VGND VGND VPWR VPWR sky130_fd_sc_hd__decap_3
XFILLER_9_42 VGND VGND VPWR VPWR sky130_fd_sc_hd__decap_3
XFILLER_174_212 VGND VGND VPWR VPWR sky130_fd_sc_hd__decap_3
XFILLER_9_75 VGND VGND VPWR VPWR sky130_fd_sc_hd__decap_3
XFILLER_119_139 VGND VGND VPWR VPWR sky130_fd_sc_hd__fill_2
X_0824_ net132 net300 VGND VGND VPWR VPWR Tile_X0Y0_OpenRAM_top.Inst_OpenRAM_top_ConfigMem.Inst_frame4_bit26.Q
+ sky130_fd_sc_hd__dlxtp_1
X_0755_ net138 net318 VGND VGND VPWR VPWR Tile_X0Y0_OpenRAM_top.Inst_OpenRAM_top_ConfigMem.Inst_frame2_bit31.Q
+ sky130_fd_sc_hd__dlxtp_1
XFILLER_127_172 VGND VGND VPWR VPWR sky130_fd_sc_hd__decap_3
XFILLER_127_161 VGND VGND VPWR VPWR sky130_fd_sc_hd__decap_3
XFILLER_142_120 VGND VGND VPWR VPWR sky130_fd_sc_hd__decap_3
X_0686_ net344 net186 net179 net180 Tile_X0Y1_OpenRAM_bot.Inst_OpenRAM_bot_ConfigMem.Inst_frame3_bit12.Q
+ Tile_X0Y1_OpenRAM_bot.Inst_OpenRAM_bot_ConfigMem.Inst_frame3_bit14.Q VGND VGND VPWR
+ VPWR _0223_ sky130_fd_sc_hd__mux4_1
XFILLER_142_164 VGND VGND VPWR VPWR sky130_fd_sc_hd__decap_3
XFILLER_88_218 VGND VGND VPWR VPWR sky130_fd_sc_hd__decap_3
XFILLER_142_197 VGND VGND VPWR VPWR sky130_fd_sc_hd__decap_3
XTAP_TAPCELL_ROW_99_769 VGND VPWR sky130_fd_sc_hd__tapvpwrvgnd_1
XFILLER_28_29 VGND VGND VPWR VPWR sky130_fd_sc_hd__decap_3
XFILLER_151_19 VGND VGND VPWR VPWR sky130_fd_sc_hd__fill_2
X_1307_ Tile_X0Y1_FrameStrobe[18] VGND VGND VPWR VPWR net458 sky130_fd_sc_hd__buf_6
X_1238_ net229 net264 VGND VGND VPWR VPWR Tile_X0Y1_OpenRAM_bot.Inst_OpenRAM_bot_ConfigMem.Inst_frame8_bit16.Q
+ sky130_fd_sc_hd__dlxtp_1
XFILLER_71_107 VGND VGND VPWR VPWR sky130_fd_sc_hd__decap_3
X_1169_ net235 net280 VGND VGND VPWR VPWR Tile_X0Y1_OpenRAM_bot.Inst_OpenRAM_bot_ConfigMem.Inst_frame6_bit21.Q
+ sky130_fd_sc_hd__dlxtp_1
XFILLER_64_181 VGND VGND VPWR VPWR sky130_fd_sc_hd__decap_3
XFILLER_100_12 VGND VGND VPWR VPWR sky130_fd_sc_hd__decap_3
XTAP_TAPCELL_ROW_102_781 VGND VPWR sky130_fd_sc_hd__tapvpwrvgnd_1
XFILLER_100_67 VGND VGND VPWR VPWR sky130_fd_sc_hd__decap_3
XFILLER_176_38 VGND VGND VPWR VPWR sky130_fd_sc_hd__decap_3
XFILLER_176_27 VGND VGND VPWR VPWR sky130_fd_sc_hd__fill_1
XFILLER_165_223 VGND VGND VPWR VPWR sky130_fd_sc_hd__fill_1
XFILLER_60_49 VGND VGND VPWR VPWR sky130_fd_sc_hd__decap_3
XFILLER_118_150 VGND VGND VPWR VPWR sky130_fd_sc_hd__decap_3
XFILLER_109_21 VGND VGND VPWR VPWR sky130_fd_sc_hd__decap_3
XFILLER_118_183 VGND VGND VPWR VPWR sky130_fd_sc_hd__decap_3
XFILLER_109_54 VGND VGND VPWR VPWR sky130_fd_sc_hd__fill_2
XFILLER_133_175 VGND VGND VPWR VPWR sky130_fd_sc_hd__decap_3
XFILLER_69_69 VGND VGND VPWR VPWR sky130_fd_sc_hd__decap_3
XFILLER_125_42 VGND VGND VPWR VPWR sky130_fd_sc_hd__fill_2
XFILLER_125_75 VGND VGND VPWR VPWR sky130_fd_sc_hd__decap_3
XTAP_TAPCELL_ROW_157_998 VGND VPWR sky130_fd_sc_hd__tapvpwrvgnd_1
XFILLER_47_159 VGND VGND VPWR VPWR sky130_fd_sc_hd__decap_3
XFILLER_141_52 VGND VGND VPWR VPWR sky130_fd_sc_hd__decap_3
XFILLER_141_96 VGND VGND VPWR VPWR sky130_fd_sc_hd__decap_3
XTAP_TAPCELL_ROW_125_873 VGND VPWR sky130_fd_sc_hd__tapvpwrvgnd_1
XFILLER_70_184 VGND VGND VPWR VPWR sky130_fd_sc_hd__decap_3
XFILLER_156_212 VGND VGND VPWR VPWR sky130_fd_sc_hd__fill_1
XFILLER_34_83 VGND VGND VPWR VPWR sky130_fd_sc_hd__fill_1
XFILLER_7_211 VGND VGND VPWR VPWR sky130_fd_sc_hd__decap_3
XFILLER_79_9 VGND VGND VPWR VPWR sky130_fd_sc_hd__decap_3
XFILLER_109_172 VGND VGND VPWR VPWR sky130_fd_sc_hd__decap_3
XFILLER_50_71 VGND VGND VPWR VPWR sky130_fd_sc_hd__decap_3
XFILLER_166_82 VGND VGND VPWR VPWR sky130_fd_sc_hd__fill_2
X_0540_ net4 net36 net261 _0085_ Tile_X0Y1_OpenRAM_bot.Inst_OpenRAM_bot_ConfigMem.Inst_frame5_bit4.Q
+ Tile_X0Y1_OpenRAM_bot.Inst_OpenRAM_bot_ConfigMem.Inst_frame5_bit5.Q VGND VGND VPWR
+ VPWR Tile_X0Y1_OpenRAM_bot.Inst_OpenRAM_bot_switch_matrix.W2BEGb2 sky130_fd_sc_hd__mux4_1
XFILLER_124_153 VGND VGND VPWR VPWR sky130_fd_sc_hd__decap_3
X_0471_ net66 Tile_X0Y0_OpenRAM_top.Inst_OpenRAM_top_ConfigMem.Inst_frame7_bit4.Q
+ Tile_X0Y0_OpenRAM_top.Inst_OpenRAM_top_ConfigMem.Inst_frame7_bit5.Q VGND VGND VPWR
+ VPWR _0115_ sky130_fd_sc_hd__o21ba_1
XFILLER_124_197 VGND VGND VPWR VPWR sky130_fd_sc_hd__decap_3
XTAP_TAPCELL_ROW_148_965 VGND VPWR sky130_fd_sc_hd__tapvpwrvgnd_1
XTAP_TAPCELL_ROW_162_1018 VGND VPWR sky130_fd_sc_hd__tapvpwrvgnd_1
XFILLER_38_159 VGND VGND VPWR VPWR sky130_fd_sc_hd__fill_2
XFILLER_53_107 VGND VGND VPWR VPWR sky130_fd_sc_hd__decap_3
X_1023_ net251 net325 VGND VGND VPWR VPWR Tile_X0Y1_OpenRAM_bot.Inst_OpenRAM_bot_ConfigMem.Inst_frame1_bit7.Q
+ sky130_fd_sc_hd__dlxtp_1
XPHY_EDGE_ROW_22_Left_205 VGND VGND VPWR VPWR sky130_fd_sc_hd__decap_3
XTAP_TAPCELL_ROW_32_500 VGND VPWR sky130_fd_sc_hd__tapvpwrvgnd_1
XFILLER_162_215 VGND VGND VPWR VPWR sky130_fd_sc_hd__decap_3
X_0807_ net116 net310 VGND VGND VPWR VPWR Tile_X0Y0_OpenRAM_top.Inst_OpenRAM_top_ConfigMem.Inst_frame3_bit11.Q
+ sky130_fd_sc_hd__dlxtp_1
XFILLER_146_19 VGND VGND VPWR VPWR sky130_fd_sc_hd__decap_3
X_0738_ net121 net327 VGND VGND VPWR VPWR Tile_X0Y0_OpenRAM_top.Inst_OpenRAM_top_ConfigMem.Inst_frame1_bit16.Q
+ sky130_fd_sc_hd__dlxtp_1
XPHY_EDGE_ROW_31_Left_214 VGND VGND VPWR VPWR sky130_fd_sc_hd__decap_3
XFILLER_115_164 VGND VGND VPWR VPWR sky130_fd_sc_hd__decap_3
XFILLER_130_134 VGND VGND VPWR VPWR sky130_fd_sc_hd__decap_3
X_0669_ _0204_ _0206_ _0207_ Tile_X0Y1_OpenRAM_bot.Inst_OpenRAM_bot_ConfigMem.Inst_frame6_bit4.Q
+ VGND VGND VPWR VPWR Tile_X0Y1_OpenRAM_bot.Inst_OpenRAM_bot_switch_matrix.S4BEG2
+ sky130_fd_sc_hd__o22a_1
XFILLER_130_156 VGND VGND VPWR VPWR sky130_fd_sc_hd__fill_2
XPHY_EDGE_ROW_2_Right_2 VGND VGND VPWR VPWR sky130_fd_sc_hd__decap_3
XTAP_TAPCELL_ROW_95_750 VGND VPWR sky130_fd_sc_hd__tapvpwrvgnd_1
XFILLER_55_49 VGND VGND VPWR VPWR sky130_fd_sc_hd__decap_3
XFILLER_37_181 VGND VGND VPWR VPWR sky130_fd_sc_hd__decap_3
XPHY_EDGE_ROW_40_Left_223 VGND VGND VPWR VPWR sky130_fd_sc_hd__decap_3
XFILLER_111_33 VGND VGND VPWR VPWR sky130_fd_sc_hd__decap_3
XFILLER_111_66 VGND VGND VPWR VPWR sky130_fd_sc_hd__decap_3
XFILLER_71_15 VGND VGND VPWR VPWR sky130_fd_sc_hd__decap_3
XFILLER_71_48 VGND VGND VPWR VPWR sky130_fd_sc_hd__decap_3
XFILLER_153_204 VGND VGND VPWR VPWR sky130_fd_sc_hd__fill_2
XFILLER_112_3 VGND VGND VPWR VPWR sky130_fd_sc_hd__fill_2
XFILLER_4_203 VGND VGND VPWR VPWR sky130_fd_sc_hd__decap_3
XFILLER_20_52 VGND VGND VPWR VPWR sky130_fd_sc_hd__decap_3
XFILLER_136_41 VGND VGND VPWR VPWR sky130_fd_sc_hd__decap_3
XFILLER_106_153 VGND VGND VPWR VPWR sky130_fd_sc_hd__decap_3
XFILLER_20_85 VGND VGND VPWR VPWR sky130_fd_sc_hd__decap_3
XFILLER_136_85 VGND VGND VPWR VPWR sky130_fd_sc_hd__decap_3
XFILLER_136_74 VGND VGND VPWR VPWR sky130_fd_sc_hd__decap_3
XFILLER_96_12 VGND VGND VPWR VPWR sky130_fd_sc_hd__fill_2
XFILLER_121_167 VGND VGND VPWR VPWR sky130_fd_sc_hd__fill_1
XFILLER_152_62 VGND VGND VPWR VPWR sky130_fd_sc_hd__decap_3
XFILLER_43_140 VGND VGND VPWR VPWR sky130_fd_sc_hd__decap_3
XTAP_TAPCELL_ROW_61_617 VGND VPWR sky130_fd_sc_hd__tapvpwrvgnd_1
XFILLER_43_195 VGND VGND VPWR VPWR sky130_fd_sc_hd__decap_3
XFILLER_129_201 VGND VGND VPWR VPWR sky130_fd_sc_hd__decap_3
XFILLER_61_81 VGND VGND VPWR VPWR sky130_fd_sc_hd__decap_3
XFILLER_77_6 VGND VGND VPWR VPWR sky130_fd_sc_hd__decap_3
XFILLER_144_215 VGND VGND VPWR VPWR sky130_fd_sc_hd__decap_3
XFILLER_6_32 VGND VGND VPWR VPWR sky130_fd_sc_hd__decap_3
XFILLER_6_21 VGND VGND VPWR VPWR sky130_fd_sc_hd__decap_3
XFILLER_6_65 VGND VGND VPWR VPWR sky130_fd_sc_hd__decap_3
XFILLER_112_134 VGND VGND VPWR VPWR sky130_fd_sc_hd__decap_3
X_0523_ net175 net188 net180 _0085_ Tile_X0Y1_OpenRAM_bot.Inst_OpenRAM_bot_ConfigMem.Inst_frame7_bit22.Q
+ Tile_X0Y1_OpenRAM_bot.Inst_OpenRAM_bot_ConfigMem.Inst_frame7_bit23.Q VGND VGND VPWR
+ VPWR Tile_X0Y1_OpenRAM_bot.Inst_OpenRAM_bot_switch_matrix.S2BEG5 sky130_fd_sc_hd__mux4_1
X_0454_ net81 net256 Tile_X0Y0_OpenRAM_top.Inst_OpenRAM_top_ConfigMem.Inst_frame2_bit31.Q
+ VGND VGND VPWR VPWR _0103_ sky130_fd_sc_hd__mux2_1
XFILLER_112_156 VGND VGND VPWR VPWR sky130_fd_sc_hd__decap_3
XFILLER_112_189 VGND VGND VPWR VPWR sky130_fd_sc_hd__decap_3
XPHY_EDGE_ROW_175_Right_175 VGND VGND VPWR VPWR sky130_fd_sc_hd__decap_3
X_0385_ net27 net59 net259 Tile_X0Y0_OpenRAM_top.Inst_OpenRAM_top_switch_matrix.J_NS2_BEG7
+ Tile_X0Y0_OpenRAM_top.Inst_OpenRAM_top_ConfigMem.Inst_frame5_bit26.Q Tile_X0Y0_OpenRAM_top.Inst_OpenRAM_top_ConfigMem.Inst_frame5_bit27.Q
+ VGND VGND VPWR VPWR Tile_X0Y0_OpenRAM_top.Inst_OpenRAM_top_switch_matrix.W2BEGb7
+ sky130_fd_sc_hd__mux4_1
XTAP_TAPCELL_ROW_84_709 VGND VPWR sky130_fd_sc_hd__tapvpwrvgnd_1
XFILLER_19_181 VGND VGND VPWR VPWR sky130_fd_sc_hd__decap_3
X_1006_ net238 net323 VGND VGND VPWR VPWR Tile_X0Y1_OpenRAM_bot.Inst_OpenRAM_bot_ConfigMem.Inst_frame1_bit24.Q
+ sky130_fd_sc_hd__dlxtp_1
XFILLER_179_156 VGND VGND VPWR VPWR sky130_fd_sc_hd__decap_3
XFILLER_179_134 VGND VGND VPWR VPWR sky130_fd_sc_hd__fill_1
XFILLER_179_178 VGND VGND VPWR VPWR sky130_fd_sc_hd__fill_1
XFILLER_179_167 VGND VGND VPWR VPWR sky130_fd_sc_hd__fill_1
XTAP_TAPCELL_ROW_177_1080 VGND VPWR sky130_fd_sc_hd__tapvpwrvgnd_1
XFILLER_135_215 VGND VGND VPWR VPWR sky130_fd_sc_hd__decap_3
XFILLER_150_218 VGND VGND VPWR VPWR sky130_fd_sc_hd__decap_3
XFILLER_173_39 VGND VGND VPWR VPWR sky130_fd_sc_hd__decap_3
XFILLER_106_11 VGND VGND VPWR VPWR sky130_fd_sc_hd__decap_3
XFILLER_103_101 VGND VGND VPWR VPWR sky130_fd_sc_hd__decap_3
XFILLER_9_9 VGND VGND VPWR VPWR sky130_fd_sc_hd__decap_3
XFILLER_1_217 VGND VGND VPWR VPWR sky130_fd_sc_hd__decap_3
XFILLER_106_44 VGND VGND VPWR VPWR sky130_fd_sc_hd__decap_3
XFILLER_103_167 VGND VGND VPWR VPWR sky130_fd_sc_hd__fill_1
XFILLER_106_77 VGND VGND VPWR VPWR sky130_fd_sc_hd__decap_3
XFILLER_103_178 VGND VGND VPWR VPWR sky130_fd_sc_hd__decap_3
XFILLER_57_210 VGND VGND VPWR VPWR sky130_fd_sc_hd__fill_2
XFILLER_181_6 VGND VGND VPWR VPWR sky130_fd_sc_hd__decap_3
XFILLER_106_88 VGND VGND VPWR VPWR sky130_fd_sc_hd__decap_3
XFILLER_66_59 VGND VGND VPWR VPWR sky130_fd_sc_hd__decap_3
XPHY_EDGE_ROW_142_Right_142 VGND VGND VPWR VPWR sky130_fd_sc_hd__decap_3
XFILLER_122_32 VGND VGND VPWR VPWR sky130_fd_sc_hd__decap_3
XTAP_TAPCELL_ROW_142_938 VGND VPWR sky130_fd_sc_hd__tapvpwrvgnd_1
XFILLER_122_65 VGND VGND VPWR VPWR sky130_fd_sc_hd__decap_3
XFILLER_25_140 VGND VGND VPWR VPWR sky130_fd_sc_hd__decap_3
XFILLER_82_47 VGND VGND VPWR VPWR sky130_fd_sc_hd__decap_3
XTAP_TAPCELL_ROW_150_971 VGND VPWR sky130_fd_sc_hd__tapvpwrvgnd_1
XFILLER_25_184 VGND VGND VPWR VPWR sky130_fd_sc_hd__decap_3
XFILLER_82_58 VGND VGND VPWR VPWR sky130_fd_sc_hd__decap_3
XTAP_TAPCELL_ROW_110_813 VGND VPWR sky130_fd_sc_hd__tapvpwrvgnd_1
XFILLER_15_63 VGND VGND VPWR VPWR sky130_fd_sc_hd__decap_3
XFILLER_40_121 VGND VGND VPWR VPWR sky130_fd_sc_hd__decap_3
XFILLER_40_165 VGND VGND VPWR VPWR sky130_fd_sc_hd__decap_3
XFILLER_147_40 VGND VGND VPWR VPWR sky130_fd_sc_hd__decap_3
XFILLER_31_84 VGND VGND VPWR VPWR sky130_fd_sc_hd__decap_3
XFILLER_147_84 VGND VGND VPWR VPWR sky130_fd_sc_hd__decap_3
Xinput151 Tile_X0Y0_S2END[1] VGND VGND VPWR VPWR net151 sky130_fd_sc_hd__clkbuf_2
Xinput162 Tile_X0Y0_S2MID[4] VGND VGND VPWR VPWR net162 sky130_fd_sc_hd__clkbuf_2
Xinput140 Tile_X0Y0_FrameData[4] VGND VGND VPWR VPWR net140 sky130_fd_sc_hd__clkbuf_4
XFILLER_48_221 VGND VGND VPWR VPWR sky130_fd_sc_hd__decap_3
Xinput173 Tile_X0Y0_S4END[7] VGND VGND VPWR VPWR net173 sky130_fd_sc_hd__clkbuf_4
Xinput184 Tile_X0Y1_E2END[6] VGND VGND VPWR VPWR net184 sky130_fd_sc_hd__clkbuf_2
Xinput195 Tile_X0Y1_E6END[10] VGND VGND VPWR VPWR net195 sky130_fd_sc_hd__clkbuf_2
XFILLER_63_202 VGND VGND VPWR VPWR sky130_fd_sc_hd__decap_3
XTAP_TAPCELL_ROW_133_905 VGND VPWR sky130_fd_sc_hd__tapvpwrvgnd_1
XFILLER_56_70 VGND VGND VPWR VPWR sky130_fd_sc_hd__decap_3
XFILLER_16_162 VGND VGND VPWR VPWR sky130_fd_sc_hd__decap_3
XFILLER_31_143 VGND VGND VPWR VPWR sky130_fd_sc_hd__decap_3
XFILLER_72_80 VGND VGND VPWR VPWR sky130_fd_sc_hd__decap_3
XFILLER_176_115 VGND VGND VPWR VPWR sky130_fd_sc_hd__decap_3
XFILLER_176_159 VGND VGND VPWR VPWR sky130_fd_sc_hd__decap_3
XFILLER_31_187 VGND VGND VPWR VPWR sky130_fd_sc_hd__decap_3
XFILLER_117_215 VGND VGND VPWR VPWR sky130_fd_sc_hd__decap_3
XFILLER_132_229 VGND VGND VPWR VPWR sky130_fd_sc_hd__fill_1
XPHY_EDGE_ROW_99_Right_99 VGND VGND VPWR VPWR sky130_fd_sc_hd__decap_3
Xfanout318 net320 VGND VGND VPWR VPWR net318 sky130_fd_sc_hd__clkbuf_2
X_0506_ net104 Tile_X0Y0_OpenRAM_top.Inst_OpenRAM_top_switch_matrix.J_NS4_BEG11 _0095_
+ Tile_X0Y0_OpenRAM_top.Inst_OpenRAM_top_switch_matrix.J_NS2_BEG7 Tile_X0Y0_OpenRAM_top.Inst_OpenRAM_top_ConfigMem.Inst_frame6_bit19.Q
+ Tile_X0Y0_OpenRAM_top.Inst_OpenRAM_top_ConfigMem.Inst_frame6_bit18.Q VGND VGND VPWR
+ VPWR _0143_ sky130_fd_sc_hd__mux4_1
XFILLER_98_165 VGND VGND VPWR VPWR sky130_fd_sc_hd__decap_3
Xfanout329 Tile_X0Y1_FrameStrobe[1] VGND VGND VPWR VPWR net329 sky130_fd_sc_hd__clkbuf_2
Xfanout307 Tile_X0Y1_FrameStrobe[3] VGND VGND VPWR VPWR net307 sky130_fd_sc_hd__clkbuf_4
XFILLER_100_115 VGND VGND VPWR VPWR sky130_fd_sc_hd__decap_3
X_1486_ Tile_X0Y1_OpenRAM_bot.Inst_OpenRAM_bot_switch_matrix.W6BEG4 VGND VGND VPWR
+ VPWR net648 sky130_fd_sc_hd__clkbuf_1
X_0437_ net106 net99 net87 Tile_X0Y0_OpenRAM_top.Inst_OpenRAM_top_switch_matrix.J_NS4_BEG10
+ Tile_X0Y0_OpenRAM_top.Inst_OpenRAM_top_ConfigMem.Inst_frame2_bit8.Q Tile_X0Y0_OpenRAM_top.Inst_OpenRAM_top_ConfigMem.Inst_frame2_bit9.Q
+ VGND VGND VPWR VPWR net404 sky130_fd_sc_hd__mux4_2
XFILLER_100_159 VGND VGND VPWR VPWR sky130_fd_sc_hd__decap_3
X_0368_ Tile_X0Y0_OpenRAM_top.Inst_OpenRAM_top_switch_matrix.N1END2 net12 net148 net44
+ Tile_X0Y0_OpenRAM_top.Inst_OpenRAM_top_ConfigMem.Inst_frame6_bit25.Q Tile_X0Y0_OpenRAM_top.Inst_OpenRAM_top_ConfigMem.Inst_frame6_bit24.Q
+ VGND VGND VPWR VPWR Tile_X0Y0_OpenRAM_top.Inst_OpenRAM_top_switch_matrix.W1BEG2
+ sky130_fd_sc_hd__mux4_1
XFILLER_36_29 VGND VGND VPWR VPWR sky130_fd_sc_hd__decap_3
XPHY_EDGE_ROW_6_Left_189 VGND VGND VPWR VPWR sky130_fd_sc_hd__decap_3
X_0299_ net175 Tile_X0Y1_OpenRAM_bot.Inst_OpenRAM_bot_switch_matrix.J_NS4_BEG13 net201
+ _0066_ Tile_X0Y1_OpenRAM_bot.Inst_OpenRAM_bot_ConfigMem.Inst_frame8_bit3.Q Tile_X0Y1_OpenRAM_bot.Inst_OpenRAM_bot_ConfigMem.Inst_frame8_bit2.Q
+ VGND VGND VPWR VPWR Tile_X0Y0_OpenRAM_top.Inst_OpenRAM_top_switch_matrix.N1END1
+ sky130_fd_sc_hd__mux4_2
XFILLER_22_121 VGND VGND VPWR VPWR sky130_fd_sc_hd__decap_3
XFILLER_108_215 VGND VGND VPWR VPWR sky130_fd_sc_hd__decap_3
XFILLER_175_181 VGND VGND VPWR VPWR sky130_fd_sc_hd__decap_3
XFILLER_117_32 VGND VGND VPWR VPWR sky130_fd_sc_hd__decap_3
XFILLER_7_6 VGND VGND VPWR VPWR sky130_fd_sc_hd__decap_3
XFILLER_77_36 VGND VGND VPWR VPWR sky130_fd_sc_hd__decap_3
XFILLER_117_98 VGND VGND VPWR VPWR sky130_fd_sc_hd__decap_3
XFILLER_77_69 VGND VGND VPWR VPWR sky130_fd_sc_hd__decap_3
XFILLER_133_20 VGND VGND VPWR VPWR sky130_fd_sc_hd__decap_3
XFILLER_93_24 VGND VGND VPWR VPWR sky130_fd_sc_hd__decap_3
XFILLER_45_213 VGND VGND VPWR VPWR sky130_fd_sc_hd__decap_3
XFILLER_93_57 VGND VGND VPWR VPWR sky130_fd_sc_hd__decap_3
XFILLER_93_68 VGND VGND VPWR VPWR sky130_fd_sc_hd__decap_3
XFILLER_26_73 VGND VGND VPWR VPWR sky130_fd_sc_hd__decap_3
XFILLER_158_137 VGND VGND VPWR VPWR sky130_fd_sc_hd__decap_3
XFILLER_9_125 VGND VGND VPWR VPWR sky130_fd_sc_hd__decap_3
XFILLER_13_187 VGND VGND VPWR VPWR sky130_fd_sc_hd__decap_3
XFILLER_9_158 VGND VGND VPWR VPWR sky130_fd_sc_hd__decap_3
XFILLER_42_50 VGND VGND VPWR VPWR sky130_fd_sc_hd__decap_3
XFILLER_9_169 VGND VGND VPWR VPWR sky130_fd_sc_hd__decap_3
XFILLER_42_83 VGND VGND VPWR VPWR sky130_fd_sc_hd__fill_1
XFILLER_166_192 VGND VGND VPWR VPWR sky130_fd_sc_hd__decap_3
XFILLER_158_94 VGND VGND VPWR VPWR sky130_fd_sc_hd__decap_3
XFILLER_158_83 VGND VGND VPWR VPWR sky130_fd_sc_hd__fill_1
XFILLER_61_9 VGND VGND VPWR VPWR sky130_fd_sc_hd__fill_1
XFILLER_181_162 VGND VGND VPWR VPWR sky130_fd_sc_hd__decap_3
XFILLER_181_151 VGND VGND VPWR VPWR sky130_fd_sc_hd__fill_2
XFILLER_114_218 VGND VGND VPWR VPWR sky130_fd_sc_hd__decap_3
XFILLER_174_71 VGND VGND VPWR VPWR sky130_fd_sc_hd__decap_3
X_1340_ Tile_X0Y0_OpenRAM_top.N4BEG_outbuf_11.A VGND VGND VPWR VPWR net491 sky130_fd_sc_hd__buf_4
XFILLER_3_33 VGND VGND VPWR VPWR sky130_fd_sc_hd__decap_3
XFILLER_95_102 VGND VGND VPWR VPWR sky130_fd_sc_hd__fill_2
XFILLER_95_113 VGND VGND VPWR VPWR sky130_fd_sc_hd__decap_3
X_1271_ net119 VGND VGND VPWR VPWR net422 sky130_fd_sc_hd__clkbuf_2
XFILLER_3_66 VGND VGND VPWR VPWR sky130_fd_sc_hd__decap_3
XFILLER_3_99 VGND VGND VPWR VPWR sky130_fd_sc_hd__decap_3
XFILLER_67_91 VGND VGND VPWR VPWR sky130_fd_sc_hd__decap_3
XFILLER_51_205 VGND VGND VPWR VPWR sky130_fd_sc_hd__decap_3
XFILLER_83_90 VGND VGND VPWR VPWR sky130_fd_sc_hd__decap_3
XFILLER_149_137 VGND VGND VPWR VPWR sky130_fd_sc_hd__decap_3
Xclkbuf_0_Tile_X0Y1_UserCLK Tile_X0Y1_UserCLK VGND VGND VPWR VPWR clknet_0_Tile_X0Y1_UserCLK
+ sky130_fd_sc_hd__clkbuf_16
X_0986_ net225 net333 VGND VGND VPWR VPWR Tile_X0Y1_OpenRAM_bot.Inst_OpenRAM_bot_ConfigMem.Inst_frame0_bit12.Q
+ sky130_fd_sc_hd__dlxtp_1
XFILLER_8_180 VGND VGND VPWR VPWR sky130_fd_sc_hd__decap_3
Xoutput400 net483 VGND VGND VPWR VPWR Tile_X0Y0_N2BEGb[2] sky130_fd_sc_hd__buf_2
Xoutput411 net494 VGND VGND VPWR VPWR Tile_X0Y0_N4BEG[14] sky130_fd_sc_hd__buf_2
XFILLER_172_162 VGND VGND VPWR VPWR sky130_fd_sc_hd__decap_3
Xoutput422 net505 VGND VGND VPWR VPWR Tile_X0Y0_UserCLKo sky130_fd_sc_hd__buf_1
XFILLER_172_195 VGND VGND VPWR VPWR sky130_fd_sc_hd__fill_1
Xoutput444 net527 VGND VGND VPWR VPWR Tile_X0Y0_W6BEG[10] sky130_fd_sc_hd__buf_2
Xoutput433 net516 VGND VGND VPWR VPWR Tile_X0Y0_W2BEG[6] sky130_fd_sc_hd__buf_2
Xoutput477 net560 VGND VGND VPWR VPWR Tile_X0Y1_FrameData_O[15] sky130_fd_sc_hd__buf_2
Xoutput466 net549 VGND VGND VPWR VPWR Tile_X0Y0_WW4BEG[5] sky130_fd_sc_hd__buf_2
Xoutput455 net538 VGND VGND VPWR VPWR Tile_X0Y0_WW4BEG[0] sky130_fd_sc_hd__buf_2
Xoutput488 net571 VGND VGND VPWR VPWR Tile_X0Y1_FrameData_O[25] sky130_fd_sc_hd__buf_2
Xoutput499 net582 VGND VGND VPWR VPWR Tile_X0Y1_FrameData_O[6] sky130_fd_sc_hd__buf_2
X_1469_ Tile_X0Y1_OpenRAM_bot.Inst_OpenRAM_bot_switch_matrix.W2BEG3 VGND VGND VPWR
+ VPWR net629 sky130_fd_sc_hd__buf_1
XFILLER_86_124 VGND VGND VPWR VPWR sky130_fd_sc_hd__decap_3
XFILLER_170_29 VGND VGND VPWR VPWR sky130_fd_sc_hd__decap_3
XFILLER_170_18 VGND VGND VPWR VPWR sky130_fd_sc_hd__decap_3
XFILLER_103_12 VGND VGND VPWR VPWR sky130_fd_sc_hd__decap_3
XTAP_TAPCELL_ROW_2_378 VGND VPWR sky130_fd_sc_hd__tapvpwrvgnd_1
XFILLER_103_89 VGND VGND VPWR VPWR sky130_fd_sc_hd__decap_3
XFILLER_63_49 VGND VGND VPWR VPWR sky130_fd_sc_hd__decap_3
XFILLER_179_27 VGND VGND VPWR VPWR sky130_fd_sc_hd__decap_3
XFILLER_10_124 VGND VGND VPWR VPWR sky130_fd_sc_hd__decap_3
XFILLER_10_168 VGND VGND VPWR VPWR sky130_fd_sc_hd__decap_3
XFILLER_6_106 VGND VGND VPWR VPWR sky130_fd_sc_hd__decap_3
XFILLER_148_192 VGND VGND VPWR VPWR sky130_fd_sc_hd__decap_3
XFILLER_12_53 VGND VGND VPWR VPWR sky130_fd_sc_hd__decap_3
XFILLER_6_139 VGND VGND VPWR VPWR sky130_fd_sc_hd__fill_1
XFILLER_128_64 VGND VGND VPWR VPWR sky130_fd_sc_hd__decap_3
XFILLER_12_97 VGND VGND VPWR VPWR sky130_fd_sc_hd__decap_3
XFILLER_163_184 VGND VGND VPWR VPWR sky130_fd_sc_hd__decap_3
XFILLER_88_24 VGND VGND VPWR VPWR sky130_fd_sc_hd__decap_3
XFILLER_88_35 VGND VGND VPWR VPWR sky130_fd_sc_hd__decap_3
XFILLER_5_3 VGND VGND VPWR VPWR sky130_fd_sc_hd__decap_3
XFILLER_88_68 VGND VGND VPWR VPWR sky130_fd_sc_hd__decap_3
XFILLER_77_113 VGND VGND VPWR VPWR sky130_fd_sc_hd__decap_3
XFILLER_144_63 VGND VGND VPWR VPWR sky130_fd_sc_hd__decap_3
XFILLER_18_224 VGND VGND VPWR VPWR sky130_fd_sc_hd__decap_3
XFILLER_37_72 VGND VGND VPWR VPWR sky130_fd_sc_hd__decap_3
XFILLER_85_190 VGND VGND VPWR VPWR sky130_fd_sc_hd__decap_3
XFILLER_33_205 VGND VGND VPWR VPWR sky130_fd_sc_hd__decap_3
XTAP_TAPCELL_ROW_16_436 VGND VPWR sky130_fd_sc_hd__tapvpwrvgnd_1
XTAP_TAPCELL_ROW_56_594 VGND VPWR sky130_fd_sc_hd__tapvpwrvgnd_1
XFILLER_169_60 VGND VGND VPWR VPWR sky130_fd_sc_hd__decap_3
XFILLER_169_93 VGND VGND VPWR VPWR sky130_fd_sc_hd__decap_3
X_0840_ net115 net302 VGND VGND VPWR VPWR Tile_X0Y0_OpenRAM_top.Inst_OpenRAM_top_ConfigMem.Inst_frame4_bit10.Q
+ sky130_fd_sc_hd__dlxtp_1
XFILLER_146_129 VGND VGND VPWR VPWR sky130_fd_sc_hd__decap_3
X_0771_ net120 net318 VGND VGND VPWR VPWR Tile_X0Y0_OpenRAM_top.Inst_OpenRAM_top_ConfigMem.Inst_frame2_bit15.Q
+ sky130_fd_sc_hd__dlxtp_1
XFILLER_154_195 VGND VGND VPWR VPWR sky130_fd_sc_hd__fill_1
XFILLER_154_162 VGND VGND VPWR VPWR sky130_fd_sc_hd__decap_3
XFILLER_5_172 VGND VGND VPWR VPWR sky130_fd_sc_hd__decap_3
XFILLER_5_161 VGND VGND VPWR VPWR sky130_fd_sc_hd__decap_3
XFILLER_38_3 VGND VGND VPWR VPWR sky130_fd_sc_hd__fill_1
XFILLER_68_135 VGND VGND VPWR VPWR sky130_fd_sc_hd__decap_3
X_1323_ Tile_X0Y0_OpenRAM_top.Inst_OpenRAM_top_switch_matrix.N2BEGb2 VGND VGND VPWR
+ VPWR net483 sky130_fd_sc_hd__buf_2
X_1254_ net222 net264 VGND VGND VPWR VPWR Tile_X0Y1_OpenRAM_bot.Inst_OpenRAM_bot_ConfigMem.Inst_frame8_bit0.Q
+ sky130_fd_sc_hd__dlxtp_1
XFILLER_68_168 VGND VGND VPWR VPWR sky130_fd_sc_hd__decap_3
XFILLER_83_105 VGND VGND VPWR VPWR sky130_fd_sc_hd__decap_3
XTAP_TAPCELL_ROW_39_528 VGND VPWR sky130_fd_sc_hd__tapvpwrvgnd_1
XTAP_TAPCELL_ROW_79_686 VGND VPWR sky130_fd_sc_hd__tapvpwrvgnd_1
XFILLER_83_116 VGND VGND VPWR VPWR sky130_fd_sc_hd__decap_3
X_1185_ net249 net281 VGND VGND VPWR VPWR Tile_X0Y1_OpenRAM_bot.Inst_OpenRAM_bot_ConfigMem.Inst_frame6_bit5.Q
+ sky130_fd_sc_hd__dlxtp_1
XFILLER_76_190 VGND VGND VPWR VPWR sky130_fd_sc_hd__decap_3
XFILLER_83_149 VGND VGND VPWR VPWR sky130_fd_sc_hd__decap_3
XTAP_TAPCELL_ROW_47_561 VGND VPWR sky130_fd_sc_hd__tapvpwrvgnd_1
XFILLER_149_19 VGND VGND VPWR VPWR sky130_fd_sc_hd__decap_3
XPHY_EDGE_ROW_96_Left_279 VGND VGND VPWR VPWR sky130_fd_sc_hd__decap_3
XFILLER_137_129 VGND VGND VPWR VPWR sky130_fd_sc_hd__decap_3
X_0969_ net243 net331 VGND VGND VPWR VPWR Tile_X0Y1_OpenRAM_bot.Inst_OpenRAM_bot_ConfigMem.Inst_frame0_bit29.Q
+ sky130_fd_sc_hd__dlxtp_1
XFILLER_165_18 VGND VGND VPWR VPWR sky130_fd_sc_hd__decap_3
XFILLER_145_140 VGND VGND VPWR VPWR sky130_fd_sc_hd__decap_3
XFILLER_145_195 VGND VGND VPWR VPWR sky130_fd_sc_hd__decap_3
XFILLER_160_165 VGND VGND VPWR VPWR sky130_fd_sc_hd__decap_3
XFILLER_58_27 VGND VGND VPWR VPWR sky130_fd_sc_hd__fill_1
XFILLER_58_38 VGND VGND VPWR VPWR sky130_fd_sc_hd__decap_3
XFILLER_59_102 VGND VGND VPWR VPWR sky130_fd_sc_hd__decap_3
Xoutput285 net368 VGND VGND VPWR VPWR ADDR_A_SRAM3 sky130_fd_sc_hd__buf_2
Xoutput296 net379 VGND VGND VPWR VPWR ADDR_B_SRAM6 sky130_fd_sc_hd__buf_2
XFILLER_59_113 VGND VGND VPWR VPWR sky130_fd_sc_hd__decap_3
XFILLER_59_146 VGND VGND VPWR VPWR sky130_fd_sc_hd__decap_3
XFILLER_74_15 VGND VGND VPWR VPWR sky130_fd_sc_hd__fill_1
XFILLER_114_88 VGND VGND VPWR VPWR sky130_fd_sc_hd__decap_3
XFILLER_74_37 VGND VGND VPWR VPWR sky130_fd_sc_hd__decap_3
XFILLER_15_216 VGND VGND VPWR VPWR sky130_fd_sc_hd__decap_3
XFILLER_130_32 VGND VGND VPWR VPWR sky130_fd_sc_hd__decap_3
XFILLER_82_182 VGND VGND VPWR VPWR sky130_fd_sc_hd__decap_3
XTAP_TAPCELL_ROW_105_790 VGND VPWR sky130_fd_sc_hd__tapvpwrvgnd_1
XFILLER_90_25 VGND VGND VPWR VPWR sky130_fd_sc_hd__decap_3
XFILLER_168_221 VGND VGND VPWR VPWR sky130_fd_sc_hd__decap_3
XFILLER_139_30 VGND VGND VPWR VPWR sky130_fd_sc_hd__decap_3
XFILLER_128_118 VGND VGND VPWR VPWR sky130_fd_sc_hd__decap_3
XFILLER_139_63 VGND VGND VPWR VPWR sky130_fd_sc_hd__decap_3
XFILLER_99_12 VGND VGND VPWR VPWR sky130_fd_sc_hd__decap_3
XFILLER_99_45 VGND VGND VPWR VPWR sky130_fd_sc_hd__decap_3
XFILLER_136_162 VGND VGND VPWR VPWR sky130_fd_sc_hd__decap_3
XFILLER_99_78 VGND VGND VPWR VPWR sky130_fd_sc_hd__decap_3
XFILLER_155_40 VGND VGND VPWR VPWR sky130_fd_sc_hd__decap_3
XFILLER_151_187 VGND VGND VPWR VPWR sky130_fd_sc_hd__decap_3
XFILLER_97_219 VGND VGND VPWR VPWR sky130_fd_sc_hd__decap_3
XFILLER_2_186 VGND VGND VPWR VPWR sky130_fd_sc_hd__decap_3
XFILLER_2_197 VGND VGND VPWR VPWR sky130_fd_sc_hd__decap_3
XFILLER_65_105 VGND VGND VPWR VPWR sky130_fd_sc_hd__decap_3
XFILLER_171_72 VGND VGND VPWR VPWR sky130_fd_sc_hd__decap_3
XFILLER_65_116 VGND VGND VPWR VPWR sky130_fd_sc_hd__decap_3
XTAP_TAPCELL_ROW_128_882 VGND VPWR sky130_fd_sc_hd__tapvpwrvgnd_1
XFILLER_0_12 VGND VGND VPWR VPWR sky130_fd_sc_hd__decap_3
XFILLER_65_149 VGND VGND VPWR VPWR sky130_fd_sc_hd__decap_3
XFILLER_159_210 VGND VGND VPWR VPWR sky130_fd_sc_hd__decap_3
XFILLER_9_21 VGND VGND VPWR VPWR sky130_fd_sc_hd__decap_3
XFILLER_21_219 VGND VGND VPWR VPWR sky130_fd_sc_hd__fill_2
XFILLER_9_54 VGND VGND VPWR VPWR sky130_fd_sc_hd__fill_2
XFILLER_119_107 VGND VGND VPWR VPWR sky130_fd_sc_hd__decap_3
XFILLER_9_87 VGND VGND VPWR VPWR sky130_fd_sc_hd__decap_3
XFILLER_174_224 VGND VGND VPWR VPWR sky130_fd_sc_hd__decap_3
X_0823_ net133 net300 VGND VGND VPWR VPWR Tile_X0Y0_OpenRAM_top.Inst_OpenRAM_top_ConfigMem.Inst_frame4_bit27.Q
+ sky130_fd_sc_hd__dlxtp_1
XFILLER_127_151 VGND VGND VPWR VPWR sky130_fd_sc_hd__fill_1
XFILLER_127_184 VGND VGND VPWR VPWR sky130_fd_sc_hd__decap_3
X_0754_ net114 net329 VGND VGND VPWR VPWR Tile_X0Y0_OpenRAM_top.Inst_OpenRAM_top_ConfigMem.Inst_frame1_bit0.Q
+ sky130_fd_sc_hd__dlxtp_1
X_0685_ _0221_ Tile_X0Y1_OpenRAM_bot.Inst_OpenRAM_bot_ConfigMem.Inst_frame3_bit13.Q
+ Tile_X0Y1_OpenRAM_bot.Inst_OpenRAM_bot_ConfigMem.Inst_frame3_bit14.Q VGND VGND VPWR
+ VPWR _0222_ sky130_fd_sc_hd__or3b_1
X_1306_ Tile_X0Y1_FrameStrobe[17] VGND VGND VPWR VPWR net457 sky130_fd_sc_hd__clkbuf_1
XFILLER_56_116 VGND VGND VPWR VPWR sky130_fd_sc_hd__decap_3
X_1237_ net230 net264 VGND VGND VPWR VPWR Tile_X0Y1_OpenRAM_bot.Inst_OpenRAM_bot_ConfigMem.Inst_frame8_bit17.Q
+ sky130_fd_sc_hd__dlxtp_1
X_1168_ net236 net278 VGND VGND VPWR VPWR Tile_X0Y1_OpenRAM_bot.Inst_OpenRAM_bot_ConfigMem.Inst_frame6_bit22.Q
+ sky130_fd_sc_hd__dlxtp_1
XFILLER_44_29 VGND VGND VPWR VPWR sky130_fd_sc_hd__decap_3
XFILLER_64_193 VGND VGND VPWR VPWR sky130_fd_sc_hd__decap_3
X_1099_ net241 net297 VGND VGND VPWR VPWR Tile_X0Y1_OpenRAM_bot.Inst_OpenRAM_bot_ConfigMem.Inst_frame4_bit27.Q
+ sky130_fd_sc_hd__dlxtp_1
XFILLER_100_35 VGND VGND VPWR VPWR sky130_fd_sc_hd__decap_3
XFILLER_100_24 VGND VGND VPWR VPWR sky130_fd_sc_hd__decap_3
XFILLER_165_202 VGND VGND VPWR VPWR sky130_fd_sc_hd__decap_3
XFILLER_100_79 VGND VGND VPWR VPWR sky130_fd_sc_hd__decap_3
XFILLER_180_227 VGND VGND VPWR VPWR sky130_fd_sc_hd__decap_3
XFILLER_133_110 VGND VGND VPWR VPWR sky130_fd_sc_hd__fill_2
XFILLER_118_162 VGND VGND VPWR VPWR sky130_fd_sc_hd__decap_3
XFILLER_114_7 VGND VGND VPWR VPWR sky130_fd_sc_hd__decap_3
XFILLER_109_33 VGND VGND VPWR VPWR sky130_fd_sc_hd__decap_3
XFILLER_118_195 VGND VGND VPWR VPWR sky130_fd_sc_hd__fill_1
XFILLER_109_88 VGND VGND VPWR VPWR sky130_fd_sc_hd__decap_3
XFILLER_109_66 VGND VGND VPWR VPWR sky130_fd_sc_hd__fill_1
XFILLER_69_15 VGND VGND VPWR VPWR sky130_fd_sc_hd__decap_3
XFILLER_69_37 VGND VGND VPWR VPWR sky130_fd_sc_hd__decap_3
XFILLER_79_208 VGND VGND VPWR VPWR sky130_fd_sc_hd__decap_3
XFILLER_133_187 VGND VGND VPWR VPWR sky130_fd_sc_hd__decap_3
XFILLER_125_21 VGND VGND VPWR VPWR sky130_fd_sc_hd__decap_3
XFILLER_47_116 VGND VGND VPWR VPWR sky130_fd_sc_hd__decap_3
XFILLER_85_36 VGND VGND VPWR VPWR sky130_fd_sc_hd__fill_1
XTAP_TAPCELL_ROW_157_999 VGND VPWR sky130_fd_sc_hd__tapvpwrvgnd_1
XFILLER_18_41 VGND VGND VPWR VPWR sky130_fd_sc_hd__fill_2
XFILLER_85_69 VGND VGND VPWR VPWR sky130_fd_sc_hd__decap_3
XFILLER_141_31 VGND VGND VPWR VPWR sky130_fd_sc_hd__decap_3
XFILLER_18_85 VGND VGND VPWR VPWR sky130_fd_sc_hd__decap_3
XFILLER_55_160 VGND VGND VPWR VPWR sky130_fd_sc_hd__decap_3
XFILLER_62_119 VGND VGND VPWR VPWR sky130_fd_sc_hd__decap_3
XFILLER_141_75 VGND VGND VPWR VPWR sky130_fd_sc_hd__decap_3
XFILLER_70_130 VGND VGND VPWR VPWR sky130_fd_sc_hd__decap_3
XFILLER_70_163 VGND VGND VPWR VPWR sky130_fd_sc_hd__decap_3
XTAP_TAPCELL_ROW_41_534 VGND VPWR sky130_fd_sc_hd__tapvpwrvgnd_1
XFILLER_7_223 VGND VGND VPWR VPWR sky130_fd_sc_hd__fill_1
XFILLER_109_140 VGND VGND VPWR VPWR sky130_fd_sc_hd__decap_3
XFILLER_50_50 VGND VGND VPWR VPWR sky130_fd_sc_hd__decap_3
XFILLER_171_205 VGND VGND VPWR VPWR sky130_fd_sc_hd__decap_3
XFILLER_166_50 VGND VGND VPWR VPWR sky130_fd_sc_hd__decap_3
XFILLER_50_83 VGND VGND VPWR VPWR sky130_fd_sc_hd__fill_1
XFILLER_50_94 VGND VGND VPWR VPWR sky130_fd_sc_hd__decap_3
XFILLER_124_121 VGND VGND VPWR VPWR sky130_fd_sc_hd__decap_3
XFILLER_109_184 VGND VGND VPWR VPWR sky130_fd_sc_hd__decap_3
X_0470_ net98 Tile_X0Y0_OpenRAM_top.Inst_OpenRAM_top_ConfigMem.Inst_frame7_bit4.Q
+ VGND VGND VPWR VPWR _0114_ sky130_fd_sc_hd__nand2b_1
XPHY_EDGE_ROW_156_Right_156 VGND VGND VPWR VPWR sky130_fd_sc_hd__decap_3
XFILLER_124_165 VGND VGND VPWR VPWR sky130_fd_sc_hd__decap_3
XFILLER_93_211 VGND VGND VPWR VPWR sky130_fd_sc_hd__decap_3
XTAP_TAPCELL_ROW_162_1019 VGND VPWR sky130_fd_sc_hd__tapvpwrvgnd_1
XFILLER_38_138 VGND VGND VPWR VPWR sky130_fd_sc_hd__fill_2
X_1022_ net252 net323 VGND VGND VPWR VPWR Tile_X0Y1_OpenRAM_bot.Inst_OpenRAM_bot_ConfigMem.Inst_frame1_bit8.Q
+ sky130_fd_sc_hd__dlxtp_1
XTAP_TAPCELL_ROW_64_626 VGND VPWR sky130_fd_sc_hd__tapvpwrvgnd_1
XFILLER_75_91 VGND VGND VPWR VPWR sky130_fd_sc_hd__decap_3
XFILLER_46_193 VGND VGND VPWR VPWR sky130_fd_sc_hd__decap_3
XTAP_TAPCELL_ROW_32_501 VGND VPWR sky130_fd_sc_hd__tapvpwrvgnd_1
XFILLER_147_202 VGND VGND VPWR VPWR sky130_fd_sc_hd__decap_3
X_0806_ net117 net308 VGND VGND VPWR VPWR Tile_X0Y0_OpenRAM_top.Inst_OpenRAM_top_ConfigMem.Inst_frame3_bit12.Q
+ sky130_fd_sc_hd__dlxtp_1
X_0737_ net122 net327 VGND VGND VPWR VPWR Tile_X0Y0_OpenRAM_top.Inst_OpenRAM_top_ConfigMem.Inst_frame1_bit17.Q
+ sky130_fd_sc_hd__dlxtp_1
XPHY_EDGE_ROW_123_Right_123 VGND VGND VPWR VPWR sky130_fd_sc_hd__decap_3
X_0668_ net176 net211 net202 _0154_ Tile_X0Y1_OpenRAM_bot.Inst_OpenRAM_bot_ConfigMem.Inst_frame6_bit2.Q
+ Tile_X0Y1_OpenRAM_bot.Inst_OpenRAM_bot_ConfigMem.Inst_frame6_bit3.Q VGND VGND VPWR
+ VPWR _0207_ sky130_fd_sc_hd__mux4_1
X_0599_ _0025_ Tile_X0Y1_OpenRAM_bot.Inst_OpenRAM_bot_ConfigMem.Inst_frame3_bit27.Q
+ _0083_ _0164_ VGND VGND VPWR VPWR net368 sky130_fd_sc_hd__a31o_1
XTAP_TAPCELL_ROW_87_718 VGND VPWR sky130_fd_sc_hd__tapvpwrvgnd_1
XPHY_EDGE_ROW_179_Left_362 VGND VGND VPWR VPWR sky130_fd_sc_hd__decap_3
XFILLER_29_116 VGND VGND VPWR VPWR sky130_fd_sc_hd__fill_1
XTAP_TAPCELL_ROW_95_751 VGND VPWR sky130_fd_sc_hd__tapvpwrvgnd_1
XFILLER_176_9 VGND VGND VPWR VPWR sky130_fd_sc_hd__decap_3
XFILLER_37_193 VGND VGND VPWR VPWR sky130_fd_sc_hd__decap_3
XFILLER_111_45 VGND VGND VPWR VPWR sky130_fd_sc_hd__decap_3
XFILLER_52_141 VGND VGND VPWR VPWR sky130_fd_sc_hd__decap_3
XFILLER_111_78 VGND VGND VPWR VPWR sky130_fd_sc_hd__decap_3
XFILLER_71_27 VGND VGND VPWR VPWR sky130_fd_sc_hd__decap_3
XFILLER_4_215 VGND VGND VPWR VPWR sky130_fd_sc_hd__decap_3
XFILLER_106_132 VGND VGND VPWR VPWR sky130_fd_sc_hd__decap_3
XFILLER_105_3 VGND VGND VPWR VPWR sky130_fd_sc_hd__decap_3
XFILLER_136_53 VGND VGND VPWR VPWR sky130_fd_sc_hd__decap_3
XFILLER_106_165 VGND VGND VPWR VPWR sky130_fd_sc_hd__decap_3
XFILLER_20_64 VGND VGND VPWR VPWR sky130_fd_sc_hd__fill_1
XFILLER_121_124 VGND VGND VPWR VPWR sky130_fd_sc_hd__decap_3
XFILLER_121_113 VGND VGND VPWR VPWR sky130_fd_sc_hd__fill_2
XFILLER_121_102 VGND VGND VPWR VPWR sky130_fd_sc_hd__fill_1
XFILLER_20_97 VGND VGND VPWR VPWR sky130_fd_sc_hd__decap_3
XFILLER_121_146 VGND VGND VPWR VPWR sky130_fd_sc_hd__decap_3
XFILLER_29_51 VGND VGND VPWR VPWR sky130_fd_sc_hd__decap_3
XFILLER_96_79 VGND VGND VPWR VPWR sky130_fd_sc_hd__decap_3
XFILLER_29_73 VGND VGND VPWR VPWR sky130_fd_sc_hd__decap_3
XFILLER_75_222 VGND VGND VPWR VPWR sky130_fd_sc_hd__fill_2
XFILLER_152_85 VGND VGND VPWR VPWR sky130_fd_sc_hd__decap_3
XFILLER_152_74 VGND VGND VPWR VPWR sky130_fd_sc_hd__decap_3
XFILLER_35_108 VGND VGND VPWR VPWR sky130_fd_sc_hd__decap_3
XFILLER_35_119 VGND VGND VPWR VPWR sky130_fd_sc_hd__decap_3
XFILLER_90_203 VGND VGND VPWR VPWR sky130_fd_sc_hd__decap_3
XFILLER_90_225 VGND VGND VPWR VPWR sky130_fd_sc_hd__decap_3
XTAP_TAPCELL_ROW_113_822 VGND VPWR sky130_fd_sc_hd__tapvpwrvgnd_1
XFILLER_43_152 VGND VGND VPWR VPWR sky130_fd_sc_hd__decap_3
XFILLER_45_94 VGND VGND VPWR VPWR sky130_fd_sc_hd__decap_3
XFILLER_91_9 VGND VGND VPWR VPWR sky130_fd_sc_hd__decap_3
XFILLER_129_213 VGND VGND VPWR VPWR sky130_fd_sc_hd__decap_3
XFILLER_177_60 VGND VGND VPWR VPWR sky130_fd_sc_hd__decap_3
XFILLER_61_93 VGND VGND VPWR VPWR sky130_fd_sc_hd__decap_3
XFILLER_177_93 VGND VGND VPWR VPWR sky130_fd_sc_hd__decap_3
XFILLER_144_227 VGND VGND VPWR VPWR sky130_fd_sc_hd__decap_3
XFILLER_6_44 VGND VGND VPWR VPWR sky130_fd_sc_hd__decap_3
XFILLER_6_88 VGND VGND VPWR VPWR sky130_fd_sc_hd__decap_3
XFILLER_6_77 VGND VGND VPWR VPWR sky130_fd_sc_hd__decap_3
X_0522_ net174 net181 net189 _0084_ Tile_X0Y1_OpenRAM_bot.Inst_OpenRAM_bot_ConfigMem.Inst_frame7_bit21.Q
+ Tile_X0Y1_OpenRAM_bot.Inst_OpenRAM_bot_ConfigMem.Inst_frame7_bit20.Q VGND VGND VPWR
+ VPWR Tile_X0Y1_OpenRAM_bot.Inst_OpenRAM_bot_switch_matrix.S2BEG4 sky130_fd_sc_hd__mux4_1
XFILLER_112_113 VGND VGND VPWR VPWR sky130_fd_sc_hd__decap_3
XFILLER_112_168 VGND VGND VPWR VPWR sky130_fd_sc_hd__decap_3
X_0453_ _0102_ Tile_X0Y0_OpenRAM_top.Inst_OpenRAM_top_ConfigMem.Inst_frame2_bit29.Q
+ _0007_ _0101_ VGND VGND VPWR VPWR net371 sky130_fd_sc_hd__a2bb2o_1
X_0384_ net26 net58 net258 Tile_X0Y0_OpenRAM_top.Inst_OpenRAM_top_switch_matrix.J_NS2_BEG6
+ Tile_X0Y0_OpenRAM_top.Inst_OpenRAM_top_ConfigMem.Inst_frame5_bit24.Q Tile_X0Y0_OpenRAM_top.Inst_OpenRAM_top_ConfigMem.Inst_frame5_bit25.Q
+ VGND VGND VPWR VPWR Tile_X0Y0_OpenRAM_top.Inst_OpenRAM_top_switch_matrix.W2BEGb6
+ sky130_fd_sc_hd__mux4_1
XTAP_TAPCELL_ROW_136_914 VGND VPWR sky130_fd_sc_hd__tapvpwrvgnd_1
XFILLER_120_190 VGND VGND VPWR VPWR sky130_fd_sc_hd__decap_3
XFILLER_26_119 VGND VGND VPWR VPWR sky130_fd_sc_hd__decap_3
XFILLER_81_214 VGND VGND VPWR VPWR sky130_fd_sc_hd__decap_3
XFILLER_179_113 VGND VGND VPWR VPWR sky130_fd_sc_hd__decap_3
XFILLER_179_102 VGND VGND VPWR VPWR sky130_fd_sc_hd__decap_3
XFILLER_19_193 VGND VGND VPWR VPWR sky130_fd_sc_hd__decap_3
XFILLER_34_141 VGND VGND VPWR VPWR sky130_fd_sc_hd__fill_2
X_1005_ net239 net323 VGND VGND VPWR VPWR Tile_X0Y1_OpenRAM_bot.Inst_OpenRAM_bot_ConfigMem.Inst_frame1_bit25.Q
+ sky130_fd_sc_hd__dlxtp_1
XTAP_TAPCELL_ROW_177_1081 VGND VPWR sky130_fd_sc_hd__tapvpwrvgnd_1
XFILLER_173_18 VGND VGND VPWR VPWR sky130_fd_sc_hd__decap_3
XFILLER_103_113 VGND VGND VPWR VPWR sky130_fd_sc_hd__decap_3
XFILLER_106_23 VGND VGND VPWR VPWR sky130_fd_sc_hd__decap_3
XFILLER_106_56 VGND VGND VPWR VPWR sky130_fd_sc_hd__decap_3
XFILLER_66_27 VGND VGND VPWR VPWR sky130_fd_sc_hd__fill_1
XFILLER_66_38 VGND VGND VPWR VPWR sky130_fd_sc_hd__decap_3
XFILLER_122_22 VGND VGND VPWR VPWR sky130_fd_sc_hd__decap_3
XFILLER_122_11 VGND VGND VPWR VPWR sky130_fd_sc_hd__decap_3
XFILLER_17_108 VGND VGND VPWR VPWR sky130_fd_sc_hd__decap_3
XFILLER_72_203 VGND VGND VPWR VPWR sky130_fd_sc_hd__decap_3
XFILLER_174_6 VGND VGND VPWR VPWR sky130_fd_sc_hd__decap_3
XFILLER_17_119 VGND VGND VPWR VPWR sky130_fd_sc_hd__decap_3
XTAP_TAPCELL_ROW_142_939 VGND VPWR sky130_fd_sc_hd__tapvpwrvgnd_1
XFILLER_122_88 VGND VGND VPWR VPWR sky130_fd_sc_hd__decap_3
XFILLER_122_77 VGND VGND VPWR VPWR sky130_fd_sc_hd__decap_3
XFILLER_82_15 VGND VGND VPWR VPWR sky130_fd_sc_hd__decap_3
XFILLER_15_31 VGND VGND VPWR VPWR sky130_fd_sc_hd__decap_3
XFILLER_25_152 VGND VGND VPWR VPWR sky130_fd_sc_hd__decap_3
XFILLER_40_100 VGND VGND VPWR VPWR sky130_fd_sc_hd__decap_3
XTAP_TAPCELL_ROW_150_972 VGND VPWR sky130_fd_sc_hd__tapvpwrvgnd_1
XFILLER_25_196 VGND VGND VPWR VPWR sky130_fd_sc_hd__decap_3
XFILLER_15_97 VGND VGND VPWR VPWR sky130_fd_sc_hd__decap_3
XFILLER_40_177 VGND VGND VPWR VPWR sky130_fd_sc_hd__decap_3
XFILLER_31_41 VGND VGND VPWR VPWR sky130_fd_sc_hd__decap_3
XFILLER_147_52 VGND VGND VPWR VPWR sky130_fd_sc_hd__decap_3
XFILLER_147_96 VGND VGND VPWR VPWR sky130_fd_sc_hd__decap_3
XFILLER_141_208 VGND VGND VPWR VPWR sky130_fd_sc_hd__fill_2
XFILLER_163_51 VGND VGND VPWR VPWR sky130_fd_sc_hd__decap_3
XFILLER_48_200 VGND VGND VPWR VPWR sky130_fd_sc_hd__decap_3
Xinput152 Tile_X0Y0_S2END[2] VGND VGND VPWR VPWR net152 sky130_fd_sc_hd__clkbuf_2
Xinput163 Tile_X0Y0_S2MID[5] VGND VGND VPWR VPWR net163 sky130_fd_sc_hd__buf_2
Xinput130 Tile_X0Y0_FrameData[24] VGND VGND VPWR VPWR net130 sky130_fd_sc_hd__clkbuf_4
XFILLER_163_84 VGND VGND VPWR VPWR sky130_fd_sc_hd__decap_3
Xinput141 Tile_X0Y0_FrameData[5] VGND VGND VPWR VPWR net141 sky130_fd_sc_hd__clkbuf_4
XFILLER_102_190 VGND VGND VPWR VPWR sky130_fd_sc_hd__decap_3
Xinput174 Tile_X0Y1_E1END[0] VGND VGND VPWR VPWR net174 sky130_fd_sc_hd__clkbuf_2
Xinput185 Tile_X0Y1_E2END[7] VGND VGND VPWR VPWR net185 sky130_fd_sc_hd__buf_1
Xinput196 Tile_X0Y1_E6END[11] VGND VGND VPWR VPWR net196 sky130_fd_sc_hd__dlymetal6s2s_1
XFILLER_56_82 VGND VGND VPWR VPWR sky130_fd_sc_hd__fill_2
XFILLER_63_214 VGND VGND VPWR VPWR sky130_fd_sc_hd__decap_3
XFILLER_63_225 VGND VGND VPWR VPWR sky130_fd_sc_hd__decap_3
XFILLER_16_141 VGND VGND VPWR VPWR sky130_fd_sc_hd__decap_3
XFILLER_16_130 VGND VGND VPWR VPWR sky130_fd_sc_hd__decap_3
XFILLER_16_174 VGND VGND VPWR VPWR sky130_fd_sc_hd__fill_1
XFILLER_31_100 VGND VGND VPWR VPWR sky130_fd_sc_hd__decap_3
XFILLER_31_122 VGND VGND VPWR VPWR sky130_fd_sc_hd__decap_3
XFILLER_176_127 VGND VGND VPWR VPWR sky130_fd_sc_hd__decap_3
XFILLER_31_166 VGND VGND VPWR VPWR sky130_fd_sc_hd__fill_2
XFILLER_169_190 VGND VGND VPWR VPWR sky130_fd_sc_hd__decap_3
XFILLER_31_199 VGND VGND VPWR VPWR sky130_fd_sc_hd__decap_3
XFILLER_68_3 VGND VGND VPWR VPWR sky130_fd_sc_hd__fill_2
XFILLER_98_100 VGND VGND VPWR VPWR sky130_fd_sc_hd__decap_3
Xfanout319 net320 VGND VGND VPWR VPWR net319 sky130_fd_sc_hd__buf_1
Xfanout308 net311 VGND VGND VPWR VPWR net308 sky130_fd_sc_hd__clkbuf_2
X_0505_ _0142_ _0141_ Tile_X0Y0_OpenRAM_top.Inst_OpenRAM_top_ConfigMem.Inst_frame6_bit14.Q
+ VGND VGND VPWR VPWR Tile_X0Y0_OpenRAM_top.Inst_OpenRAM_top_switch_matrix.S4BEG2
+ sky130_fd_sc_hd__mux2_1
X_1485_ Tile_X0Y1_OpenRAM_bot.Inst_OpenRAM_bot_switch_matrix.W6BEG3 VGND VGND VPWR
+ VPWR net647 sky130_fd_sc_hd__clkbuf_1
X_0436_ net105 net113 net97 Tile_X0Y0_OpenRAM_top.Inst_OpenRAM_top_switch_matrix.J_NS4_BEG9
+ Tile_X0Y0_OpenRAM_top.Inst_OpenRAM_top_ConfigMem.Inst_frame2_bit6.Q Tile_X0Y0_OpenRAM_top.Inst_OpenRAM_top_ConfigMem.Inst_frame2_bit7.Q
+ VGND VGND VPWR VPWR net403 sky130_fd_sc_hd__mux4_2
.ends
