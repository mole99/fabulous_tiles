* NGSPICE file created from SimpleCLB.ext - technology: sky130A

* Black-box entry subcircuit for sky130_fd_sc_hd__decap_3 abstract view
.subckt sky130_fd_sc_hd__decap_3 VGND VNB VPB VPWR
.ends

* Black-box entry subcircuit for sky130_fd_sc_hd__tapvpwrvgnd_1 abstract view
.subckt sky130_fd_sc_hd__tapvpwrvgnd_1 VGND VPWR
.ends

* Black-box entry subcircuit for sky130_fd_sc_hd__dlxtp_1 abstract view
.subckt sky130_fd_sc_hd__dlxtp_1 D GATE VGND VNB VPB VPWR Q
.ends

* Black-box entry subcircuit for sky130_fd_sc_hd__fill_2 abstract view
.subckt sky130_fd_sc_hd__fill_2 VGND VNB VPB VPWR
.ends

* Black-box entry subcircuit for sky130_fd_sc_hd__fill_1 abstract view
.subckt sky130_fd_sc_hd__fill_1 VGND VNB VPB VPWR
.ends

* Black-box entry subcircuit for sky130_fd_sc_hd__diode_2 abstract view
.subckt sky130_fd_sc_hd__diode_2 DIODE VGND VNB VPB VPWR
.ends

* Black-box entry subcircuit for sky130_fd_sc_hd__mux4_1 abstract view
.subckt sky130_fd_sc_hd__mux4_1 A0 A1 A2 A3 S0 S1 VGND VNB VPB VPWR X
.ends

* Black-box entry subcircuit for sky130_fd_sc_hd__o221a_1 abstract view
.subckt sky130_fd_sc_hd__o221a_1 A1 A2 B1 B2 C1 VGND VNB VPB VPWR X
.ends

* Black-box entry subcircuit for sky130_fd_sc_hd__mux2_1 abstract view
.subckt sky130_fd_sc_hd__mux2_1 A0 A1 S VGND VNB VPB VPWR X
.ends

* Black-box entry subcircuit for sky130_fd_sc_hd__nand2_1 abstract view
.subckt sky130_fd_sc_hd__nand2_1 A B VGND VNB VPB VPWR Y
.ends

* Black-box entry subcircuit for sky130_fd_sc_hd__buf_4 abstract view
.subckt sky130_fd_sc_hd__buf_4 A VGND VNB VPB VPWR X
.ends

* Black-box entry subcircuit for sky130_fd_sc_hd__clkbuf_2 abstract view
.subckt sky130_fd_sc_hd__clkbuf_2 A VGND VNB VPB VPWR X
.ends

* Black-box entry subcircuit for sky130_fd_sc_hd__buf_2 abstract view
.subckt sky130_fd_sc_hd__buf_2 A VGND VNB VPB VPWR X
.ends

* Black-box entry subcircuit for sky130_fd_sc_hd__clkbuf_1 abstract view
.subckt sky130_fd_sc_hd__clkbuf_1 A VGND VNB VPB VPWR X
.ends

* Black-box entry subcircuit for sky130_fd_sc_hd__inv_1 abstract view
.subckt sky130_fd_sc_hd__inv_1 A VGND VNB VPB VPWR Y
.ends

* Black-box entry subcircuit for sky130_fd_sc_hd__o2bb2a_4 abstract view
.subckt sky130_fd_sc_hd__o2bb2a_4 A1_N A2_N B1 B2 VGND VNB VPB VPWR X
.ends

* Black-box entry subcircuit for sky130_fd_sc_hd__mux2_4 abstract view
.subckt sky130_fd_sc_hd__mux2_4 A0 A1 S VGND VNB VPB VPWR X
.ends

* Black-box entry subcircuit for sky130_fd_sc_hd__buf_1 abstract view
.subckt sky130_fd_sc_hd__buf_1 A VGND VNB VPB VPWR X
.ends

* Black-box entry subcircuit for sky130_fd_sc_hd__or3_1 abstract view
.subckt sky130_fd_sc_hd__or3_1 A B C VGND VNB VPB VPWR X
.ends

* Black-box entry subcircuit for sky130_fd_sc_hd__buf_6 abstract view
.subckt sky130_fd_sc_hd__buf_6 A VGND VNB VPB VPWR X
.ends

* Black-box entry subcircuit for sky130_fd_sc_hd__o22a_1 abstract view
.subckt sky130_fd_sc_hd__o22a_1 A1 A2 B1 B2 VGND VNB VPB VPWR X
.ends

* Black-box entry subcircuit for sky130_fd_sc_hd__mux4_2 abstract view
.subckt sky130_fd_sc_hd__mux4_2 A0 A1 A2 A3 S0 S1 VGND VNB VPB VPWR X
.ends

* Black-box entry subcircuit for sky130_fd_sc_hd__buf_8 abstract view
.subckt sky130_fd_sc_hd__buf_8 A VGND VNB VPB VPWR X
.ends

* Black-box entry subcircuit for sky130_fd_sc_hd__nor2_1 abstract view
.subckt sky130_fd_sc_hd__nor2_1 A B VGND VNB VPB VPWR Y
.ends

* Black-box entry subcircuit for sky130_fd_sc_hd__o21a_1 abstract view
.subckt sky130_fd_sc_hd__o21a_1 A1 A2 B1 VGND VNB VPB VPWR X
.ends

* Black-box entry subcircuit for sky130_fd_sc_hd__a22o_1 abstract view
.subckt sky130_fd_sc_hd__a22o_1 A1 A2 B1 B2 VGND VNB VPB VPWR X
.ends

* Black-box entry subcircuit for sky130_fd_sc_hd__a31o_1 abstract view
.subckt sky130_fd_sc_hd__a31o_1 A1 A2 A3 B1 VGND VNB VPB VPWR X
.ends

* Black-box entry subcircuit for sky130_fd_sc_hd__and2_4 abstract view
.subckt sky130_fd_sc_hd__and2_4 A B VGND VNB VPB VPWR X
.ends

* Black-box entry subcircuit for sky130_fd_sc_hd__o211a_1 abstract view
.subckt sky130_fd_sc_hd__o211a_1 A1 A2 B1 C1 VGND VNB VPB VPWR X
.ends

* Black-box entry subcircuit for sky130_fd_sc_hd__clkbuf_4 abstract view
.subckt sky130_fd_sc_hd__clkbuf_4 A VGND VNB VPB VPWR X
.ends

* Black-box entry subcircuit for sky130_fd_sc_hd__or2_1 abstract view
.subckt sky130_fd_sc_hd__or2_1 A B VGND VNB VPB VPWR X
.ends

* Black-box entry subcircuit for sky130_fd_sc_hd__o22a_2 abstract view
.subckt sky130_fd_sc_hd__o22a_2 A1 A2 B1 B2 VGND VNB VPB VPWR X
.ends

* Black-box entry subcircuit for sky130_fd_sc_hd__a21oi_1 abstract view
.subckt sky130_fd_sc_hd__a21oi_1 A1 A2 B1 VGND VNB VPB VPWR Y
.ends

* Black-box entry subcircuit for sky130_fd_sc_hd__nor2_4 abstract view
.subckt sky130_fd_sc_hd__nor2_4 A B VGND VNB VPB VPWR Y
.ends

* Black-box entry subcircuit for sky130_fd_sc_hd__dlygate4sd3_1 abstract view
.subckt sky130_fd_sc_hd__dlygate4sd3_1 A VGND VNB VPB VPWR X
.ends

* Black-box entry subcircuit for sky130_fd_sc_hd__o21ai_1 abstract view
.subckt sky130_fd_sc_hd__o21ai_1 A1 A2 B1 VGND VNB VPB VPWR Y
.ends

* Black-box entry subcircuit for sky130_fd_sc_hd__o22a_4 abstract view
.subckt sky130_fd_sc_hd__o22a_4 A1 A2 B1 B2 VGND VNB VPB VPWR X
.ends

* Black-box entry subcircuit for sky130_fd_sc_hd__a2bb2o_4 abstract view
.subckt sky130_fd_sc_hd__a2bb2o_4 A1_N A2_N B1 B2 VGND VNB VPB VPWR X
.ends

* Black-box entry subcircuit for sky130_fd_sc_hd__a21boi_1 abstract view
.subckt sky130_fd_sc_hd__a21boi_1 A1 A2 B1_N VGND VNB VPB VPWR Y
.ends

* Black-box entry subcircuit for sky130_fd_sc_hd__inv_2 abstract view
.subckt sky130_fd_sc_hd__inv_2 A VGND VNB VPB VPWR Y
.ends

* Black-box entry subcircuit for sky130_fd_sc_hd__and2_1 abstract view
.subckt sky130_fd_sc_hd__and2_1 A B VGND VNB VPB VPWR X
.ends

* Black-box entry subcircuit for sky130_fd_sc_hd__nand2b_1 abstract view
.subckt sky130_fd_sc_hd__nand2b_1 A_N B VGND VNB VPB VPWR Y
.ends

* Black-box entry subcircuit for sky130_fd_sc_hd__dlymetal6s2s_1 abstract view
.subckt sky130_fd_sc_hd__dlymetal6s2s_1 A VGND VNB VPB VPWR X
.ends

* Black-box entry subcircuit for sky130_fd_sc_hd__a21boi_2 abstract view
.subckt sky130_fd_sc_hd__a21boi_2 A1 A2 B1_N VGND VNB VPB VPWR Y
.ends

* Black-box entry subcircuit for sky130_fd_sc_hd__o32a_4 abstract view
.subckt sky130_fd_sc_hd__o32a_4 A1 A2 A3 B1 B2 VGND VNB VPB VPWR X
.ends

* Black-box entry subcircuit for sky130_fd_sc_hd__a311oi_4 abstract view
.subckt sky130_fd_sc_hd__a311oi_4 A1 A2 A3 B1 C1 VGND VNB VPB VPWR Y
.ends

* Black-box entry subcircuit for sky130_fd_sc_hd__a211o_1 abstract view
.subckt sky130_fd_sc_hd__a211o_1 A1 A2 B1 C1 VGND VNB VPB VPWR X
.ends

* Black-box entry subcircuit for sky130_fd_sc_hd__a21bo_1 abstract view
.subckt sky130_fd_sc_hd__a21bo_1 A1 A2 B1_N VGND VNB VPB VPWR X
.ends

* Black-box entry subcircuit for sky130_fd_sc_hd__a32o_1 abstract view
.subckt sky130_fd_sc_hd__a32o_1 A1 A2 A3 B1 B2 VGND VNB VPB VPWR X
.ends

* Black-box entry subcircuit for sky130_fd_sc_hd__nand2b_4 abstract view
.subckt sky130_fd_sc_hd__nand2b_4 A_N B VGND VNB VPB VPWR Y
.ends

* Black-box entry subcircuit for sky130_fd_sc_hd__o221ai_1 abstract view
.subckt sky130_fd_sc_hd__o221ai_1 A1 A2 B1 B2 C1 VGND VNB VPB VPWR Y
.ends

* Black-box entry subcircuit for sky130_fd_sc_hd__o2bb2a_1 abstract view
.subckt sky130_fd_sc_hd__o2bb2a_1 A1_N A2_N B1 B2 VGND VNB VPB VPWR X
.ends

* Black-box entry subcircuit for sky130_fd_sc_hd__and2b_1 abstract view
.subckt sky130_fd_sc_hd__and2b_1 A_N B VGND VNB VPB VPWR X
.ends

* Black-box entry subcircuit for sky130_fd_sc_hd__a22o_4 abstract view
.subckt sky130_fd_sc_hd__a22o_4 A1 A2 B1 B2 VGND VNB VPB VPWR X
.ends

* Black-box entry subcircuit for sky130_fd_sc_hd__a311o_1 abstract view
.subckt sky130_fd_sc_hd__a311o_1 A1 A2 A3 B1 C1 VGND VNB VPB VPWR X
.ends

* Black-box entry subcircuit for sky130_fd_sc_hd__nand2_2 abstract view
.subckt sky130_fd_sc_hd__nand2_2 A B VGND VNB VPB VPWR Y
.ends

* Black-box entry subcircuit for sky130_fd_sc_hd__or2_4 abstract view
.subckt sky130_fd_sc_hd__or2_4 A B VGND VNB VPB VPWR X
.ends

* Black-box entry subcircuit for sky130_fd_sc_hd__dfxtp_1 abstract view
.subckt sky130_fd_sc_hd__dfxtp_1 CLK D VGND VNB VPB VPWR Q
.ends

* Black-box entry subcircuit for sky130_fd_sc_hd__a211oi_1 abstract view
.subckt sky130_fd_sc_hd__a211oi_1 A1 A2 B1 C1 VGND VNB VPB VPWR Y
.ends

* Black-box entry subcircuit for sky130_fd_sc_hd__o21ai_4 abstract view
.subckt sky130_fd_sc_hd__o21ai_4 A1 A2 B1 VGND VNB VPB VPWR Y
.ends

* Black-box entry subcircuit for sky130_fd_sc_hd__clkbuf_16 abstract view
.subckt sky130_fd_sc_hd__clkbuf_16 A VGND VNB VPB VPWR X
.ends

* Black-box entry subcircuit for sky130_fd_sc_hd__o21ba_1 abstract view
.subckt sky130_fd_sc_hd__o21ba_1 A1 A2 B1_N VGND VNB VPB VPWR X
.ends

* Black-box entry subcircuit for sky130_fd_sc_hd__o211ai_4 abstract view
.subckt sky130_fd_sc_hd__o211ai_4 A1 A2 B1 C1 VGND VNB VPB VPWR Y
.ends

* Black-box entry subcircuit for sky130_fd_sc_hd__or3b_1 abstract view
.subckt sky130_fd_sc_hd__or3b_1 A B C_N VGND VNB VPB VPWR X
.ends

* Black-box entry subcircuit for sky130_fd_sc_hd__and3_1 abstract view
.subckt sky130_fd_sc_hd__and3_1 A B C VGND VNB VPB VPWR X
.ends

* Black-box entry subcircuit for sky130_fd_sc_hd__or3_4 abstract view
.subckt sky130_fd_sc_hd__or3_4 A B C VGND VNB VPB VPWR X
.ends

* Black-box entry subcircuit for sky130_fd_sc_hd__nor2_8 abstract view
.subckt sky130_fd_sc_hd__nor2_8 A B VGND VNB VPB VPWR Y
.ends

* Black-box entry subcircuit for sky130_fd_sc_hd__clkbuf_8 abstract view
.subckt sky130_fd_sc_hd__clkbuf_8 A VGND VNB VPB VPWR X
.ends

* Black-box entry subcircuit for sky130_fd_sc_hd__nand2_8 abstract view
.subckt sky130_fd_sc_hd__nand2_8 A B VGND VNB VPB VPWR Y
.ends

* Black-box entry subcircuit for sky130_fd_sc_hd__o21a_4 abstract view
.subckt sky130_fd_sc_hd__o21a_4 A1 A2 B1 VGND VNB VPB VPWR X
.ends

* Black-box entry subcircuit for sky130_fd_sc_hd__nand2_4 abstract view
.subckt sky130_fd_sc_hd__nand2_4 A B VGND VNB VPB VPWR Y
.ends

* Black-box entry subcircuit for sky130_fd_sc_hd__a21oi_2 abstract view
.subckt sky130_fd_sc_hd__a21oi_2 A1 A2 B1 VGND VNB VPB VPWR Y
.ends

* Black-box entry subcircuit for sky130_fd_sc_hd__o311a_4 abstract view
.subckt sky130_fd_sc_hd__o311a_4 A1 A2 A3 B1 C1 VGND VNB VPB VPWR X
.ends

* Black-box entry subcircuit for sky130_fd_sc_hd__a21o_1 abstract view
.subckt sky130_fd_sc_hd__a21o_1 A1 A2 B1 VGND VNB VPB VPWR X
.ends

* Black-box entry subcircuit for sky130_fd_sc_hd__o21ai_2 abstract view
.subckt sky130_fd_sc_hd__o21ai_2 A1 A2 B1 VGND VNB VPB VPWR Y
.ends

* Black-box entry subcircuit for sky130_fd_sc_hd__dlygate4sd1_1 abstract view
.subckt sky130_fd_sc_hd__dlygate4sd1_1 A VGND VNB VPB VPWR X
.ends

* Black-box entry subcircuit for sky130_fd_sc_hd__or2_2 abstract view
.subckt sky130_fd_sc_hd__or2_2 A B VGND VNB VPB VPWR X
.ends

* Black-box entry subcircuit for sky130_fd_sc_hd__mux2_2 abstract view
.subckt sky130_fd_sc_hd__mux2_2 A0 A1 S VGND VNB VPB VPWR X
.ends

* Black-box entry subcircuit for sky130_fd_sc_hd__a221o_1 abstract view
.subckt sky130_fd_sc_hd__a221o_1 A1 A2 B1 B2 C1 VGND VNB VPB VPWR X
.ends

* Black-box entry subcircuit for sky130_fd_sc_hd__a31o_4 abstract view
.subckt sky130_fd_sc_hd__a31o_4 A1 A2 A3 B1 VGND VNB VPB VPWR X
.ends

.subckt SimpleCLB Ci Co E1BEG[0] E1BEG[1] E1BEG[2] E1BEG[3] E1END[0] E1END[1] E1END[2]
+ E1END[3] E2BEG[0] E2BEG[1] E2BEG[2] E2BEG[3] E2BEG[4] E2BEG[5] E2BEG[6] E2BEG[7]
+ E2BEGb[0] E2BEGb[1] E2BEGb[2] E2BEGb[3] E2BEGb[4] E2BEGb[5] E2BEGb[6] E2BEGb[7]
+ E2END[0] E2END[1] E2END[2] E2END[3] E2END[4] E2END[5] E2END[6] E2END[7] E2MID[0]
+ E2MID[1] E2MID[2] E2MID[3] E2MID[4] E2MID[5] E2MID[6] E2MID[7] E6BEG[0] E6BEG[10]
+ E6BEG[11] E6BEG[1] E6BEG[2] E6BEG[3] E6BEG[4] E6BEG[5] E6BEG[6] E6BEG[7] E6BEG[8]
+ E6BEG[9] E6END[0] E6END[10] E6END[11] E6END[1] E6END[2] E6END[3] E6END[4] E6END[5]
+ E6END[6] E6END[7] E6END[8] E6END[9] EE4BEG[0] EE4BEG[10] EE4BEG[11] EE4BEG[12] EE4BEG[13]
+ EE4BEG[14] EE4BEG[15] EE4BEG[1] EE4BEG[2] EE4BEG[3] EE4BEG[4] EE4BEG[5] EE4BEG[6]
+ EE4BEG[7] EE4BEG[8] EE4BEG[9] EE4END[0] EE4END[10] EE4END[11] EE4END[12] EE4END[13]
+ EE4END[14] EE4END[15] EE4END[1] EE4END[2] EE4END[3] EE4END[4] EE4END[5] EE4END[6]
+ EE4END[7] EE4END[8] EE4END[9] FrameData[0] FrameData[10] FrameData[11] FrameData[12]
+ FrameData[13] FrameData[14] FrameData[15] FrameData[16] FrameData[17] FrameData[18]
+ FrameData[19] FrameData[1] FrameData[20] FrameData[21] FrameData[22] FrameData[23]
+ FrameData[24] FrameData[25] FrameData[26] FrameData[27] FrameData[28] FrameData[29]
+ FrameData[2] FrameData[30] FrameData[31] FrameData[3] FrameData[4] FrameData[5]
+ FrameData[6] FrameData[7] FrameData[8] FrameData[9] FrameData_O[0] FrameData_O[10]
+ FrameData_O[11] FrameData_O[12] FrameData_O[13] FrameData_O[14] FrameData_O[15]
+ FrameData_O[16] FrameData_O[17] FrameData_O[18] FrameData_O[19] FrameData_O[1] FrameData_O[20]
+ FrameData_O[21] FrameData_O[22] FrameData_O[23] FrameData_O[24] FrameData_O[25]
+ FrameData_O[26] FrameData_O[27] FrameData_O[28] FrameData_O[29] FrameData_O[2] FrameData_O[30]
+ FrameData_O[31] FrameData_O[3] FrameData_O[4] FrameData_O[5] FrameData_O[6] FrameData_O[7]
+ FrameData_O[8] FrameData_O[9] FrameStrobe[0] FrameStrobe[10] FrameStrobe[11] FrameStrobe[12]
+ FrameStrobe[13] FrameStrobe[14] FrameStrobe[15] FrameStrobe[16] FrameStrobe[17]
+ FrameStrobe[18] FrameStrobe[19] FrameStrobe[1] FrameStrobe[2] FrameStrobe[3] FrameStrobe[4]
+ FrameStrobe[5] FrameStrobe[6] FrameStrobe[7] FrameStrobe[8] FrameStrobe[9] FrameStrobe_O[0]
+ FrameStrobe_O[10] FrameStrobe_O[11] FrameStrobe_O[12] FrameStrobe_O[13] FrameStrobe_O[14]
+ FrameStrobe_O[15] FrameStrobe_O[16] FrameStrobe_O[17] FrameStrobe_O[18] FrameStrobe_O[19]
+ FrameStrobe_O[1] FrameStrobe_O[2] FrameStrobe_O[3] FrameStrobe_O[4] FrameStrobe_O[5]
+ FrameStrobe_O[6] FrameStrobe_O[7] FrameStrobe_O[8] FrameStrobe_O[9] N1BEG[0] N1BEG[1]
+ N1BEG[2] N1BEG[3] N1END[0] N1END[1] N1END[2] N1END[3] N2BEG[0] N2BEG[1] N2BEG[2]
+ N2BEG[3] N2BEG[4] N2BEG[5] N2BEG[6] N2BEG[7] N2BEGb[0] N2BEGb[1] N2BEGb[2] N2BEGb[3]
+ N2BEGb[4] N2BEGb[5] N2BEGb[6] N2BEGb[7] N2END[0] N2END[1] N2END[2] N2END[3] N2END[4]
+ N2END[5] N2END[6] N2END[7] N2MID[0] N2MID[1] N2MID[2] N2MID[3] N2MID[4] N2MID[5]
+ N2MID[6] N2MID[7] N4BEG[0] N4BEG[10] N4BEG[11] N4BEG[12] N4BEG[13] N4BEG[14] N4BEG[15]
+ N4BEG[1] N4BEG[2] N4BEG[3] N4BEG[4] N4BEG[5] N4BEG[6] N4BEG[7] N4BEG[8] N4BEG[9]
+ N4END[0] N4END[10] N4END[11] N4END[12] N4END[13] N4END[14] N4END[15] N4END[1] N4END[2]
+ N4END[3] N4END[4] N4END[5] N4END[6] N4END[7] N4END[8] N4END[9] NN4BEG[0] NN4BEG[10]
+ NN4BEG[11] NN4BEG[12] NN4BEG[13] NN4BEG[14] NN4BEG[15] NN4BEG[1] NN4BEG[2] NN4BEG[3]
+ NN4BEG[4] NN4BEG[5] NN4BEG[6] NN4BEG[7] NN4BEG[8] NN4BEG[9] NN4END[0] NN4END[10]
+ NN4END[11] NN4END[12] NN4END[13] NN4END[14] NN4END[15] NN4END[1] NN4END[2] NN4END[3]
+ NN4END[4] NN4END[5] NN4END[6] NN4END[7] NN4END[8] NN4END[9] S1BEG[0] S1BEG[1] S1BEG[2]
+ S1BEG[3] S1END[0] S1END[1] S1END[2] S1END[3] S2BEG[0] S2BEG[1] S2BEG[2] S2BEG[3]
+ S2BEG[4] S2BEG[5] S2BEG[6] S2BEG[7] S2BEGb[0] S2BEGb[1] S2BEGb[2] S2BEGb[3] S2BEGb[4]
+ S2BEGb[5] S2BEGb[6] S2BEGb[7] S2END[0] S2END[1] S2END[2] S2END[3] S2END[4] S2END[5]
+ S2END[6] S2END[7] S2MID[0] S2MID[1] S2MID[2] S2MID[3] S2MID[4] S2MID[5] S2MID[6]
+ S2MID[7] S4BEG[0] S4BEG[10] S4BEG[11] S4BEG[12] S4BEG[13] S4BEG[14] S4BEG[15] S4BEG[1]
+ S4BEG[2] S4BEG[3] S4BEG[4] S4BEG[5] S4BEG[6] S4BEG[7] S4BEG[8] S4BEG[9] S4END[0]
+ S4END[10] S4END[11] S4END[12] S4END[13] S4END[14] S4END[15] S4END[1] S4END[2] S4END[3]
+ S4END[4] S4END[5] S4END[6] S4END[7] S4END[8] S4END[9] SS4BEG[0] SS4BEG[10] SS4BEG[11]
+ SS4BEG[12] SS4BEG[13] SS4BEG[14] SS4BEG[15] SS4BEG[1] SS4BEG[2] SS4BEG[3] SS4BEG[4]
+ SS4BEG[5] SS4BEG[6] SS4BEG[7] SS4BEG[8] SS4BEG[9] SS4END[0] SS4END[10] SS4END[11]
+ SS4END[12] SS4END[13] SS4END[14] SS4END[15] SS4END[1] SS4END[2] SS4END[3] SS4END[4]
+ SS4END[5] SS4END[6] SS4END[7] SS4END[8] SS4END[9] UserCLK UserCLKo VGND VPWR W1BEG[0]
+ W1BEG[1] W1BEG[2] W1BEG[3] W1END[0] W1END[1] W1END[2] W1END[3] W2BEG[0] W2BEG[1]
+ W2BEG[2] W2BEG[3] W2BEG[4] W2BEG[5] W2BEG[6] W2BEG[7] W2BEGb[0] W2BEGb[1] W2BEGb[2]
+ W2BEGb[3] W2BEGb[4] W2BEGb[5] W2BEGb[6] W2BEGb[7] W2END[0] W2END[1] W2END[2] W2END[3]
+ W2END[4] W2END[5] W2END[6] W2END[7] W2MID[0] W2MID[1] W2MID[2] W2MID[3] W2MID[4]
+ W2MID[5] W2MID[6] W2MID[7] W6BEG[0] W6BEG[10] W6BEG[11] W6BEG[1] W6BEG[2] W6BEG[3]
+ W6BEG[4] W6BEG[5] W6BEG[6] W6BEG[7] W6BEG[8] W6BEG[9] W6END[0] W6END[10] W6END[11]
+ W6END[1] W6END[2] W6END[3] W6END[4] W6END[5] W6END[6] W6END[7] W6END[8] W6END[9]
+ WW4BEG[0] WW4BEG[10] WW4BEG[11] WW4BEG[12] WW4BEG[13] WW4BEG[14] WW4BEG[15] WW4BEG[1]
+ WW4BEG[2] WW4BEG[3] WW4BEG[4] WW4BEG[5] WW4BEG[6] WW4BEG[7] WW4BEG[8] WW4BEG[9]
+ WW4END[0] WW4END[10] WW4END[11] WW4END[12] WW4END[13] WW4END[14] WW4END[15] WW4END[1]
+ WW4END[2] WW4END[3] WW4END[4] WW4END[5] WW4END[6] WW4END[7] WW4END[8] WW4END[9]
XFILLER_54_203 VGND VGND VPWR VPWR sky130_fd_sc_hd__decap_3
XTAP_TAPCELL_ROW_37_412 VGND VPWR sky130_fd_sc_hd__tapvpwrvgnd_1
XFILLER_54_236 VGND VGND VPWR VPWR sky130_fd_sc_hd__decap_3
X_2106_ net770 net690 VGND VGND VPWR VPWR Inst_SimpleCLB_ConfigMem.Inst_frame1_bit21.Q
+ sky130_fd_sc_hd__dlxtp_1
XFILLER_54_269 VGND VGND VPWR VPWR sky130_fd_sc_hd__decap_3
X_2037_ net784 net682 VGND VGND VPWR VPWR Inst_SimpleCLB_ConfigMem.Inst_frame3_bit16.Q
+ sky130_fd_sc_hd__dlxtp_1
XFILLER_10_306 VGND VGND VPWR VPWR sky130_fd_sc_hd__fill_2
XTAP_TAPCELL_ROW_20_312 VGND VPWR sky130_fd_sc_hd__tapvpwrvgnd_1
XFILLER_77_37 VGND VGND VPWR VPWR sky130_fd_sc_hd__fill_1
XFILLER_45_203 VGND VGND VPWR VPWR sky130_fd_sc_hd__decap_3
XFILLER_45_225 VGND VGND VPWR VPWR sky130_fd_sc_hd__decap_3
XANTENNA_224 _0142_ VGND VGND VPWR VPWR sky130_fd_sc_hd__diode_2
XANTENNA_202 SS4END[2] VGND VGND VPWR VPWR sky130_fd_sc_hd__diode_2
XANTENNA_213 net791 VGND VGND VPWR VPWR sky130_fd_sc_hd__diode_2
XFILLER_60_206 VGND VGND VPWR VPWR sky130_fd_sc_hd__decap_3
XFILLER_26_85 VGND VGND VPWR VPWR sky130_fd_sc_hd__decap_3
XTAP_TAPCELL_ROW_43_448 VGND VPWR sky130_fd_sc_hd__tapvpwrvgnd_1
XFILLER_13_144 VGND VGND VPWR VPWR sky130_fd_sc_hd__decap_3
X_1270_ S1END[0] W1END[0] S2END[0] net647 Inst_SimpleCLB_ConfigMem.Inst_frame2_bit23.Q
+ Inst_SimpleCLB_ConfigMem.Inst_frame2_bit22.Q VGND VGND VPWR VPWR _0351_ sky130_fd_sc_hd__mux4_1
XFILLER_44_280 VGND VGND VPWR VPWR sky130_fd_sc_hd__decap_3
X_0985_ Inst_LC_LUT4c_frame_config_dffesr.inst_cus_mux161_buf.A0 _0056_ _0057_ Inst_LC_LUT4c_frame_config_dffesr.inst_cus_mux161_buf.A6
+ _0082_ VGND VGND VPWR VPWR _0083_ sky130_fd_sc_hd__o221a_1
XFILLER_8_170 VGND VGND VPWR VPWR sky130_fd_sc_hd__fill_1
X_1606_ net777 net702 VGND VGND VPWR VPWR Inst_LD_LUT4c_frame_config_dffesr.inst_cus_mux161_buf.A6
+ sky130_fd_sc_hd__dlxtp_1
XFILLER_59_328 VGND VGND VPWR VPWR sky130_fd_sc_hd__fill_1
X_1537_ Inst_LF_LUT4c_frame_config_dffesr.c_reset_value _0198_ _0560_ VGND VGND VPWR
+ VPWR _0561_ sky130_fd_sc_hd__mux2_1
X_1468_ net612 _0126_ Inst_SimpleCLB_switch_matrix.JS2BEG0 _0142_ Inst_SimpleCLB_ConfigMem.Inst_frame11_bit16.Q
+ Inst_SimpleCLB_ConfigMem.Inst_frame11_bit17.Q VGND VGND VPWR VPWR Inst_SimpleCLB_switch_matrix.W1BEG1
+ sky130_fd_sc_hd__mux4_1
XFILLER_47_18 VGND VGND VPWR VPWR sky130_fd_sc_hd__decap_3
X_1399_ Inst_SimpleCLB_ConfigMem.Inst_frame12_bit11.Q _0462_ VGND VGND VPWR VPWR _0463_
+ sky130_fd_sc_hd__nand2_1
XFILLER_27_225 VGND VGND VPWR VPWR sky130_fd_sc_hd__decap_3
XFILLER_27_258 VGND VGND VPWR VPWR sky130_fd_sc_hd__decap_3
XFILLER_63_39 VGND VGND VPWR VPWR sky130_fd_sc_hd__decap_3
XFILLER_50_250 VGND VGND VPWR VPWR sky130_fd_sc_hd__fill_2
XTAP_TAPCELL_ROW_40_429 VGND VPWR sky130_fd_sc_hd__tapvpwrvgnd_1
XFILLER_10_147 VGND VGND VPWR VPWR sky130_fd_sc_hd__decap_3
XFILLER_10_136 VGND VGND VPWR VPWR sky130_fd_sc_hd__decap_3
XFILLER_10_169 VGND VGND VPWR VPWR sky130_fd_sc_hd__decap_3
XFILLER_2_346 VGND VGND VPWR VPWR sky130_fd_sc_hd__fill_1
Xfanout650 N1END[2] VGND VGND VPWR VPWR net650 sky130_fd_sc_hd__buf_4
Xfanout683 net684 VGND VGND VPWR VPWR net683 sky130_fd_sc_hd__clkbuf_2
Xfanout694 net696 VGND VGND VPWR VPWR net694 sky130_fd_sc_hd__clkbuf_2
Xfanout661 net662 VGND VGND VPWR VPWR net661 sky130_fd_sc_hd__clkbuf_2
Xfanout672 FrameStrobe[5] VGND VGND VPWR VPWR net672 sky130_fd_sc_hd__buf_2
XFILLER_37_84 VGND VGND VPWR VPWR sky130_fd_sc_hd__decap_3
XFILLER_26_291 VGND VGND VPWR VPWR sky130_fd_sc_hd__decap_3
XFILLER_33_228 VGND VGND VPWR VPWR sky130_fd_sc_hd__decap_3
X_0770_ E2END[4] S2END[4] net801 W2END[4] Inst_SimpleCLB_ConfigMem.Inst_frame3_bit7.Q
+ Inst_SimpleCLB_ConfigMem.Inst_frame3_bit6.Q VGND VGND VPWR VPWR _0606_ sky130_fd_sc_hd__mux4_1
XFILLER_5_162 VGND VGND VPWR VPWR sky130_fd_sc_hd__decap_3
XFILLER_5_184 VGND VGND VPWR VPWR sky130_fd_sc_hd__decap_3
X_2371_ Inst_SimpleCLB_switch_matrix.JW2BEG5 VGND VGND VPWR VPWR net216 sky130_fd_sc_hd__clkbuf_1
XFILLER_68_114 VGND VGND VPWR VPWR sky130_fd_sc_hd__decap_3
X_1322_ net629 net619 Inst_SimpleCLB_ConfigMem.Inst_frame10_bit2.Q VGND VGND VPWR
+ VPWR _0396_ sky130_fd_sc_hd__mux2_1
XFILLER_78_91 VGND VGND VPWR VPWR sky130_fd_sc_hd__decap_3
X_1253_ net654 E1END[0] NN4END[0] E2END[0] Inst_SimpleCLB_ConfigMem.Inst_frame1_bit23.Q
+ Inst_SimpleCLB_ConfigMem.Inst_frame1_bit22.Q VGND VGND VPWR VPWR _0336_ sky130_fd_sc_hd__mux4_1
XTAP_TAPCELL_ROW_79_665 VGND VPWR sky130_fd_sc_hd__tapvpwrvgnd_1
X_1184_ _0270_ _0269_ Inst_SimpleCLB_ConfigMem.Inst_frame1_bit20.Q VGND VGND VPWR
+ VPWR _0271_ sky130_fd_sc_hd__mux2_1
XFILLER_76_191 VGND VGND VPWR VPWR sky130_fd_sc_hd__decap_3
XFILLER_24_217 VGND VGND VPWR VPWR sky130_fd_sc_hd__fill_1
XTAP_TAPCELL_ROW_62_565 VGND VPWR sky130_fd_sc_hd__tapvpwrvgnd_1
X_0968_ N4END[0] W6END[0] SS4END[0] Inst_SimpleCLB_switch_matrix.JW2BEG2 Inst_SimpleCLB_ConfigMem.Inst_frame0_bit9.Q
+ Inst_SimpleCLB_ConfigMem.Inst_frame0_bit8.Q VGND VGND VPWR VPWR _0067_ sky130_fd_sc_hd__mux4_1
X_0899_ N2MID[7] E2MID[7] S2MID[7] W2MID[7] Inst_SimpleCLB_ConfigMem.Inst_frame6_bit2.Q
+ Inst_SimpleCLB_ConfigMem.Inst_frame6_bit3.Q VGND VGND VPWR VPWR _0724_ sky130_fd_sc_hd__mux4_1
Xoutput220 net220 VGND VGND VPWR VPWR W2BEGb[1] sky130_fd_sc_hd__buf_2
Xoutput242 net242 VGND VGND VPWR VPWR WW4BEG[12] sky130_fd_sc_hd__buf_4
Xoutput253 net253 VGND VGND VPWR VPWR WW4BEG[8] sky130_fd_sc_hd__buf_2
Xoutput231 net231 VGND VGND VPWR VPWR W6BEG[2] sky130_fd_sc_hd__buf_2
XFILLER_82_194 VGND VGND VPWR VPWR sky130_fd_sc_hd__fill_2
XTAP_TAPCELL_ROW_53_510 VGND VPWR sky130_fd_sc_hd__tapvpwrvgnd_1
XFILLER_23_250 VGND VGND VPWR VPWR sky130_fd_sc_hd__decap_3
XFILLER_0_24 VGND VGND VPWR VPWR sky130_fd_sc_hd__decap_3
XFILLER_46_320 VGND VGND VPWR VPWR sky130_fd_sc_hd__fill_1
XTAP_TAPCELL_ROW_76_646 VGND VPWR sky130_fd_sc_hd__tapvpwrvgnd_1
XFILLER_0_79 VGND VGND VPWR VPWR sky130_fd_sc_hd__decap_3
XTAP_TAPCELL_ROW_16_289 VGND VPWR sky130_fd_sc_hd__tapvpwrvgnd_1
XFILLER_9_33 VGND VGND VPWR VPWR sky130_fd_sc_hd__decap_3
X_1940_ net787 net668 VGND VGND VPWR VPWR Inst_SimpleCLB_ConfigMem.Inst_frame6_bit15.Q
+ sky130_fd_sc_hd__dlxtp_1
X_1871_ net796 net661 VGND VGND VPWR VPWR Inst_SimpleCLB_ConfigMem.Inst_frame8_bit10.Q
+ sky130_fd_sc_hd__dlxtp_1
X_0822_ net801 S4END[2] SS4END[2] W2END[2] Inst_SimpleCLB_ConfigMem.Inst_frame3_bit30.Q
+ Inst_SimpleCLB_ConfigMem.Inst_frame3_bit31.Q VGND VGND VPWR VPWR _0654_ sky130_fd_sc_hd__mux4_1
XFILLER_80_81 VGND VGND VPWR VPWR sky130_fd_sc_hd__decap_3
X_0753_ Inst_SimpleCLB_ConfigMem.Inst_frame3_bit29.Q VGND VGND VPWR VPWR _0589_ sky130_fd_sc_hd__inv_1
XFILLER_50_3 VGND VGND VPWR VPWR sky130_fd_sc_hd__decap_3
X_2354_ SS4END[13] VGND VGND VPWR VPWR net205 sky130_fd_sc_hd__clkbuf_2
X_1305_ W6END[1] net627 net637 net616 Inst_SimpleCLB_ConfigMem.Inst_frame5_bit27.Q
+ Inst_SimpleCLB_ConfigMem.Inst_frame5_bit26.Q VGND VGND VPWR VPWR _0381_ sky130_fd_sc_hd__mux4_1
X_2285_ N4END[12] VGND VGND VPWR VPWR net136 sky130_fd_sc_hd__clkbuf_1
XFILLER_56_117 VGND VGND VPWR VPWR sky130_fd_sc_hd__decap_3
X_1236_ _0162_ Inst_LD_LUT4c_frame_config_dffesr.c_I0mux _0316_ _0319_ VGND VGND VPWR
+ VPWR _0320_ sky130_fd_sc_hd__o2bb2a_4
XFILLER_56_139 VGND VGND VPWR VPWR sky130_fd_sc_hd__fill_1
X_1167_ _0249_ _0251_ _0254_ Inst_SimpleCLB_ConfigMem.Inst_frame3_bit21.Q VGND VGND
+ VPWR VPWR Inst_SimpleCLB_switch_matrix.E2BEG6 sky130_fd_sc_hd__o2bb2a_4
XFILLER_52_312 VGND VGND VPWR VPWR sky130_fd_sc_hd__decap_3
XFILLER_12_209 VGND VGND VPWR VPWR sky130_fd_sc_hd__decap_3
X_1098_ Inst_LF_LUT4c_frame_config_dffesr.inst_cus_mux161_buf.A15 _0171_ _0173_ Inst_LF_LUT4c_frame_config_dffesr.inst_cus_mux161_buf.A13
+ _0189_ VGND VGND VPWR VPWR _0190_ sky130_fd_sc_hd__o221a_1
XFILLER_60_18 VGND VGND VPWR VPWR sky130_fd_sc_hd__decap_3
XFILLER_20_253 VGND VGND VPWR VPWR sky130_fd_sc_hd__decap_3
XTAP_TAPCELL_ROW_7_235 VGND VPWR sky130_fd_sc_hd__tapvpwrvgnd_1
XFILLER_85_26 VGND VGND VPWR VPWR sky130_fd_sc_hd__fill_2
XFILLER_18_97 VGND VGND VPWR VPWR sky130_fd_sc_hd__fill_1
XTAP_TAPCELL_ROW_73_627 VGND VPWR sky130_fd_sc_hd__tapvpwrvgnd_1
XFILLER_70_153 VGND VGND VPWR VPWR sky130_fd_sc_hd__decap_3
XFILLER_34_41 VGND VGND VPWR VPWR sky130_fd_sc_hd__decap_3
XFILLER_34_74 VGND VGND VPWR VPWR sky130_fd_sc_hd__decap_3
XFILLER_34_85 VGND VGND VPWR VPWR sky130_fd_sc_hd__decap_3
XFILLER_7_213 VGND VGND VPWR VPWR sky130_fd_sc_hd__decap_3
XFILLER_50_40 VGND VGND VPWR VPWR sky130_fd_sc_hd__fill_1
XFILLER_59_60 VGND VGND VPWR VPWR sky130_fd_sc_hd__fill_2
XFILLER_78_231 VGND VGND VPWR VPWR sky130_fd_sc_hd__decap_3
XFILLER_78_253 VGND VGND VPWR VPWR sky130_fd_sc_hd__fill_2
XFILLER_38_128 VGND VGND VPWR VPWR sky130_fd_sc_hd__decap_3
XFILLER_19_331 VGND VGND VPWR VPWR sky130_fd_sc_hd__decap_3
X_2070_ net782 net685 VGND VGND VPWR VPWR Inst_SimpleCLB_ConfigMem.Inst_frame2_bit17.Q
+ sky130_fd_sc_hd__dlxtp_1
X_1021_ _0117_ Inst_LB_LUT4c_frame_config_dffesr.LUT_flop Inst_LB_LUT4c_frame_config_dffesr.c_out_mux
+ VGND VGND VPWR VPWR Inst_LB_LUT4c_frame_config_dffesr.O sky130_fd_sc_hd__mux2_4
XFILLER_75_92 VGND VGND VPWR VPWR sky130_fd_sc_hd__decap_3
XFILLER_61_164 VGND VGND VPWR VPWR sky130_fd_sc_hd__decap_3
X_1923_ net750 net664 VGND VGND VPWR VPWR Inst_SimpleCLB_ConfigMem.Inst_frame7_bit30.Q
+ sky130_fd_sc_hd__dlxtp_1
X_1854_ net763 net655 VGND VGND VPWR VPWR Inst_SimpleCLB_ConfigMem.Inst_frame9_bit25.Q
+ sky130_fd_sc_hd__dlxtp_1
X_1785_ net775 net720 VGND VGND VPWR VPWR Inst_SimpleCLB_ConfigMem.Inst_frame11_bit20.Q
+ sky130_fd_sc_hd__dlxtp_1
X_0805_ net622 net613 net632 net609 Inst_SimpleCLB_ConfigMem.Inst_frame5_bit31.Q Inst_SimpleCLB_ConfigMem.Inst_frame5_bit30.Q
+ VGND VGND VPWR VPWR _0638_ sky130_fd_sc_hd__mux4_1
X_0736_ E2MID[4] VGND VGND VPWR VPWR _0572_ sky130_fd_sc_hd__inv_1
XFILLER_69_220 VGND VGND VPWR VPWR sky130_fd_sc_hd__decap_3
X_2406_ Inst_SimpleCLB_switch_matrix.WW4BEG0 VGND VGND VPWR VPWR net242 sky130_fd_sc_hd__buf_1
X_2337_ S4END[12] VGND VGND VPWR VPWR net188 sky130_fd_sc_hd__buf_4
XTAP_TAPCELL_ROW_4_216 VGND VPWR sky130_fd_sc_hd__tapvpwrvgnd_1
XFILLER_69_275 VGND VGND VPWR VPWR sky130_fd_sc_hd__decap_3
XFILLER_29_139 VGND VGND VPWR VPWR sky130_fd_sc_hd__decap_3
X_2268_ Inst_SimpleCLB_switch_matrix.JN2BEG7 VGND VGND VPWR VPWR net113 sky130_fd_sc_hd__buf_1
X_1219_ _0286_ _0288_ _0303_ VGND VGND VPWR VPWR _0304_ sky130_fd_sc_hd__or3_1
XFILLER_25_334 VGND VGND VPWR VPWR sky130_fd_sc_hd__fill_2
X_2199_ EE4END[14] VGND VGND VPWR VPWR net35 sky130_fd_sc_hd__clkbuf_1
XTAP_TAPCELL_ROW_70_608 VGND VPWR sky130_fd_sc_hd__tapvpwrvgnd_1
XFILLER_52_175 VGND VGND VPWR VPWR sky130_fd_sc_hd__fill_1
XFILLER_52_197 VGND VGND VPWR VPWR sky130_fd_sc_hd__decap_3
XFILLER_20_98 VGND VGND VPWR VPWR sky130_fd_sc_hd__decap_3
XFILLER_29_41 VGND VGND VPWR VPWR sky130_fd_sc_hd__decap_3
XFILLER_29_96 VGND VGND VPWR VPWR sky130_fd_sc_hd__decap_3
XFILLER_75_223 VGND VGND VPWR VPWR sky130_fd_sc_hd__fill_1
XFILLER_90_237 VGND VGND VPWR VPWR sky130_fd_sc_hd__decap_3
XFILLER_90_215 VGND VGND VPWR VPWR sky130_fd_sc_hd__decap_3
XFILLER_45_40 VGND VGND VPWR VPWR sky130_fd_sc_hd__decap_3
XFILLER_16_334 VGND VGND VPWR VPWR sky130_fd_sc_hd__decap_3
XFILLER_45_62 VGND VGND VPWR VPWR sky130_fd_sc_hd__decap_3
XFILLER_31_337 VGND VGND VPWR VPWR sky130_fd_sc_hd__decap_3
XFILLER_43_197 VGND VGND VPWR VPWR sky130_fd_sc_hd__decap_3
XFILLER_84_9 VGND VGND VPWR VPWR sky130_fd_sc_hd__decap_3
XFILLER_6_12 VGND VGND VPWR VPWR sky130_fd_sc_hd__decap_3
X_1570_ net754 net692 VGND VGND VPWR VPWR Inst_LB_LUT4c_frame_config_dffesr.inst_cus_mux161_buf.A8
+ sky130_fd_sc_hd__dlxtp_1
XANTENNA_5 E1END[0] VGND VGND VPWR VPWR sky130_fd_sc_hd__diode_2
XFILLER_6_78 VGND VGND VPWR VPWR sky130_fd_sc_hd__decap_3
XFILLER_3_293 VGND VGND VPWR VPWR sky130_fd_sc_hd__decap_3
XFILLER_13_3 VGND VGND VPWR VPWR sky130_fd_sc_hd__fill_2
X_2122_ net741 net730 VGND VGND VPWR VPWR Inst_SimpleCLB_ConfigMem.Inst_frame0_bit5.Q
+ sky130_fd_sc_hd__dlxtp_1
XFILLER_66_234 VGND VGND VPWR VPWR sky130_fd_sc_hd__decap_3
XFILLER_66_245 VGND VGND VPWR VPWR sky130_fd_sc_hd__decap_3
XFILLER_81_215 VGND VGND VPWR VPWR sky130_fd_sc_hd__decap_3
X_2053_ net798 net683 VGND VGND VPWR VPWR Inst_SimpleCLB_ConfigMem.Inst_frame2_bit0.Q
+ sky130_fd_sc_hd__dlxtp_1
XTAP_TAPCELL_ROW_49_487 VGND VPWR sky130_fd_sc_hd__tapvpwrvgnd_1
XFILLER_19_194 VGND VGND VPWR VPWR sky130_fd_sc_hd__decap_3
X_1004_ Inst_SimpleCLB_ConfigMem.Inst_frame10_bit20.Q _0632_ VGND VGND VPWR VPWR _0101_
+ sky130_fd_sc_hd__nand2_1
X_1906_ net791 net666 VGND VGND VPWR VPWR Inst_SimpleCLB_ConfigMem.Inst_frame7_bit13.Q
+ sky130_fd_sc_hd__dlxtp_1
X_1837_ net735 net658 VGND VGND VPWR VPWR Inst_SimpleCLB_ConfigMem.Inst_frame9_bit8.Q
+ sky130_fd_sc_hd__dlxtp_1
X_1768_ net746 net720 VGND VGND VPWR VPWR Inst_SimpleCLB_ConfigMem.Inst_frame11_bit3.Q
+ sky130_fd_sc_hd__dlxtp_1
XFILLER_89_337 VGND VGND VPWR VPWR sky130_fd_sc_hd__fill_1
X_1699_ net749 net710 VGND VGND VPWR VPWR Inst_SimpleCLB_ConfigMem.Inst_frame14_bit30.Q
+ sky130_fd_sc_hd__dlxtp_1
XFILLER_57_256 VGND VGND VPWR VPWR sky130_fd_sc_hd__fill_2
XFILLER_72_237 VGND VGND VPWR VPWR sky130_fd_sc_hd__decap_3
XFILLER_15_10 VGND VGND VPWR VPWR sky130_fd_sc_hd__fill_1
XFILLER_25_175 VGND VGND VPWR VPWR sky130_fd_sc_hd__fill_2
XFILLER_15_54 VGND VGND VPWR VPWR sky130_fd_sc_hd__fill_2
XFILLER_13_337 VGND VGND VPWR VPWR sky130_fd_sc_hd__decap_3
XFILLER_40_112 VGND VGND VPWR VPWR sky130_fd_sc_hd__decap_3
XFILLER_40_167 VGND VGND VPWR VPWR sky130_fd_sc_hd__decap_3
Xoutput7 net7 VGND VGND VPWR VPWR E2BEG[1] sky130_fd_sc_hd__buf_4
Xoutput20 net20 VGND VGND VPWR VPWR E2BEGb[6] sky130_fd_sc_hd__buf_2
Xoutput42 net42 VGND VGND VPWR VPWR EE4BEG[2] sky130_fd_sc_hd__buf_2
Xoutput31 net31 VGND VGND VPWR VPWR E6BEG[7] sky130_fd_sc_hd__buf_2
Xoutput64 net64 VGND VGND VPWR VPWR FrameData_O[22] sky130_fd_sc_hd__buf_2
Xoutput75 net75 VGND VGND VPWR VPWR FrameData_O[3] sky130_fd_sc_hd__buf_2
Xoutput53 net53 VGND VGND VPWR VPWR FrameData_O[12] sky130_fd_sc_hd__buf_2
Xoutput97 net97 VGND VGND VPWR VPWR FrameStrobe_O[5] sky130_fd_sc_hd__buf_2
Xoutput86 net86 VGND VGND VPWR VPWR FrameStrobe_O[13] sky130_fd_sc_hd__buf_2
XFILLER_48_212 VGND VGND VPWR VPWR sky130_fd_sc_hd__decap_3
XTAP_TAPCELL_ROW_46_468 VGND VPWR sky130_fd_sc_hd__tapvpwrvgnd_1
XFILLER_71_281 VGND VGND VPWR VPWR sky130_fd_sc_hd__fill_1
XFILLER_71_292 VGND VGND VPWR VPWR sky130_fd_sc_hd__decap_3
XFILLER_31_145 VGND VGND VPWR VPWR sky130_fd_sc_hd__fill_1
XFILLER_31_167 VGND VGND VPWR VPWR sky130_fd_sc_hd__fill_1
XFILLER_31_178 VGND VGND VPWR VPWR sky130_fd_sc_hd__decap_3
X_1622_ net782 net700 VGND VGND VPWR VPWR Inst_LE_LUT4c_frame_config_dffesr.inst_cus_mux161_buf.A3
+ sky130_fd_sc_hd__dlxtp_1
X_1553_ net793 FrameStrobe[18] VGND VGND VPWR VPWR Inst_LA_LUT4c_frame_config_dffesr.inst_cus_mux161_buf.A10
+ sky130_fd_sc_hd__dlxtp_1
X_1484_ N2END[3] N4END[2] E6END[0] net633 Inst_SimpleCLB_ConfigMem.Inst_frame13_bit4.Q
+ Inst_SimpleCLB_ConfigMem.Inst_frame13_bit5.Q VGND VGND VPWR VPWR Inst_SimpleCLB_switch_matrix.N4BEG1
+ sky130_fd_sc_hd__mux4_1
XFILLER_39_223 VGND VGND VPWR VPWR sky130_fd_sc_hd__fill_1
XFILLER_39_245 VGND VGND VPWR VPWR sky130_fd_sc_hd__decap_3
X_2105_ net773 net690 VGND VGND VPWR VPWR Inst_SimpleCLB_ConfigMem.Inst_frame1_bit20.Q
+ sky130_fd_sc_hd__dlxtp_1
XTAP_TAPCELL_ROW_37_413 VGND VPWR sky130_fd_sc_hd__tapvpwrvgnd_1
XFILLER_54_215 VGND VGND VPWR VPWR sky130_fd_sc_hd__decap_3
XFILLER_54_226 VGND VGND VPWR VPWR sky130_fd_sc_hd__fill_1
XFILLER_54_248 VGND VGND VPWR VPWR sky130_fd_sc_hd__decap_3
X_2036_ net786 net682 VGND VGND VPWR VPWR Inst_SimpleCLB_ConfigMem.Inst_frame3_bit15.Q
+ sky130_fd_sc_hd__dlxtp_1
XTAP_TAPCELL_ROW_20_313 VGND VPWR sky130_fd_sc_hd__tapvpwrvgnd_1
XFILLER_89_167 VGND VGND VPWR VPWR sky130_fd_sc_hd__fill_1
XANTENNA_203 net224 VGND VGND VPWR VPWR sky130_fd_sc_hd__diode_2
XANTENNA_214 net802 VGND VGND VPWR VPWR sky130_fd_sc_hd__diode_2
XFILLER_45_237 VGND VGND VPWR VPWR sky130_fd_sc_hd__decap_3
XANTENNA_225 net736 VGND VGND VPWR VPWR sky130_fd_sc_hd__diode_2
XFILLER_60_218 VGND VGND VPWR VPWR sky130_fd_sc_hd__decap_3
XTAP_TAPCELL_ROW_43_449 VGND VPWR sky130_fd_sc_hd__tapvpwrvgnd_1
XFILLER_53_281 VGND VGND VPWR VPWR sky130_fd_sc_hd__decap_3
XFILLER_13_167 VGND VGND VPWR VPWR sky130_fd_sc_hd__fill_1
XFILLER_13_189 VGND VGND VPWR VPWR sky130_fd_sc_hd__decap_3
XFILLER_42_74 VGND VGND VPWR VPWR sky130_fd_sc_hd__decap_3
XFILLER_42_85 VGND VGND VPWR VPWR sky130_fd_sc_hd__decap_3
Xrebuffer8 _0051_ VGND VGND VPWR VPWR net262 sky130_fd_sc_hd__buf_6
XFILLER_67_71 VGND VGND VPWR VPWR sky130_fd_sc_hd__decap_3
XFILLER_44_292 VGND VGND VPWR VPWR sky130_fd_sc_hd__decap_3
XFILLER_80_3 VGND VGND VPWR VPWR sky130_fd_sc_hd__decap_3
X_0984_ Inst_LC_LUT4c_frame_config_dffesr.inst_cus_mux161_buf.A4 _0053_ _0054_ Inst_LC_LUT4c_frame_config_dffesr.inst_cus_mux161_buf.A2
+ VGND VGND VPWR VPWR _0082_ sky130_fd_sc_hd__o22a_1
X_1605_ net799 net698 VGND VGND VPWR VPWR Inst_LD_LUT4c_frame_config_dffesr.inst_cus_mux161_buf.A5
+ sky130_fd_sc_hd__dlxtp_1
X_1536_ Inst_SimpleCLB_ConfigMem.Inst_frame8_bit4.Q _0539_ VGND VGND VPWR VPWR _0560_
+ sky130_fd_sc_hd__nand2_1
X_1467_ net608 Inst_SimpleCLB_switch_matrix.JS2BEG1 net645 net258 Inst_SimpleCLB_ConfigMem.Inst_frame11_bit19.Q
+ Inst_SimpleCLB_ConfigMem.Inst_frame11_bit18.Q VGND VGND VPWR VPWR Inst_SimpleCLB_switch_matrix.W1BEG2
+ sky130_fd_sc_hd__mux4_2
X_1398_ net302 net620 Inst_SimpleCLB_ConfigMem.Inst_frame12_bit10.Q VGND VGND VPWR
+ VPWR _0462_ sky130_fd_sc_hd__mux2_1
X_2019_ net749 net675 VGND VGND VPWR VPWR Inst_SimpleCLB_ConfigMem.Inst_frame4_bit30.Q
+ sky130_fd_sc_hd__dlxtp_1
XFILLER_10_104 VGND VGND VPWR VPWR sky130_fd_sc_hd__decap_3
XFILLER_50_262 VGND VGND VPWR VPWR sky130_fd_sc_hd__decap_3
XFILLER_12_88 VGND VGND VPWR VPWR sky130_fd_sc_hd__decap_3
Xfanout640 net641 VGND VGND VPWR VPWR net640 sky130_fd_sc_hd__buf_8
Xfanout651 N1END[2] VGND VGND VPWR VPWR net651 sky130_fd_sc_hd__clkbuf_2
Xfanout673 net674 VGND VGND VPWR VPWR net673 sky130_fd_sc_hd__clkbuf_2
Xfanout684 net686 VGND VGND VPWR VPWR net684 sky130_fd_sc_hd__buf_2
Xfanout662 FrameStrobe[8] VGND VGND VPWR VPWR net662 sky130_fd_sc_hd__clkbuf_1
Xfanout695 net696 VGND VGND VPWR VPWR net695 sky130_fd_sc_hd__buf_1
XFILLER_18_226 VGND VGND VPWR VPWR sky130_fd_sc_hd__fill_2
XFILLER_37_63 VGND VGND VPWR VPWR sky130_fd_sc_hd__decap_3
XFILLER_5_141 VGND VGND VPWR VPWR sky130_fd_sc_hd__decap_3
XFILLER_5_196 VGND VGND VPWR VPWR sky130_fd_sc_hd__decap_3
X_2370_ Inst_SimpleCLB_switch_matrix.JW2BEG4 VGND VGND VPWR VPWR net215 sky130_fd_sc_hd__buf_6
XFILLER_68_126 VGND VGND VPWR VPWR sky130_fd_sc_hd__fill_2
X_1321_ Inst_SimpleCLB_ConfigMem.Inst_frame10_bit4.Q _0394_ VGND VGND VPWR VPWR _0395_
+ sky130_fd_sc_hd__nor2_1
XFILLER_78_70 VGND VGND VPWR VPWR sky130_fd_sc_hd__fill_2
X_1252_ _0582_ _0332_ Inst_SimpleCLB_ConfigMem.Inst_frame1_bit25.Q VGND VGND VPWR
+ VPWR _0335_ sky130_fd_sc_hd__o21a_1
XTAP_TAPCELL_ROW_79_666 VGND VPWR sky130_fd_sc_hd__tapvpwrvgnd_1
XFILLER_83_107 VGND VGND VPWR VPWR sky130_fd_sc_hd__decap_3
X_1183_ net648 N2END[7] net802 E2END[7] Inst_SimpleCLB_ConfigMem.Inst_frame1_bit18.Q
+ Inst_SimpleCLB_ConfigMem.Inst_frame1_bit19.Q VGND VGND VPWR VPWR _0270_ sky130_fd_sc_hd__mux4_1
XFILLER_32_251 VGND VGND VPWR VPWR sky130_fd_sc_hd__fill_1
XFILLER_32_262 VGND VGND VPWR VPWR sky130_fd_sc_hd__decap_3
X_0967_ _0061_ _0063_ _0066_ Inst_SimpleCLB_ConfigMem.Inst_frame1_bit5.Q VGND VGND
+ VPWR VPWR Inst_SimpleCLB_switch_matrix.JW2BEG2 sky130_fd_sc_hd__o2bb2a_4
XPHY_EDGE_ROW_12_Right_12 VGND VGND VPWR VPWR sky130_fd_sc_hd__decap_3
Xoutput210 net210 VGND VGND VPWR VPWR W1BEG[3] sky130_fd_sc_hd__buf_4
X_0898_ E2MID[6] W2MID[6] S2MID[6] Inst_SimpleCLB_switch_matrix.JN2BEG4 Inst_SimpleCLB_ConfigMem.Inst_frame7_bit3.Q
+ Inst_SimpleCLB_ConfigMem.Inst_frame7_bit2.Q VGND VGND VPWR VPWR _0723_ sky130_fd_sc_hd__mux4_2
Xoutput221 net221 VGND VGND VPWR VPWR W2BEGb[2] sky130_fd_sc_hd__buf_2
Xoutput243 net243 VGND VGND VPWR VPWR WW4BEG[13] sky130_fd_sc_hd__buf_8
Xoutput232 net232 VGND VGND VPWR VPWR W6BEG[3] sky130_fd_sc_hd__buf_2
Xoutput254 net254 VGND VGND VPWR VPWR WW4BEG[9] sky130_fd_sc_hd__buf_2
X_1519_ Inst_SimpleCLB_ConfigMem.Inst_frame10_bit29.Q _0530_ VGND VGND VPWR VPWR _0547_
+ sky130_fd_sc_hd__nand2_1
XFILLER_74_118 VGND VGND VPWR VPWR sky130_fd_sc_hd__decap_3
XFILLER_67_181 VGND VGND VPWR VPWR sky130_fd_sc_hd__decap_3
XPHY_EDGE_ROW_21_Right_21 VGND VGND VPWR VPWR sky130_fd_sc_hd__decap_3
XFILLER_15_218 VGND VGND VPWR VPWR sky130_fd_sc_hd__decap_3
XTAP_TAPCELL_ROW_53_511 VGND VPWR sky130_fd_sc_hd__tapvpwrvgnd_1
XFILLER_23_54 VGND VGND VPWR VPWR sky130_fd_sc_hd__fill_2
XFILLER_23_87 VGND VGND VPWR VPWR sky130_fd_sc_hd__decap_3
XPHY_EDGE_ROW_30_Right_30 VGND VGND VPWR VPWR sky130_fd_sc_hd__decap_3
XFILLER_2_144 VGND VGND VPWR VPWR sky130_fd_sc_hd__fill_2
XFILLER_48_62 VGND VGND VPWR VPWR sky130_fd_sc_hd__fill_2
XTAP_TAPCELL_ROW_76_647 VGND VPWR sky130_fd_sc_hd__tapvpwrvgnd_1
XFILLER_0_47 VGND VGND VPWR VPWR sky130_fd_sc_hd__decap_3
XFILLER_64_50 VGND VGND VPWR VPWR sky130_fd_sc_hd__fill_1
XFILLER_61_346 VGND VGND VPWR VPWR sky130_fd_sc_hd__fill_1
XFILLER_14_251 VGND VGND VPWR VPWR sky130_fd_sc_hd__fill_1
X_1870_ net734 net660 VGND VGND VPWR VPWR Inst_SimpleCLB_ConfigMem.Inst_frame8_bit9.Q
+ sky130_fd_sc_hd__dlxtp_1
X_0821_ Inst_SimpleCLB_ConfigMem.Inst_frame2_bit0.Q _0650_ Inst_SimpleCLB_ConfigMem.Inst_frame2_bit1.Q
+ VGND VGND VPWR VPWR _0653_ sky130_fd_sc_hd__o21a_1
X_0752_ Inst_SimpleCLB_ConfigMem.Inst_frame3_bit28.Q VGND VGND VPWR VPWR _0588_ sky130_fd_sc_hd__inv_1
XFILLER_43_3 VGND VGND VPWR VPWR sky130_fd_sc_hd__decap_3
X_2353_ SS4END[12] VGND VGND VPWR VPWR net204 sky130_fd_sc_hd__clkbuf_2
X_1304_ _0376_ _0377_ _0380_ _0595_ VGND VGND VPWR VPWR Inst_SimpleCLB_switch_matrix.JN2BEG7
+ sky130_fd_sc_hd__a22o_1
X_2284_ N4END[11] VGND VGND VPWR VPWR net135 sky130_fd_sc_hd__clkbuf_1
X_1235_ Inst_SimpleCLB_ConfigMem.Inst_frame9_bit9.Q _0317_ _0318_ Inst_LD_LUT4c_frame_config_dffesr.c_I0mux
+ VGND VGND VPWR VPWR _0319_ sky130_fd_sc_hd__a31o_1
XFILLER_49_192 VGND VGND VPWR VPWR sky130_fd_sc_hd__decap_3
X_1166_ _0252_ _0253_ Inst_SimpleCLB_ConfigMem.Inst_frame3_bit20.Q VGND VGND VPWR
+ VPWR _0254_ sky130_fd_sc_hd__mux2_1
X_1097_ Inst_LF_LUT4c_frame_config_dffesr.inst_cus_mux161_buf.A9 _0166_ _0167_ VGND
+ VGND VPWR VPWR _0189_ sky130_fd_sc_hd__or3_1
XFILLER_20_265 VGND VGND VPWR VPWR sky130_fd_sc_hd__decap_3
X_1999_ net796 net676 VGND VGND VPWR VPWR Inst_SimpleCLB_ConfigMem.Inst_frame4_bit10.Q
+ sky130_fd_sc_hd__dlxtp_1
XFILLER_69_39 VGND VGND VPWR VPWR sky130_fd_sc_hd__decap_3
XFILLER_85_49 VGND VGND VPWR VPWR sky130_fd_sc_hd__decap_3
XFILLER_43_335 VGND VGND VPWR VPWR sky130_fd_sc_hd__fill_1
XFILLER_55_162 VGND VGND VPWR VPWR sky130_fd_sc_hd__decap_3
XFILLER_55_173 VGND VGND VPWR VPWR sky130_fd_sc_hd__decap_3
XTAP_TAPCELL_ROW_73_628 VGND VPWR sky130_fd_sc_hd__tapvpwrvgnd_1
XFILLER_70_121 VGND VGND VPWR VPWR sky130_fd_sc_hd__fill_1
XFILLER_34_53 VGND VGND VPWR VPWR sky130_fd_sc_hd__decap_3
XFILLER_70_165 VGND VGND VPWR VPWR sky130_fd_sc_hd__decap_3
XFILLER_11_265 VGND VGND VPWR VPWR sky130_fd_sc_hd__decap_3
XFILLER_11_287 VGND VGND VPWR VPWR sky130_fd_sc_hd__decap_3
XFILLER_11_276 VGND VGND VPWR VPWR sky130_fd_sc_hd__decap_3
XFILLER_7_225 VGND VGND VPWR VPWR sky130_fd_sc_hd__decap_3
XFILLER_50_85 VGND VGND VPWR VPWR sky130_fd_sc_hd__decap_3
XFILLER_59_83 VGND VGND VPWR VPWR sky130_fd_sc_hd__decap_3
XFILLER_78_287 VGND VGND VPWR VPWR sky130_fd_sc_hd__fill_2
XFILLER_15_7 VGND VGND VPWR VPWR sky130_fd_sc_hd__decap_3
X_1020_ _0109_ _0116_ VGND VGND VPWR VPWR _0117_ sky130_fd_sc_hd__and2_4
XFILLER_19_343 VGND VGND VPWR VPWR sky130_fd_sc_hd__decap_3
XFILLER_34_324 VGND VGND VPWR VPWR sky130_fd_sc_hd__fill_1
XFILLER_34_346 VGND VGND VPWR VPWR sky130_fd_sc_hd__fill_1
X_1922_ net753 net663 VGND VGND VPWR VPWR Inst_SimpleCLB_ConfigMem.Inst_frame7_bit29.Q
+ sky130_fd_sc_hd__dlxtp_1
X_1853_ net765 net655 VGND VGND VPWR VPWR Inst_SimpleCLB_ConfigMem.Inst_frame9_bit24.Q
+ sky130_fd_sc_hd__dlxtp_1
XTAP_TAPCELL_ROW_12_260 VGND VPWR sky130_fd_sc_hd__tapvpwrvgnd_1
X_0804_ _0636_ VGND VGND VPWR VPWR _0637_ sky130_fd_sc_hd__inv_1
X_1784_ net779 net722 VGND VGND VPWR VPWR Inst_SimpleCLB_ConfigMem.Inst_frame11_bit19.Q
+ sky130_fd_sc_hd__dlxtp_1
XFILLER_6_280 VGND VGND VPWR VPWR sky130_fd_sc_hd__fill_2
X_0735_ N2MID[4] VGND VGND VPWR VPWR _0571_ sky130_fd_sc_hd__inv_1
X_2405_ WW4END[15] VGND VGND VPWR VPWR net241 sky130_fd_sc_hd__clkbuf_2
X_2336_ S4END[11] VGND VGND VPWR VPWR net187 sky130_fd_sc_hd__clkbuf_2
XTAP_TAPCELL_ROW_4_217 VGND VPWR sky130_fd_sc_hd__tapvpwrvgnd_1
XFILLER_29_118 VGND VGND VPWR VPWR sky130_fd_sc_hd__decap_3
X_2267_ Inst_SimpleCLB_switch_matrix.JN2BEG6 VGND VGND VPWR VPWR net112 sky130_fd_sc_hd__buf_6
X_1218_ _0301_ _0302_ VGND VGND VPWR VPWR _0303_ sky130_fd_sc_hd__nand2_1
XPHY_EDGE_ROW_9_Left_100 VGND VGND VPWR VPWR sky130_fd_sc_hd__decap_3
XFILLER_1_90 VGND VGND VPWR VPWR sky130_fd_sc_hd__decap_3
XFILLER_25_324 VGND VGND VPWR VPWR sky130_fd_sc_hd__fill_2
X_2198_ EE4END[13] VGND VGND VPWR VPWR net49 sky130_fd_sc_hd__clkbuf_1
X_1149_ net648 N2END[7] E1END[3] E2END[7] Inst_SimpleCLB_ConfigMem.Inst_frame2_bit18.Q
+ Inst_SimpleCLB_ConfigMem.Inst_frame2_bit19.Q VGND VGND VPWR VPWR _0238_ sky130_fd_sc_hd__mux4_1
XFILLER_25_346 VGND VGND VPWR VPWR sky130_fd_sc_hd__fill_1
XTAP_TAPCELL_ROW_70_609 VGND VPWR sky130_fd_sc_hd__tapvpwrvgnd_1
XFILLER_4_206 VGND VGND VPWR VPWR sky130_fd_sc_hd__decap_3
XFILLER_20_66 VGND VGND VPWR VPWR sky130_fd_sc_hd__decap_3
XFILLER_75_202 VGND VGND VPWR VPWR sky130_fd_sc_hd__decap_3
XFILLER_75_246 VGND VGND VPWR VPWR sky130_fd_sc_hd__decap_3
XFILLER_90_249 VGND VGND VPWR VPWR sky130_fd_sc_hd__decap_3
XFILLER_16_346 VGND VGND VPWR VPWR sky130_fd_sc_hd__fill_1
XFILLER_28_195 VGND VGND VPWR VPWR sky130_fd_sc_hd__fill_1
XFILLER_43_110 VGND VGND VPWR VPWR sky130_fd_sc_hd__fill_2
XFILLER_45_52 VGND VGND VPWR VPWR sky130_fd_sc_hd__decap_3
XFILLER_45_74 VGND VGND VPWR VPWR sky130_fd_sc_hd__fill_2
XFILLER_61_84 VGND VGND VPWR VPWR sky130_fd_sc_hd__decap_3
XFILLER_6_24 VGND VGND VPWR VPWR sky130_fd_sc_hd__decap_3
XFILLER_6_57 VGND VGND VPWR VPWR sky130_fd_sc_hd__decap_3
XFILLER_6_35 VGND VGND VPWR VPWR sky130_fd_sc_hd__fill_1
XANTENNA_6 E1END[2] VGND VGND VPWR VPWR sky130_fd_sc_hd__diode_2
X_2121_ net743 net730 VGND VGND VPWR VPWR Inst_SimpleCLB_ConfigMem.Inst_frame0_bit4.Q
+ sky130_fd_sc_hd__dlxtp_1
XFILLER_19_140 VGND VGND VPWR VPWR sky130_fd_sc_hd__decap_3
X_2052_ net747 net679 VGND VGND VPWR VPWR Inst_SimpleCLB_ConfigMem.Inst_frame3_bit31.Q
+ sky130_fd_sc_hd__dlxtp_1
X_1003_ Inst_LB_LUT4c_frame_config_dffesr.inst_cus_mux161_buf.A10 _0096_ _0099_ _0095_
+ VGND VGND VPWR VPWR _0100_ sky130_fd_sc_hd__o211a_1
XFILLER_81_249 VGND VGND VPWR VPWR sky130_fd_sc_hd__decap_3
X_1905_ net792 net666 VGND VGND VPWR VPWR Inst_SimpleCLB_ConfigMem.Inst_frame7_bit12.Q
+ sky130_fd_sc_hd__dlxtp_1
XPHY_EDGE_ROW_6_Right_6 VGND VGND VPWR VPWR sky130_fd_sc_hd__decap_3
X_1836_ net737 net655 VGND VGND VPWR VPWR Inst_SimpleCLB_ConfigMem.Inst_frame9_bit7.Q
+ sky130_fd_sc_hd__dlxtp_1
X_1767_ net752 net720 VGND VGND VPWR VPWR Inst_SimpleCLB_ConfigMem.Inst_frame11_bit2.Q
+ sky130_fd_sc_hd__dlxtp_1
X_1698_ net755 net710 VGND VGND VPWR VPWR Inst_SimpleCLB_ConfigMem.Inst_frame14_bit29.Q
+ sky130_fd_sc_hd__dlxtp_1
X_2319_ Inst_SimpleCLB_switch_matrix.JS2BEG6 VGND VGND VPWR VPWR net164 sky130_fd_sc_hd__buf_8
XFILLER_57_279 VGND VGND VPWR VPWR sky130_fd_sc_hd__fill_1
XFILLER_82_17 VGND VGND VPWR VPWR sky130_fd_sc_hd__decap_3
XFILLER_25_110 VGND VGND VPWR VPWR sky130_fd_sc_hd__fill_2
XFILLER_65_290 VGND VGND VPWR VPWR sky130_fd_sc_hd__fill_1
XFILLER_40_124 VGND VGND VPWR VPWR sky130_fd_sc_hd__decap_3
XFILLER_40_179 VGND VGND VPWR VPWR sky130_fd_sc_hd__fill_1
XFILLER_31_54 VGND VGND VPWR VPWR sky130_fd_sc_hd__fill_2
XFILLER_31_76 VGND VGND VPWR VPWR sky130_fd_sc_hd__decap_3
XFILLER_31_98 VGND VGND VPWR VPWR sky130_fd_sc_hd__fill_2
Xoutput8 net8 VGND VGND VPWR VPWR E2BEG[2] sky130_fd_sc_hd__buf_6
Xoutput10 net10 VGND VGND VPWR VPWR E2BEG[4] sky130_fd_sc_hd__buf_8
Xoutput21 net21 VGND VGND VPWR VPWR E2BEGb[7] sky130_fd_sc_hd__buf_2
Xoutput43 net43 VGND VGND VPWR VPWR EE4BEG[3] sky130_fd_sc_hd__buf_2
Xoutput32 net32 VGND VGND VPWR VPWR E6BEG[8] sky130_fd_sc_hd__buf_2
Xoutput76 net76 VGND VGND VPWR VPWR FrameData_O[4] sky130_fd_sc_hd__buf_2
Xoutput54 net54 VGND VGND VPWR VPWR FrameData_O[13] sky130_fd_sc_hd__buf_2
Xoutput65 net65 VGND VGND VPWR VPWR FrameData_O[23] sky130_fd_sc_hd__buf_2
Xoutput87 net87 VGND VGND VPWR VPWR FrameStrobe_O[14] sky130_fd_sc_hd__buf_2
Xoutput98 net98 VGND VGND VPWR VPWR FrameStrobe_O[6] sky130_fd_sc_hd__buf_2
XFILLER_48_224 VGND VGND VPWR VPWR sky130_fd_sc_hd__fill_2
XFILLER_48_268 VGND VGND VPWR VPWR sky130_fd_sc_hd__fill_1
XFILLER_56_51 VGND VGND VPWR VPWR sky130_fd_sc_hd__decap_3
XFILLER_16_165 VGND VGND VPWR VPWR sky130_fd_sc_hd__decap_3
XTAP_TAPCELL_ROW_46_469 VGND VPWR sky130_fd_sc_hd__tapvpwrvgnd_1
XFILLER_16_187 VGND VGND VPWR VPWR sky130_fd_sc_hd__decap_3
XFILLER_31_113 VGND VGND VPWR VPWR sky130_fd_sc_hd__decap_3
XPHY_EDGE_ROW_59_Right_59 VGND VGND VPWR VPWR sky130_fd_sc_hd__decap_3
X_1621_ net784 net700 VGND VGND VPWR VPWR Inst_LE_LUT4c_frame_config_dffesr.inst_cus_mux161_buf.A2
+ sky130_fd_sc_hd__dlxtp_1
X_1552_ net795 net692 VGND VGND VPWR VPWR Inst_LA_LUT4c_frame_config_dffesr.inst_cus_mux161_buf.A9
+ sky130_fd_sc_hd__dlxtp_1
X_1483_ N2END[0] N4END[3] W6END[1] net348 Inst_SimpleCLB_ConfigMem.Inst_frame13_bit6.Q
+ Inst_SimpleCLB_ConfigMem.Inst_frame13_bit7.Q VGND VGND VPWR VPWR Inst_SimpleCLB_switch_matrix.N4BEG2
+ sky130_fd_sc_hd__mux4_1
XFILLER_39_202 VGND VGND VPWR VPWR sky130_fd_sc_hd__decap_3
XPHY_EDGE_ROW_68_Right_68 VGND VGND VPWR VPWR sky130_fd_sc_hd__decap_3
X_2104_ net778 net690 VGND VGND VPWR VPWR Inst_SimpleCLB_ConfigMem.Inst_frame1_bit19.Q
+ sky130_fd_sc_hd__dlxtp_1
XTAP_TAPCELL_ROW_37_414 VGND VPWR sky130_fd_sc_hd__tapvpwrvgnd_1
XFILLER_47_290 VGND VGND VPWR VPWR sky130_fd_sc_hd__decap_3
X_2035_ net788 net682 VGND VGND VPWR VPWR Inst_SimpleCLB_ConfigMem.Inst_frame3_bit14.Q
+ sky130_fd_sc_hd__dlxtp_1
XFILLER_62_271 VGND VGND VPWR VPWR sky130_fd_sc_hd__fill_1
XFILLER_22_135 VGND VGND VPWR VPWR sky130_fd_sc_hd__fill_1
XPHY_EDGE_ROW_77_Right_77 VGND VGND VPWR VPWR sky130_fd_sc_hd__decap_3
XFILLER_22_168 VGND VGND VPWR VPWR sky130_fd_sc_hd__decap_3
X_1819_ net769 net726 VGND VGND VPWR VPWR Inst_SimpleCLB_ConfigMem.Inst_frame10_bit22.Q
+ sky130_fd_sc_hd__dlxtp_1
XFILLER_7_9 VGND VGND VPWR VPWR sky130_fd_sc_hd__decap_3
Xfanout800 E6END[1] VGND VGND VPWR VPWR net800 sky130_fd_sc_hd__clkbuf_4
XFILLER_77_17 VGND VGND VPWR VPWR sky130_fd_sc_hd__fill_1
XPHY_EDGE_ROW_86_Right_86 VGND VGND VPWR VPWR sky130_fd_sc_hd__decap_3
XANTENNA_215 E1END[0] VGND VGND VPWR VPWR sky130_fd_sc_hd__diode_2
XANTENNA_204 net235 VGND VGND VPWR VPWR sky130_fd_sc_hd__diode_2
XANTENNA_226 net757 VGND VGND VPWR VPWR sky130_fd_sc_hd__diode_2
XFILLER_53_293 VGND VGND VPWR VPWR sky130_fd_sc_hd__decap_3
XTAP_TAPCELL_ROW_51_494 VGND VPWR sky130_fd_sc_hd__tapvpwrvgnd_1
XFILLER_42_97 VGND VGND VPWR VPWR sky130_fd_sc_hd__decap_3
Xrebuffer9 _0245_ VGND VGND VPWR VPWR net263 sky130_fd_sc_hd__buf_6
XFILLER_3_36 VGND VGND VPWR VPWR sky130_fd_sc_hd__decap_3
XFILLER_67_83 VGND VGND VPWR VPWR sky130_fd_sc_hd__decap_3
XFILLER_36_227 VGND VGND VPWR VPWR sky130_fd_sc_hd__decap_3
XFILLER_51_219 VGND VGND VPWR VPWR sky130_fd_sc_hd__decap_3
XFILLER_83_82 VGND VGND VPWR VPWR sky130_fd_sc_hd__fill_1
X_0983_ _0059_ _0080_ _0015_ VGND VGND VPWR VPWR _0081_ sky130_fd_sc_hd__mux2_4
XFILLER_12_190 VGND VGND VPWR VPWR sky130_fd_sc_hd__decap_3
XFILLER_73_3 VGND VGND VPWR VPWR sky130_fd_sc_hd__fill_1
X_1604_ net748 net696 VGND VGND VPWR VPWR Inst_LD_LUT4c_frame_config_dffesr.inst_cus_mux161_buf.A4
+ sky130_fd_sc_hd__dlxtp_1
X_1535_ Inst_SimpleCLB_ConfigMem.Inst_frame8_bit5.Q _0530_ VGND VGND VPWR VPWR _0559_
+ sky130_fd_sc_hd__nand2_1
XFILLER_86_138 VGND VGND VPWR VPWR sky130_fd_sc_hd__fill_2
X_1466_ net305 _0669_ net265 _0644_ Inst_SimpleCLB_ConfigMem.Inst_frame11_bit20.Q
+ Inst_SimpleCLB_ConfigMem.Inst_frame11_bit21.Q VGND VGND VPWR VPWR Inst_SimpleCLB_switch_matrix.W1BEG3
+ sky130_fd_sc_hd__mux4_1
X_1397_ Inst_SimpleCLB_ConfigMem.Inst_frame12_bit12.Q _0460_ VGND VGND VPWR VPWR _0461_
+ sky130_fd_sc_hd__nor2_1
XFILLER_27_216 VGND VGND VPWR VPWR sky130_fd_sc_hd__decap_3
XFILLER_27_249 VGND VGND VPWR VPWR sky130_fd_sc_hd__decap_3
X_2018_ net753 net675 VGND VGND VPWR VPWR Inst_SimpleCLB_ConfigMem.Inst_frame4_bit29.Q
+ sky130_fd_sc_hd__dlxtp_1
XFILLER_50_241 VGND VGND VPWR VPWR sky130_fd_sc_hd__decap_3
XFILLER_12_56 VGND VGND VPWR VPWR sky130_fd_sc_hd__fill_1
XFILLER_2_304 VGND VGND VPWR VPWR sky130_fd_sc_hd__decap_3
Xfanout641 Inst_LA_LUT4c_frame_config_dffesr.O VGND VGND VPWR VPWR net641 sky130_fd_sc_hd__buf_8
Xfanout630 Inst_LC_LUT4c_frame_config_dffesr.O VGND VGND VPWR VPWR net630 sky130_fd_sc_hd__buf_8
Xfanout663 net664 VGND VGND VPWR VPWR net663 sky130_fd_sc_hd__buf_2
Xfanout674 FrameStrobe[5] VGND VGND VPWR VPWR net674 sky130_fd_sc_hd__clkbuf_2
Xfanout652 N1END[1] VGND VGND VPWR VPWR net652 sky130_fd_sc_hd__clkbuf_4
Xfanout685 net686 VGND VGND VPWR VPWR net685 sky130_fd_sc_hd__buf_2
Xfanout696 FrameStrobe[17] VGND VGND VPWR VPWR net696 sky130_fd_sc_hd__clkbuf_2
XFILLER_37_42 VGND VGND VPWR VPWR sky130_fd_sc_hd__fill_1
XFILLER_37_75 VGND VGND VPWR VPWR sky130_fd_sc_hd__decap_3
XFILLER_33_219 VGND VGND VPWR VPWR sky130_fd_sc_hd__decap_3
XFILLER_41_252 VGND VGND VPWR VPWR sky130_fd_sc_hd__decap_3
XFILLER_5_153 VGND VGND VPWR VPWR sky130_fd_sc_hd__decap_3
XFILLER_5_175 VGND VGND VPWR VPWR sky130_fd_sc_hd__decap_3
X_1320_ net648 net802 S1END[3] net646 Inst_SimpleCLB_ConfigMem.Inst_frame10_bit2.Q
+ Inst_SimpleCLB_ConfigMem.Inst_frame10_bit3.Q VGND VGND VPWR VPWR _0394_ sky130_fd_sc_hd__mux4_1
X_1251_ Inst_SimpleCLB_ConfigMem.Inst_frame1_bit24.Q _0333_ VGND VGND VPWR VPWR _0334_
+ sky130_fd_sc_hd__or2_1
XTAP_TAPCELL_ROW_79_667 VGND VPWR sky130_fd_sc_hd__tapvpwrvgnd_1
X_1182_ S1END[1] S1END[3] S2END[7] net646 Inst_SimpleCLB_ConfigMem.Inst_frame1_bit18.Q
+ Inst_SimpleCLB_ConfigMem.Inst_frame1_bit19.Q VGND VGND VPWR VPWR _0269_ sky130_fd_sc_hd__mux4_1
XFILLER_17_271 VGND VGND VPWR VPWR sky130_fd_sc_hd__decap_3
XFILLER_32_274 VGND VGND VPWR VPWR sky130_fd_sc_hd__decap_3
X_0966_ _0064_ _0065_ Inst_SimpleCLB_ConfigMem.Inst_frame1_bit4.Q VGND VGND VPWR VPWR
+ _0066_ sky130_fd_sc_hd__mux2_1
XPHY_EDGE_ROW_18_Left_109 VGND VGND VPWR VPWR sky130_fd_sc_hd__decap_3
Xoutput200 net200 VGND VGND VPWR VPWR SS4BEG[4] sky130_fd_sc_hd__buf_2
X_0897_ _0717_ _0719_ _0722_ Inst_SimpleCLB_ConfigMem.Inst_frame4_bit13.Q VGND VGND
+ VPWR VPWR Inst_SimpleCLB_switch_matrix.JN2BEG4 sky130_fd_sc_hd__o22a_2
Xoutput222 net222 VGND VGND VPWR VPWR W2BEGb[3] sky130_fd_sc_hd__buf_2
Xoutput211 net211 VGND VGND VPWR VPWR W2BEG[0] sky130_fd_sc_hd__buf_4
Xoutput244 net244 VGND VGND VPWR VPWR WW4BEG[14] sky130_fd_sc_hd__buf_4
Xoutput233 net233 VGND VGND VPWR VPWR W6BEG[4] sky130_fd_sc_hd__buf_2
X_1518_ net395 _0546_ _0545_ VGND VGND VPWR VPWR _0001_ sky130_fd_sc_hd__mux2_1
X_1449_ _0504_ _0506_ _0502_ VGND VGND VPWR VPWR Inst_SimpleCLB_switch_matrix.NN4BEG2
+ sky130_fd_sc_hd__a21oi_1
XPHY_EDGE_ROW_27_Left_118 VGND VGND VPWR VPWR sky130_fd_sc_hd__decap_3
XFILLER_74_29 VGND VGND VPWR VPWR sky130_fd_sc_hd__decap_3
XFILLER_70_314 VGND VGND VPWR VPWR sky130_fd_sc_hd__fill_2
XFILLER_70_336 VGND VGND VPWR VPWR sky130_fd_sc_hd__fill_1
XFILLER_23_241 VGND VGND VPWR VPWR sky130_fd_sc_hd__decap_3
XFILLER_23_22 VGND VGND VPWR VPWR sky130_fd_sc_hd__fill_2
XPHY_EDGE_ROW_36_Left_127 VGND VGND VPWR VPWR sky130_fd_sc_hd__decap_3
XFILLER_2_134 VGND VGND VPWR VPWR sky130_fd_sc_hd__decap_3
XPHY_EDGE_ROW_45_Left_136 VGND VGND VPWR VPWR sky130_fd_sc_hd__decap_3
XFILLER_48_85 VGND VGND VPWR VPWR sky130_fd_sc_hd__decap_3
XFILLER_0_15 VGND VGND VPWR VPWR sky130_fd_sc_hd__decap_3
XTAP_TAPCELL_ROW_76_648 VGND VPWR sky130_fd_sc_hd__tapvpwrvgnd_1
XTAP_TAPCELL_ROW_84_692 VGND VPWR sky130_fd_sc_hd__tapvpwrvgnd_1
XFILLER_14_285 VGND VGND VPWR VPWR sky130_fd_sc_hd__fill_1
XFILLER_9_57 VGND VGND VPWR VPWR sky130_fd_sc_hd__decap_3
X_0820_ _0576_ _0651_ VGND VGND VPWR VPWR _0652_ sky130_fd_sc_hd__or2_1
XPHY_EDGE_ROW_54_Left_145 VGND VGND VPWR VPWR sky130_fd_sc_hd__decap_3
X_0751_ Inst_SimpleCLB_ConfigMem.Inst_frame2_bit25.Q VGND VGND VPWR VPWR _0587_ sky130_fd_sc_hd__inv_1
XFILLER_36_3 VGND VGND VPWR VPWR sky130_fd_sc_hd__decap_3
X_2352_ SS4END[11] VGND VGND VPWR VPWR net203 sky130_fd_sc_hd__clkbuf_2
X_2283_ N4END[10] VGND VGND VPWR VPWR net134 sky130_fd_sc_hd__buf_1
X_1303_ _0378_ _0379_ Inst_SimpleCLB_ConfigMem.Inst_frame4_bit24.Q VGND VGND VPWR
+ VPWR _0380_ sky130_fd_sc_hd__mux2_1
XPHY_EDGE_ROW_63_Left_154 VGND VGND VPWR VPWR sky130_fd_sc_hd__decap_3
X_1234_ Inst_SimpleCLB_ConfigMem.Inst_frame9_bit8.Q _0714_ VGND VGND VPWR VPWR _0318_
+ sky130_fd_sc_hd__or2_1
XFILLER_56_108 VGND VGND VPWR VPWR sky130_fd_sc_hd__decap_3
XFILLER_49_160 VGND VGND VPWR VPWR sky130_fd_sc_hd__decap_3
X_1165_ S1END[1] S1END[3] S2END[7] net646 Inst_SimpleCLB_ConfigMem.Inst_frame3_bit18.Q
+ Inst_SimpleCLB_ConfigMem.Inst_frame3_bit19.Q VGND VGND VPWR VPWR _0253_ sky130_fd_sc_hd__mux4_1
XFILLER_64_141 VGND VGND VPWR VPWR sky130_fd_sc_hd__decap_3
X_1096_ _0187_ _0186_ Inst_SimpleCLB_ConfigMem.Inst_frame8_bit3.Q VGND VGND VPWR VPWR
+ _0188_ sky130_fd_sc_hd__mux2_4
XPHY_EDGE_ROW_72_Left_163 VGND VGND VPWR VPWR sky130_fd_sc_hd__decap_3
XTAP_TAPCELL_ROW_15_280 VGND VPWR sky130_fd_sc_hd__tapvpwrvgnd_1
X_1998_ net733 net675 VGND VGND VPWR VPWR Inst_SimpleCLB_ConfigMem.Inst_frame4_bit9.Q
+ sky130_fd_sc_hd__dlxtp_1
XFILLER_20_277 VGND VGND VPWR VPWR sky130_fd_sc_hd__decap_3
X_0949_ N2MID[2] W2MID[2] E2MID[2] Inst_SimpleCLB_switch_matrix.E2BEG4 Inst_SimpleCLB_ConfigMem.Inst_frame7_bit5.Q
+ Inst_SimpleCLB_ConfigMem.Inst_frame7_bit4.Q VGND VGND VPWR VPWR _0049_ sky130_fd_sc_hd__mux4_1
XPHY_EDGE_ROW_81_Left_172 VGND VGND VPWR VPWR sky130_fd_sc_hd__decap_3
XFILLER_85_17 VGND VGND VPWR VPWR sky130_fd_sc_hd__decap_3
XFILLER_47_108 VGND VGND VPWR VPWR sky130_fd_sc_hd__decap_3
XFILLER_18_88 VGND VGND VPWR VPWR sky130_fd_sc_hd__decap_3
XTAP_TAPCELL_ROW_73_629 VGND VPWR sky130_fd_sc_hd__tapvpwrvgnd_1
XPHY_EDGE_ROW_90_Left_181 VGND VGND VPWR VPWR sky130_fd_sc_hd__decap_3
XFILLER_55_196 VGND VGND VPWR VPWR sky130_fd_sc_hd__decap_3
XFILLER_34_32 VGND VGND VPWR VPWR sky130_fd_sc_hd__decap_3
XFILLER_34_65 VGND VGND VPWR VPWR sky130_fd_sc_hd__decap_3
XFILLER_34_98 VGND VGND VPWR VPWR sky130_fd_sc_hd__decap_3
XFILLER_7_204 VGND VGND VPWR VPWR sky130_fd_sc_hd__decap_3
XFILLER_7_237 VGND VGND VPWR VPWR sky130_fd_sc_hd__fill_2
XFILLER_50_97 VGND VGND VPWR VPWR sky130_fd_sc_hd__decap_3
XFILLER_38_119 VGND VGND VPWR VPWR sky130_fd_sc_hd__decap_3
XPHY_EDGE_ROW_3_Left_94 VGND VGND VPWR VPWR sky130_fd_sc_hd__decap_3
XFILLER_46_141 VGND VGND VPWR VPWR sky130_fd_sc_hd__decap_3
X_1921_ FrameData[28] net664 VGND VGND VPWR VPWR Inst_SimpleCLB_ConfigMem.Inst_frame7_bit28.Q
+ sky130_fd_sc_hd__dlxtp_1
X_1852_ FrameData[23] net657 VGND VGND VPWR VPWR Inst_SimpleCLB_ConfigMem.Inst_frame9_bit23.Q
+ sky130_fd_sc_hd__dlxtp_1
XTAP_TAPCELL_ROW_12_261 VGND VPWR sky130_fd_sc_hd__tapvpwrvgnd_1
X_0803_ W6END[0] net627 net641 net616 Inst_SimpleCLB_ConfigMem.Inst_frame5_bit31.Q
+ Inst_SimpleCLB_ConfigMem.Inst_frame5_bit30.Q VGND VGND VPWR VPWR _0636_ sky130_fd_sc_hd__mux4_1
X_1783_ net781 net722 VGND VGND VPWR VPWR Inst_SimpleCLB_ConfigMem.Inst_frame11_bit18.Q
+ sky130_fd_sc_hd__dlxtp_1
X_0734_ Inst_SimpleCLB_ConfigMem.Inst_frame3_bit1.Q VGND VGND VPWR VPWR _0570_ sky130_fd_sc_hd__inv_1
X_2404_ WW4END[14] VGND VGND VPWR VPWR net240 sky130_fd_sc_hd__clkbuf_2
X_2335_ S4END[10] VGND VGND VPWR VPWR net186 sky130_fd_sc_hd__clkbuf_2
XFILLER_29_108 VGND VGND VPWR VPWR sky130_fd_sc_hd__decap_3
XFILLER_69_266 VGND VGND VPWR VPWR sky130_fd_sc_hd__decap_3
X_1217_ Inst_LH_LUT4c_frame_config_dffesr.inst_cus_mux161_buf.A5 _0294_ Inst_LH_LUT4c_frame_config_dffesr.inst_cus_mux161_buf.A1
+ _0295_ VGND VGND VPWR VPWR _0302_ sky130_fd_sc_hd__o22a_1
X_2197_ EE4END[12] VGND VGND VPWR VPWR net48 sky130_fd_sc_hd__clkbuf_1
X_1148_ _0236_ _0235_ Inst_SimpleCLB_ConfigMem.Inst_frame2_bit20.Q VGND VGND VPWR
+ VPWR _0237_ sky130_fd_sc_hd__mux2_4
XFILLER_37_196 VGND VGND VPWR VPWR sky130_fd_sc_hd__decap_3
XFILLER_52_133 VGND VGND VPWR VPWR sky130_fd_sc_hd__decap_3
X_1079_ _0166_ _0167_ VGND VGND VPWR VPWR _0172_ sky130_fd_sc_hd__nor2_4
XFILLER_20_78 VGND VGND VPWR VPWR sky130_fd_sc_hd__decap_3
XFILLER_75_214 VGND VGND VPWR VPWR sky130_fd_sc_hd__decap_3
XFILLER_75_225 VGND VGND VPWR VPWR sky130_fd_sc_hd__decap_3
XFILLER_28_141 VGND VGND VPWR VPWR sky130_fd_sc_hd__fill_1
XFILLER_75_258 VGND VGND VPWR VPWR sky130_fd_sc_hd__decap_3
XFILLER_75_269 VGND VGND VPWR VPWR sky130_fd_sc_hd__decap_3
XFILLER_90_228 VGND VGND VPWR VPWR sky130_fd_sc_hd__decap_3
XFILLER_90_206 VGND VGND VPWR VPWR sky130_fd_sc_hd__decap_3
XFILLER_28_163 VGND VGND VPWR VPWR sky130_fd_sc_hd__fill_2
XFILLER_16_325 VGND VGND VPWR VPWR sky130_fd_sc_hd__decap_3
XFILLER_31_306 VGND VGND VPWR VPWR sky130_fd_sc_hd__decap_3
XFILLER_43_188 VGND VGND VPWR VPWR sky130_fd_sc_hd__decap_3
XFILLER_61_30 VGND VGND VPWR VPWR sky130_fd_sc_hd__fill_2
XFILLER_61_63 VGND VGND VPWR VPWR sky130_fd_sc_hd__fill_2
XANTENNA_7 net14 VGND VGND VPWR VPWR sky130_fd_sc_hd__diode_2
XFILLER_6_69 VGND VGND VPWR VPWR sky130_fd_sc_hd__decap_3
XFILLER_3_240 VGND VGND VPWR VPWR sky130_fd_sc_hd__decap_3
X_2120_ net745 net731 VGND VGND VPWR VPWR Inst_SimpleCLB_ConfigMem.Inst_frame0_bit3.Q
+ sky130_fd_sc_hd__dlxtp_1
XFILLER_66_203 VGND VGND VPWR VPWR sky130_fd_sc_hd__decap_3
XFILLER_66_214 VGND VGND VPWR VPWR sky130_fd_sc_hd__decap_3
X_2051_ net749 net679 VGND VGND VPWR VPWR Inst_SimpleCLB_ConfigMem.Inst_frame3_bit30.Q
+ sky130_fd_sc_hd__dlxtp_1
X_1002_ Inst_LB_LUT4c_frame_config_dffesr.inst_cus_mux161_buf.A8 _0009_ _0010_ Inst_LB_LUT4c_frame_config_dffesr.inst_cus_mux161_buf.A14
+ _0098_ VGND VGND VPWR VPWR _0099_ sky130_fd_sc_hd__o221a_1
XFILLER_19_185 VGND VGND VPWR VPWR sky130_fd_sc_hd__decap_3
XFILLER_34_188 VGND VGND VPWR VPWR sky130_fd_sc_hd__decap_3
X_1904_ net794 net665 VGND VGND VPWR VPWR Inst_SimpleCLB_ConfigMem.Inst_frame7_bit11.Q
+ sky130_fd_sc_hd__dlxtp_1
X_1835_ net739 net655 VGND VGND VPWR VPWR Inst_SimpleCLB_ConfigMem.Inst_frame9_bit6.Q
+ sky130_fd_sc_hd__dlxtp_1
X_1766_ net776 net720 VGND VGND VPWR VPWR Inst_SimpleCLB_ConfigMem.Inst_frame11_bit1.Q
+ sky130_fd_sc_hd__dlxtp_1
X_1697_ net757 net710 VGND VGND VPWR VPWR Inst_SimpleCLB_ConfigMem.Inst_frame14_bit28.Q
+ sky130_fd_sc_hd__dlxtp_1
X_2318_ Inst_SimpleCLB_switch_matrix.JS2BEG5 VGND VGND VPWR VPWR net163 sky130_fd_sc_hd__buf_6
XFILLER_57_247 VGND VGND VPWR VPWR sky130_fd_sc_hd__decap_3
X_2249_ net719 VGND VGND VPWR VPWR net85 sky130_fd_sc_hd__buf_1
XFILLER_25_166 VGND VGND VPWR VPWR sky130_fd_sc_hd__fill_2
XFILLER_25_188 VGND VGND VPWR VPWR sky130_fd_sc_hd__decap_3
XFILLER_40_103 VGND VGND VPWR VPWR sky130_fd_sc_hd__decap_3
XFILLER_40_136 VGND VGND VPWR VPWR sky130_fd_sc_hd__decap_3
XFILLER_40_158 VGND VGND VPWR VPWR sky130_fd_sc_hd__decap_3
Xoutput9 net9 VGND VGND VPWR VPWR E2BEG[3] sky130_fd_sc_hd__buf_6
Xoutput11 net11 VGND VGND VPWR VPWR E2BEG[5] sky130_fd_sc_hd__buf_6
Xoutput22 net22 VGND VGND VPWR VPWR E6BEG[0] sky130_fd_sc_hd__buf_2
Xoutput33 net33 VGND VGND VPWR VPWR E6BEG[9] sky130_fd_sc_hd__buf_2
Xoutput66 net66 VGND VGND VPWR VPWR FrameData_O[24] sky130_fd_sc_hd__buf_2
Xoutput44 net44 VGND VGND VPWR VPWR EE4BEG[4] sky130_fd_sc_hd__buf_2
Xoutput55 net55 VGND VGND VPWR VPWR FrameData_O[14] sky130_fd_sc_hd__buf_2
Xoutput99 net99 VGND VGND VPWR VPWR FrameStrobe_O[7] sky130_fd_sc_hd__buf_2
Xoutput88 net88 VGND VGND VPWR VPWR FrameStrobe_O[15] sky130_fd_sc_hd__buf_2
Xoutput77 net77 VGND VGND VPWR VPWR FrameData_O[5] sky130_fd_sc_hd__buf_2
XFILLER_48_203 VGND VGND VPWR VPWR sky130_fd_sc_hd__decap_3
XFILLER_48_247 VGND VGND VPWR VPWR sky130_fd_sc_hd__decap_3
XFILLER_63_228 VGND VGND VPWR VPWR sky130_fd_sc_hd__fill_1
XFILLER_56_85 VGND VGND VPWR VPWR sky130_fd_sc_hd__fill_2
X_1620_ net787 net699 VGND VGND VPWR VPWR Inst_LE_LUT4c_frame_config_dffesr.inst_cus_mux161_buf.A1
+ sky130_fd_sc_hd__dlxtp_1
XFILLER_68_6 VGND VGND VPWR VPWR sky130_fd_sc_hd__decap_3
X_1551_ net797 net691 VGND VGND VPWR VPWR Inst_LA_LUT4c_frame_config_dffesr.inst_cus_mux161_buf.A8
+ sky130_fd_sc_hd__dlxtp_1
X_1482_ N2END[1] W6END[0] N4END[0] net609 Inst_SimpleCLB_ConfigMem.Inst_frame13_bit9.Q
+ Inst_SimpleCLB_ConfigMem.Inst_frame13_bit8.Q VGND VGND VPWR VPWR Inst_SimpleCLB_switch_matrix.N4BEG3
+ sky130_fd_sc_hd__mux4_2
XFILLER_39_225 VGND VGND VPWR VPWR sky130_fd_sc_hd__decap_3
X_2103_ net780 net690 VGND VGND VPWR VPWR Inst_SimpleCLB_ConfigMem.Inst_frame1_bit18.Q
+ sky130_fd_sc_hd__dlxtp_1
XTAP_TAPCELL_ROW_37_415 VGND VPWR sky130_fd_sc_hd__tapvpwrvgnd_1
XFILLER_39_269 VGND VGND VPWR VPWR sky130_fd_sc_hd__decap_3
XFILLER_54_206 VGND VGND VPWR VPWR sky130_fd_sc_hd__decap_3
X_2034_ net791 net681 VGND VGND VPWR VPWR Inst_SimpleCLB_ConfigMem.Inst_frame3_bit13.Q
+ sky130_fd_sc_hd__dlxtp_1
XFILLER_54_239 VGND VGND VPWR VPWR sky130_fd_sc_hd__decap_3
XFILLER_62_250 VGND VGND VPWR VPWR sky130_fd_sc_hd__fill_2
XFILLER_10_309 VGND VGND VPWR VPWR sky130_fd_sc_hd__decap_3
XFILLER_30_180 VGND VGND VPWR VPWR sky130_fd_sc_hd__decap_3
X_1818_ net772 net724 VGND VGND VPWR VPWR Inst_SimpleCLB_ConfigMem.Inst_frame10_bit21.Q
+ sky130_fd_sc_hd__dlxtp_1
X_1749_ FrameData[16] net719 VGND VGND VPWR VPWR Inst_SimpleCLB_ConfigMem.Inst_frame12_bit16.Q
+ sky130_fd_sc_hd__dlxtp_1
Xfanout801 E6END[0] VGND VGND VPWR VPWR net801 sky130_fd_sc_hd__buf_2
XFILLER_45_206 VGND VGND VPWR VPWR sky130_fd_sc_hd__decap_3
XANTENNA_216 E1END[2] VGND VGND VPWR VPWR sky130_fd_sc_hd__diode_2
XFILLER_45_228 VGND VGND VPWR VPWR sky130_fd_sc_hd__decap_3
XANTENNA_205 net645 VGND VGND VPWR VPWR sky130_fd_sc_hd__diode_2
XFILLER_26_66 VGND VGND VPWR VPWR sky130_fd_sc_hd__decap_3
XANTENNA_227 net767 VGND VGND VPWR VPWR sky130_fd_sc_hd__diode_2
XFILLER_60_209 VGND VGND VPWR VPWR sky130_fd_sc_hd__decap_3
XFILLER_13_103 VGND VGND VPWR VPWR sky130_fd_sc_hd__decap_3
XFILLER_26_88 VGND VGND VPWR VPWR sky130_fd_sc_hd__decap_3
XFILLER_53_272 VGND VGND VPWR VPWR sky130_fd_sc_hd__decap_3
XFILLER_13_158 VGND VGND VPWR VPWR sky130_fd_sc_hd__decap_3
XFILLER_13_147 VGND VGND VPWR VPWR sky130_fd_sc_hd__decap_3
XFILLER_42_32 VGND VGND VPWR VPWR sky130_fd_sc_hd__decap_3
XTAP_TAPCELL_ROW_51_495 VGND VPWR sky130_fd_sc_hd__tapvpwrvgnd_1
XFILLER_5_346 VGND VGND VPWR VPWR sky130_fd_sc_hd__fill_1
XFILLER_5_335 VGND VGND VPWR VPWR sky130_fd_sc_hd__fill_1
XFILLER_67_51 VGND VGND VPWR VPWR sky130_fd_sc_hd__decap_3
XFILLER_44_283 VGND VGND VPWR VPWR sky130_fd_sc_hd__decap_3
X_0982_ Inst_LC_LUT4c_frame_config_dffesr.inst_cus_mux161_buf.A14 _0057_ _0078_ _0079_
+ VGND VGND VPWR VPWR _0080_ sky130_fd_sc_hd__o211a_1
XTAP_TAPCELL_ROW_42_440 VGND VPWR sky130_fd_sc_hd__tapvpwrvgnd_1
XFILLER_66_3 VGND VGND VPWR VPWR sky130_fd_sc_hd__decap_3
X_1603_ net750 net696 VGND VGND VPWR VPWR Inst_LD_LUT4c_frame_config_dffesr.inst_cus_mux161_buf.A3
+ sky130_fd_sc_hd__dlxtp_1
X_1534_ net393 _0558_ _0556_ VGND VGND VPWR VPWR _0005_ sky130_fd_sc_hd__mux2_1
X_1465_ _0518_ _0520_ _0516_ VGND VGND VPWR VPWR Inst_SimpleCLB_switch_matrix.NN4BEG0
+ sky130_fd_sc_hd__a21oi_1
X_1396_ net648 net802 S1END[3] net646 Inst_SimpleCLB_ConfigMem.Inst_frame12_bit10.Q
+ Inst_SimpleCLB_ConfigMem.Inst_frame12_bit11.Q VGND VGND VPWR VPWR _0460_ sky130_fd_sc_hd__mux4_1
XFILLER_27_228 VGND VGND VPWR VPWR sky130_fd_sc_hd__decap_3
XFILLER_42_209 VGND VGND VPWR VPWR sky130_fd_sc_hd__decap_3
X_2017_ net756 net675 VGND VGND VPWR VPWR Inst_SimpleCLB_ConfigMem.Inst_frame4_bit28.Q
+ sky130_fd_sc_hd__dlxtp_1
XFILLER_50_253 VGND VGND VPWR VPWR sky130_fd_sc_hd__decap_3
XFILLER_10_139 VGND VGND VPWR VPWR sky130_fd_sc_hd__fill_1
XFILLER_12_35 VGND VGND VPWR VPWR sky130_fd_sc_hd__fill_1
Xhold140 Inst_LD_LUT4c_frame_config_dffesr.LUT_flop VGND VGND VPWR VPWR net394 sky130_fd_sc_hd__dlygate4sd3_1
Xfanout631 net632 VGND VGND VPWR VPWR net631 sky130_fd_sc_hd__buf_8
Xfanout620 Inst_LD_LUT4c_frame_config_dffesr.O VGND VGND VPWR VPWR net620 sky130_fd_sc_hd__clkbuf_4
XFILLER_77_106 VGND VGND VPWR VPWR sky130_fd_sc_hd__decap_3
Xfanout642 net644 VGND VGND VPWR VPWR net642 sky130_fd_sc_hd__buf_2
Xfanout653 net654 VGND VGND VPWR VPWR net653 sky130_fd_sc_hd__buf_2
Xfanout675 net678 VGND VGND VPWR VPWR net675 sky130_fd_sc_hd__buf_2
Xfanout664 FrameStrobe[7] VGND VGND VPWR VPWR net664 sky130_fd_sc_hd__clkbuf_2
XFILLER_85_161 VGND VGND VPWR VPWR sky130_fd_sc_hd__decap_3
Xfanout697 FrameStrobe[17] VGND VGND VPWR VPWR net697 sky130_fd_sc_hd__clkbuf_2
Xfanout686 FrameStrobe[2] VGND VGND VPWR VPWR net686 sky130_fd_sc_hd__clkbuf_2
XFILLER_85_172 VGND VGND VPWR VPWR sky130_fd_sc_hd__decap_3
XFILLER_37_87 VGND VGND VPWR VPWR sky130_fd_sc_hd__fill_2
XFILLER_26_294 VGND VGND VPWR VPWR sky130_fd_sc_hd__fill_1
XFILLER_5_187 VGND VGND VPWR VPWR sky130_fd_sc_hd__decap_3
XFILLER_5_165 VGND VGND VPWR VPWR sky130_fd_sc_hd__decap_3
XFILLER_68_117 VGND VGND VPWR VPWR sky130_fd_sc_hd__decap_3
XFILLER_78_61 VGND VGND VPWR VPWR sky130_fd_sc_hd__decap_3
XFILLER_78_94 VGND VGND VPWR VPWR sky130_fd_sc_hd__fill_1
X_1250_ W2END[0] net268 net640 net626 Inst_SimpleCLB_ConfigMem.Inst_frame1_bit23.Q
+ Inst_SimpleCLB_ConfigMem.Inst_frame1_bit22.Q VGND VGND VPWR VPWR _0333_ sky130_fd_sc_hd__mux4_1
X_1181_ _0266_ _0267_ Inst_SimpleCLB_ConfigMem.Inst_frame1_bit20.Q VGND VGND VPWR
+ VPWR _0268_ sky130_fd_sc_hd__mux2_4
XFILLER_76_150 VGND VGND VPWR VPWR sky130_fd_sc_hd__decap_3
XFILLER_64_334 VGND VGND VPWR VPWR sky130_fd_sc_hd__fill_1
XFILLER_76_194 VGND VGND VPWR VPWR sky130_fd_sc_hd__fill_2
XFILLER_17_261 VGND VGND VPWR VPWR sky130_fd_sc_hd__fill_1
XFILLER_32_220 VGND VGND VPWR VPWR sky130_fd_sc_hd__decap_3
XFILLER_32_242 VGND VGND VPWR VPWR sky130_fd_sc_hd__decap_3
XFILLER_32_253 VGND VGND VPWR VPWR sky130_fd_sc_hd__decap_3
X_0965_ net800 S4END[3] SS4END[3] W2END[3] Inst_SimpleCLB_ConfigMem.Inst_frame1_bit2.Q
+ Inst_SimpleCLB_ConfigMem.Inst_frame1_bit3.Q VGND VGND VPWR VPWR _0065_ sky130_fd_sc_hd__mux4_1
X_0896_ _0720_ _0721_ Inst_SimpleCLB_ConfigMem.Inst_frame4_bit12.Q VGND VGND VPWR
+ VPWR _0722_ sky130_fd_sc_hd__mux2_1
Xoutput201 net201 VGND VGND VPWR VPWR SS4BEG[5] sky130_fd_sc_hd__buf_2
Xoutput223 net223 VGND VGND VPWR VPWR W2BEGb[4] sky130_fd_sc_hd__buf_2
Xoutput212 net212 VGND VGND VPWR VPWR W2BEG[1] sky130_fd_sc_hd__clkbuf_4
Xoutput234 net234 VGND VGND VPWR VPWR W6BEG[5] sky130_fd_sc_hd__buf_2
Xoutput245 net245 VGND VGND VPWR VPWR WW4BEG[15] sky130_fd_sc_hd__buf_8
X_1517_ _0704_ Inst_LA_LUT4c_frame_config_dffesr.c_reset_value _0544_ VGND VGND VPWR
+ VPWR _0546_ sky130_fd_sc_hd__mux2_1
X_1448_ Inst_SimpleCLB_ConfigMem.Inst_frame13_bit17.Q _0505_ Inst_SimpleCLB_ConfigMem.Inst_frame13_bit18.Q
+ VGND VGND VPWR VPWR _0506_ sky130_fd_sc_hd__a21oi_1
X_1379_ Inst_SimpleCLB_ConfigMem.Inst_frame11_bit3.Q _0444_ Inst_SimpleCLB_ConfigMem.Inst_frame11_bit4.Q
+ VGND VGND VPWR VPWR _0445_ sky130_fd_sc_hd__o21ai_1
XFILLER_74_19 VGND VGND VPWR VPWR sky130_fd_sc_hd__decap_3
XFILLER_23_231 VGND VGND VPWR VPWR sky130_fd_sc_hd__decap_3
XFILLER_23_253 VGND VGND VPWR VPWR sky130_fd_sc_hd__fill_2
XFILLER_48_42 VGND VGND VPWR VPWR sky130_fd_sc_hd__decap_3
XFILLER_58_150 VGND VGND VPWR VPWR sky130_fd_sc_hd__decap_3
XTAP_TAPCELL_ROW_76_649 VGND VPWR sky130_fd_sc_hd__tapvpwrvgnd_1
XFILLER_0_27 VGND VGND VPWR VPWR sky130_fd_sc_hd__fill_1
XTAP_TAPCELL_ROW_84_693 VGND VPWR sky130_fd_sc_hd__tapvpwrvgnd_1
XFILLER_14_242 VGND VGND VPWR VPWR sky130_fd_sc_hd__decap_3
X_0750_ Inst_SimpleCLB_ConfigMem.Inst_frame2_bit24.Q VGND VGND VPWR VPWR _0586_ sky130_fd_sc_hd__inv_1
XFILLER_50_6 VGND VGND VPWR VPWR sky130_fd_sc_hd__decap_3
X_2351_ SS4END[10] VGND VGND VPWR VPWR net202 sky130_fd_sc_hd__buf_2
X_2282_ N4END[9] VGND VGND VPWR VPWR net133 sky130_fd_sc_hd__clkbuf_1
X_1302_ S1END[0] W1END[0] S2END[0] net647 Inst_SimpleCLB_ConfigMem.Inst_frame4_bit23.Q
+ Inst_SimpleCLB_ConfigMem.Inst_frame4_bit22.Q VGND VGND VPWR VPWR _0379_ sky130_fd_sc_hd__mux4_1
XFILLER_29_3 VGND VGND VPWR VPWR sky130_fd_sc_hd__fill_2
X_1233_ Inst_SimpleCLB_ConfigMem.Inst_frame9_bit8.Q _0711_ VGND VGND VPWR VPWR _0317_
+ sky130_fd_sc_hd__nand2_1
XFILLER_49_183 VGND VGND VPWR VPWR sky130_fd_sc_hd__decap_3
X_1164_ net648 N2END[7] net802 E2END[7] Inst_SimpleCLB_ConfigMem.Inst_frame3_bit18.Q
+ Inst_SimpleCLB_ConfigMem.Inst_frame3_bit19.Q VGND VGND VPWR VPWR _0252_ sky130_fd_sc_hd__mux4_1
XFILLER_64_120 VGND VGND VPWR VPWR sky130_fd_sc_hd__decap_3
X_1095_ _0184_ _0185_ Inst_SimpleCLB_ConfigMem.Inst_frame8_bit2.Q VGND VGND VPWR VPWR
+ _0187_ sky130_fd_sc_hd__mux2_4
XFILLER_52_315 VGND VGND VPWR VPWR sky130_fd_sc_hd__fill_1
XTAP_TAPCELL_ROW_15_281 VGND VPWR sky130_fd_sc_hd__tapvpwrvgnd_1
X_1997_ net735 net675 VGND VGND VPWR VPWR Inst_SimpleCLB_ConfigMem.Inst_frame4_bit8.Q
+ sky130_fd_sc_hd__dlxtp_1
XFILLER_20_256 VGND VGND VPWR VPWR sky130_fd_sc_hd__decap_3
X_0948_ _0045_ _0043_ _0048_ Inst_SimpleCLB_ConfigMem.Inst_frame3_bit13.Q VGND VGND
+ VPWR VPWR Inst_SimpleCLB_switch_matrix.E2BEG4 sky130_fd_sc_hd__o22a_4
X_0879_ net624 net615 net634 net610 Inst_SimpleCLB_ConfigMem.Inst_frame4_bit3.Q Inst_SimpleCLB_ConfigMem.Inst_frame4_bit2.Q
+ VGND VGND VPWR VPWR _0706_ sky130_fd_sc_hd__mux4_1
XFILLER_34_44 VGND VGND VPWR VPWR sky130_fd_sc_hd__decap_3
XFILLER_70_156 VGND VGND VPWR VPWR sky130_fd_sc_hd__decap_3
XTAP_TAPCELL_ROW_81_674 VGND VPWR sky130_fd_sc_hd__tapvpwrvgnd_1
XFILLER_11_223 VGND VGND VPWR VPWR sky130_fd_sc_hd__fill_1
XFILLER_34_77 VGND VGND VPWR VPWR sky130_fd_sc_hd__decap_3
XFILLER_34_88 VGND VGND VPWR VPWR sky130_fd_sc_hd__decap_3
XFILLER_11_234 VGND VGND VPWR VPWR sky130_fd_sc_hd__fill_2
XFILLER_7_216 VGND VGND VPWR VPWR sky130_fd_sc_hd__decap_3
XFILLER_19_334 VGND VGND VPWR VPWR sky130_fd_sc_hd__fill_2
XFILLER_46_120 VGND VGND VPWR VPWR sky130_fd_sc_hd__decap_3
XTAP_TAPCELL_ROW_29_362 VGND VPWR sky130_fd_sc_hd__tapvpwrvgnd_1
XFILLER_75_95 VGND VGND VPWR VPWR sky130_fd_sc_hd__decap_3
XFILLER_61_134 VGND VGND VPWR VPWR sky130_fd_sc_hd__decap_3
XFILLER_61_156 VGND VGND VPWR VPWR sky130_fd_sc_hd__decap_3
XFILLER_61_167 VGND VGND VPWR VPWR sky130_fd_sc_hd__fill_1
X_1920_ net759 net664 VGND VGND VPWR VPWR Inst_SimpleCLB_ConfigMem.Inst_frame7_bit27.Q
+ sky130_fd_sc_hd__dlxtp_1
X_1851_ FrameData[22] net657 VGND VGND VPWR VPWR Inst_SimpleCLB_ConfigMem.Inst_frame9_bit22.Q
+ sky130_fd_sc_hd__dlxtp_1
XTAP_TAPCELL_ROW_12_262 VGND VPWR sky130_fd_sc_hd__tapvpwrvgnd_1
X_0802_ _0566_ _0631_ Inst_SimpleCLB_ConfigMem.Inst_frame10_bit11.Q VGND VGND VPWR
+ VPWR _0635_ sky130_fd_sc_hd__a21oi_1
X_1782_ net783 net722 VGND VGND VPWR VPWR Inst_SimpleCLB_ConfigMem.Inst_frame11_bit17.Q
+ sky130_fd_sc_hd__dlxtp_1
X_0733_ Inst_SimpleCLB_ConfigMem.Inst_frame3_bit0.Q VGND VGND VPWR VPWR _0569_ sky130_fd_sc_hd__inv_1
XFILLER_6_271 VGND VGND VPWR VPWR sky130_fd_sc_hd__fill_1
X_2403_ WW4END[13] VGND VGND VPWR VPWR net254 sky130_fd_sc_hd__clkbuf_2
X_2334_ S4END[9] VGND VGND VPWR VPWR net185 sky130_fd_sc_hd__buf_4
XFILLER_69_223 VGND VGND VPWR VPWR sky130_fd_sc_hd__fill_1
XFILLER_69_256 VGND VGND VPWR VPWR sky130_fd_sc_hd__decap_3
XFILLER_69_278 VGND VGND VPWR VPWR sky130_fd_sc_hd__fill_2
X_2265_ Inst_SimpleCLB_switch_matrix.JN2BEG4 VGND VGND VPWR VPWR net110 sky130_fd_sc_hd__clkbuf_2
X_1216_ Inst_LH_LUT4c_frame_config_dffesr.inst_cus_mux161_buf.A3 _0292_ _0293_ Inst_LH_LUT4c_frame_config_dffesr.inst_cus_mux161_buf.A7
+ VGND VGND VPWR VPWR _0301_ sky130_fd_sc_hd__o22a_1
X_2196_ EE4END[11] VGND VGND VPWR VPWR net47 sky130_fd_sc_hd__clkbuf_1
X_1147_ W2END[7] net639 net644 net630 Inst_SimpleCLB_ConfigMem.Inst_frame2_bit19.Q
+ Inst_SimpleCLB_ConfigMem.Inst_frame2_bit18.Q VGND VGND VPWR VPWR _0236_ sky130_fd_sc_hd__mux4_1
X_1078_ net259 _0167_ VGND VGND VPWR VPWR _0171_ sky130_fd_sc_hd__nand2_1
XTAP_TAPCELL_ROW_35_398 VGND VPWR sky130_fd_sc_hd__tapvpwrvgnd_1
XFILLER_29_44 VGND VGND VPWR VPWR sky130_fd_sc_hd__decap_3
XFILLER_29_99 VGND VGND VPWR VPWR sky130_fd_sc_hd__decap_3
XFILLER_90_218 VGND VGND VPWR VPWR sky130_fd_sc_hd__decap_3
XFILLER_16_315 VGND VGND VPWR VPWR sky130_fd_sc_hd__decap_3
XFILLER_83_281 VGND VGND VPWR VPWR sky130_fd_sc_hd__decap_3
XFILLER_16_337 VGND VGND VPWR VPWR sky130_fd_sc_hd__decap_3
XFILLER_45_43 VGND VGND VPWR VPWR sky130_fd_sc_hd__decap_3
XFILLER_45_65 VGND VGND VPWR VPWR sky130_fd_sc_hd__decap_3
XFILLER_43_167 VGND VGND VPWR VPWR sky130_fd_sc_hd__fill_1
XFILLER_6_15 VGND VGND VPWR VPWR sky130_fd_sc_hd__decap_3
XANTENNA_8 E6END[5] VGND VGND VPWR VPWR sky130_fd_sc_hd__diode_2
XFILLER_3_296 VGND VGND VPWR VPWR sky130_fd_sc_hd__decap_3
X_2050_ net753 net679 VGND VGND VPWR VPWR Inst_SimpleCLB_ConfigMem.Inst_frame3_bit29.Q
+ sky130_fd_sc_hd__dlxtp_1
XFILLER_66_237 VGND VGND VPWR VPWR sky130_fd_sc_hd__fill_1
XFILLER_66_248 VGND VGND VPWR VPWR sky130_fd_sc_hd__decap_3
XFILLER_81_218 VGND VGND VPWR VPWR sky130_fd_sc_hd__decap_3
X_1001_ Inst_LB_LUT4c_frame_config_dffesr.inst_cus_mux161_buf.A12 _0097_ VGND VGND
+ VPWR VPWR _0098_ sky130_fd_sc_hd__or2_1
XFILLER_19_197 VGND VGND VPWR VPWR sky130_fd_sc_hd__decap_3
XFILLER_34_101 VGND VGND VPWR VPWR sky130_fd_sc_hd__decap_3
XFILLER_22_318 VGND VGND VPWR VPWR sky130_fd_sc_hd__fill_1
XFILLER_30_340 VGND VGND VPWR VPWR sky130_fd_sc_hd__decap_3
X_1903_ net796 net665 VGND VGND VPWR VPWR Inst_SimpleCLB_ConfigMem.Inst_frame7_bit10.Q
+ sky130_fd_sc_hd__dlxtp_1
X_1834_ net741 net655 VGND VGND VPWR VPWR Inst_SimpleCLB_ConfigMem.Inst_frame9_bit5.Q
+ sky130_fd_sc_hd__dlxtp_1
X_1765_ net798 net720 VGND VGND VPWR VPWR Inst_SimpleCLB_ConfigMem.Inst_frame11_bit0.Q
+ sky130_fd_sc_hd__dlxtp_1
X_1696_ net758 net710 VGND VGND VPWR VPWR Inst_SimpleCLB_ConfigMem.Inst_frame14_bit27.Q
+ sky130_fd_sc_hd__dlxtp_1
X_2317_ Inst_SimpleCLB_switch_matrix.JS2BEG4 VGND VGND VPWR VPWR net162 sky130_fd_sc_hd__buf_2
X_2248_ net723 VGND VGND VPWR VPWR net84 sky130_fd_sc_hd__clkbuf_2
X_2179_ E6END[4] VGND VGND VPWR VPWR net26 sky130_fd_sc_hd__buf_1
XFILLER_65_281 VGND VGND VPWR VPWR sky130_fd_sc_hd__decap_3
XFILLER_80_240 VGND VGND VPWR VPWR sky130_fd_sc_hd__decap_3
XFILLER_40_115 VGND VGND VPWR VPWR sky130_fd_sc_hd__decap_3
XFILLER_31_45 VGND VGND VPWR VPWR sky130_fd_sc_hd__decap_3
Xoutput12 net12 VGND VGND VPWR VPWR E2BEG[6] sky130_fd_sc_hd__buf_8
Xoutput34 net34 VGND VGND VPWR VPWR EE4BEG[0] sky130_fd_sc_hd__buf_2
Xoutput23 net23 VGND VGND VPWR VPWR E6BEG[10] sky130_fd_sc_hd__buf_6
Xoutput67 net67 VGND VGND VPWR VPWR FrameData_O[25] sky130_fd_sc_hd__buf_2
XFILLER_0_211 VGND VGND VPWR VPWR sky130_fd_sc_hd__fill_1
Xoutput45 net45 VGND VGND VPWR VPWR EE4BEG[5] sky130_fd_sc_hd__buf_2
Xoutput56 net56 VGND VGND VPWR VPWR FrameData_O[15] sky130_fd_sc_hd__buf_2
Xoutput89 net89 VGND VGND VPWR VPWR FrameStrobe_O[16] sky130_fd_sc_hd__buf_2
XFILLER_0_222 VGND VGND VPWR VPWR sky130_fd_sc_hd__fill_2
Xoutput78 net78 VGND VGND VPWR VPWR FrameData_O[6] sky130_fd_sc_hd__buf_2
XFILLER_48_215 VGND VGND VPWR VPWR sky130_fd_sc_hd__decap_3
XFILLER_71_240 VGND VGND VPWR VPWR sky130_fd_sc_hd__decap_3
XFILLER_71_262 VGND VGND VPWR VPWR sky130_fd_sc_hd__decap_3
XFILLER_72_41 VGND VGND VPWR VPWR sky130_fd_sc_hd__decap_3
XFILLER_71_295 VGND VGND VPWR VPWR sky130_fd_sc_hd__decap_3
XFILLER_72_85 VGND VGND VPWR VPWR sky130_fd_sc_hd__fill_2
XFILLER_8_344 VGND VGND VPWR VPWR sky130_fd_sc_hd__decap_3
X_1550_ net734 net692 VGND VGND VPWR VPWR Inst_LA_LUT4c_frame_config_dffesr.inst_cus_mux161_buf.A7
+ sky130_fd_sc_hd__dlxtp_1
X_1481_ net617 Inst_SimpleCLB_switch_matrix.JN2BEG3 _0076_ _0040_ Inst_SimpleCLB_ConfigMem.Inst_frame13_bit23.Q
+ Inst_SimpleCLB_ConfigMem.Inst_frame13_bit22.Q VGND VGND VPWR VPWR Inst_SimpleCLB_switch_matrix.E1BEG0
+ sky130_fd_sc_hd__mux4_1
XFILLER_39_248 VGND VGND VPWR VPWR sky130_fd_sc_hd__decap_3
X_2102_ net782 net689 VGND VGND VPWR VPWR Inst_SimpleCLB_ConfigMem.Inst_frame1_bit17.Q
+ sky130_fd_sc_hd__dlxtp_1
XFILLER_54_218 VGND VGND VPWR VPWR sky130_fd_sc_hd__decap_3
X_2033_ net792 net681 VGND VGND VPWR VPWR Inst_SimpleCLB_ConfigMem.Inst_frame3_bit12.Q
+ sky130_fd_sc_hd__dlxtp_1
XFILLER_47_281 VGND VGND VPWR VPWR sky130_fd_sc_hd__decap_3
XTAP_TAPCELL_ROW_45_460 VGND VPWR sky130_fd_sc_hd__tapvpwrvgnd_1
X_1817_ net775 net724 VGND VGND VPWR VPWR Inst_SimpleCLB_ConfigMem.Inst_frame10_bit20.Q
+ sky130_fd_sc_hd__dlxtp_1
XFILLER_30_192 VGND VGND VPWR VPWR sky130_fd_sc_hd__decap_3
X_1748_ net786 net719 VGND VGND VPWR VPWR Inst_SimpleCLB_ConfigMem.Inst_frame12_bit15.Q
+ sky130_fd_sc_hd__dlxtp_1
X_1679_ net797 net708 VGND VGND VPWR VPWR Inst_LH_LUT4c_frame_config_dffesr.inst_cus_mux161_buf.A3
+ sky130_fd_sc_hd__dlxtp_1
Xfanout802 E1END[3] VGND VGND VPWR VPWR net802 sky130_fd_sc_hd__clkbuf_4
XFILLER_38_270 VGND VGND VPWR VPWR sky130_fd_sc_hd__decap_3
XANTENNA_206 net651 VGND VGND VPWR VPWR sky130_fd_sc_hd__diode_2
XTAP_TAPCELL_ROW_68_596 VGND VPWR sky130_fd_sc_hd__tapvpwrvgnd_1
XANTENNA_217 EE4END[11] VGND VGND VPWR VPWR sky130_fd_sc_hd__diode_2
XANTENNA_228 E1END[0] VGND VGND VPWR VPWR sky130_fd_sc_hd__diode_2
XFILLER_53_284 VGND VGND VPWR VPWR sky130_fd_sc_hd__decap_3
XFILLER_42_77 VGND VGND VPWR VPWR sky130_fd_sc_hd__decap_3
XTAP_TAPCELL_ROW_51_496 VGND VPWR sky130_fd_sc_hd__tapvpwrvgnd_1
XFILLER_42_88 VGND VGND VPWR VPWR sky130_fd_sc_hd__decap_3
XFILLER_88_181 VGND VGND VPWR VPWR sky130_fd_sc_hd__decap_3
XFILLER_67_74 VGND VGND VPWR VPWR sky130_fd_sc_hd__decap_3
XFILLER_44_240 VGND VGND VPWR VPWR sky130_fd_sc_hd__decap_3
XFILLER_44_295 VGND VGND VPWR VPWR sky130_fd_sc_hd__fill_1
X_0981_ Inst_LC_LUT4c_frame_config_dffesr.inst_cus_mux161_buf.A12 _0053_ _0054_ Inst_LC_LUT4c_frame_config_dffesr.inst_cus_mux161_buf.A10
+ VGND VGND VPWR VPWR _0079_ sky130_fd_sc_hd__o22a_1
XTAP_TAPCELL_ROW_42_441 VGND VPWR sky130_fd_sc_hd__tapvpwrvgnd_1
XFILLER_12_181 VGND VGND VPWR VPWR sky130_fd_sc_hd__decap_3
XFILLER_8_141 VGND VGND VPWR VPWR sky130_fd_sc_hd__decap_3
X_1602_ net754 net696 VGND VGND VPWR VPWR Inst_LD_LUT4c_frame_config_dffesr.inst_cus_mux161_buf.A2
+ sky130_fd_sc_hd__dlxtp_1
XFILLER_59_3 VGND VGND VPWR VPWR sky130_fd_sc_hd__decap_3
X_1533_ Inst_LE_LUT4c_frame_config_dffesr.c_reset_value _0217_ _0557_ VGND VGND VPWR
+ VPWR _0558_ sky130_fd_sc_hd__mux2_1
X_1464_ Inst_SimpleCLB_ConfigMem.Inst_frame13_bit11.Q _0519_ Inst_SimpleCLB_ConfigMem.Inst_frame13_bit12.Q
+ VGND VGND VPWR VPWR _0520_ sky130_fd_sc_hd__a21oi_1
XFILLER_86_107 VGND VGND VPWR VPWR sky130_fd_sc_hd__fill_2
X_1395_ Inst_SimpleCLB_ConfigMem.Inst_frame12_bit17.Q _0455_ _0459_ _0458_ VGND VGND
+ VPWR VPWR Inst_SimpleCLB_switch_matrix.E6BEG1 sky130_fd_sc_hd__a2bb2o_4
XFILLER_82_346 VGND VGND VPWR VPWR sky130_fd_sc_hd__fill_1
X_2016_ net758 net678 VGND VGND VPWR VPWR Inst_SimpleCLB_ConfigMem.Inst_frame4_bit27.Q
+ sky130_fd_sc_hd__dlxtp_1
XFILLER_50_265 VGND VGND VPWR VPWR sky130_fd_sc_hd__fill_1
XFILLER_12_69 VGND VGND VPWR VPWR sky130_fd_sc_hd__decap_3
XFILLER_12_47 VGND VGND VPWR VPWR sky130_fd_sc_hd__decap_3
XFILLER_88_29 VGND VGND VPWR VPWR sky130_fd_sc_hd__decap_3
Xhold141 Inst_LA_LUT4c_frame_config_dffesr.LUT_flop VGND VGND VPWR VPWR net395 sky130_fd_sc_hd__dlygate4sd3_1
Xfanout610 net611 VGND VGND VPWR VPWR net610 sky130_fd_sc_hd__buf_8
Xfanout621 net623 VGND VGND VPWR VPWR net621 sky130_fd_sc_hd__buf_2
Xfanout632 net635 VGND VGND VPWR VPWR net632 sky130_fd_sc_hd__buf_8
Xfanout643 net644 VGND VGND VPWR VPWR net643 sky130_fd_sc_hd__clkbuf_2
Xfanout654 N1END[0] VGND VGND VPWR VPWR net654 sky130_fd_sc_hd__clkbuf_2
Xfanout665 FrameStrobe[7] VGND VGND VPWR VPWR net665 sky130_fd_sc_hd__clkbuf_2
Xfanout676 net677 VGND VGND VPWR VPWR net676 sky130_fd_sc_hd__clkbuf_2
XFILLER_85_140 VGND VGND VPWR VPWR sky130_fd_sc_hd__fill_1
Xfanout687 net688 VGND VGND VPWR VPWR net687 sky130_fd_sc_hd__clkbuf_2
Xfanout698 net702 VGND VGND VPWR VPWR net698 sky130_fd_sc_hd__clkbuf_2
XFILLER_73_302 VGND VGND VPWR VPWR sky130_fd_sc_hd__fill_1
XFILLER_37_55 VGND VGND VPWR VPWR sky130_fd_sc_hd__fill_1
XFILLER_37_66 VGND VGND VPWR VPWR sky130_fd_sc_hd__decap_3
XFILLER_73_346 VGND VGND VPWR VPWR sky130_fd_sc_hd__fill_1
XFILLER_26_251 VGND VGND VPWR VPWR sky130_fd_sc_hd__fill_1
XFILLER_41_232 VGND VGND VPWR VPWR sky130_fd_sc_hd__fill_2
XFILLER_53_54 VGND VGND VPWR VPWR sky130_fd_sc_hd__fill_2
XFILLER_5_111 VGND VGND VPWR VPWR sky130_fd_sc_hd__fill_1
XFILLER_5_144 VGND VGND VPWR VPWR sky130_fd_sc_hd__decap_3
XFILLER_5_199 VGND VGND VPWR VPWR sky130_fd_sc_hd__decap_3
X_1180_ net618 net624 net634 net363 Inst_SimpleCLB_ConfigMem.Inst_frame1_bit18.Q Inst_SimpleCLB_ConfigMem.Inst_frame1_bit19.Q
+ VGND VGND VPWR VPWR _0267_ sky130_fd_sc_hd__mux4_1
XFILLER_32_265 VGND VGND VPWR VPWR sky130_fd_sc_hd__decap_3
X_0964_ net652 N2END[3] net649 EE4END[3] Inst_SimpleCLB_ConfigMem.Inst_frame1_bit3.Q
+ Inst_SimpleCLB_ConfigMem.Inst_frame1_bit2.Q VGND VGND VPWR VPWR _0064_ sky130_fd_sc_hd__mux4_1
X_0895_ S1END[1] S2END[5] W1END[1] net646 Inst_SimpleCLB_ConfigMem.Inst_frame4_bit10.Q
+ Inst_SimpleCLB_ConfigMem.Inst_frame4_bit11.Q VGND VGND VPWR VPWR _0721_ sky130_fd_sc_hd__mux4_1
Xoutput213 net213 VGND VGND VPWR VPWR W2BEG[2] sky130_fd_sc_hd__buf_6
Xoutput202 net202 VGND VGND VPWR VPWR SS4BEG[6] sky130_fd_sc_hd__buf_2
Xoutput224 net224 VGND VGND VPWR VPWR W2BEGb[5] sky130_fd_sc_hd__buf_2
Xoutput235 net235 VGND VGND VPWR VPWR W6BEG[6] sky130_fd_sc_hd__buf_2
X_1516_ Inst_SimpleCLB_ConfigMem.Inst_frame10_bit19.Q _0530_ VGND VGND VPWR VPWR _0545_
+ sky130_fd_sc_hd__nand2_1
Xoutput246 net246 VGND VGND VPWR VPWR WW4BEG[1] sky130_fd_sc_hd__buf_2
X_1447_ W1END[0] net638 Inst_SimpleCLB_ConfigMem.Inst_frame13_bit16.Q VGND VGND VPWR
+ VPWR _0505_ sky130_fd_sc_hd__mux2_1
X_1378_ _0443_ VGND VGND VPWR VPWR _0444_ sky130_fd_sc_hd__inv_1
XFILLER_55_346 VGND VGND VPWR VPWR sky130_fd_sc_hd__fill_1
XFILLER_23_210 VGND VGND VPWR VPWR sky130_fd_sc_hd__decap_3
XFILLER_48_21 VGND VGND VPWR VPWR sky130_fd_sc_hd__decap_3
XFILLER_48_54 VGND VGND VPWR VPWR sky130_fd_sc_hd__decap_3
XFILLER_48_76 VGND VGND VPWR VPWR sky130_fd_sc_hd__decap_3
XFILLER_73_110 VGND VGND VPWR VPWR sky130_fd_sc_hd__fill_2
XFILLER_58_195 VGND VGND VPWR VPWR sky130_fd_sc_hd__fill_1
XFILLER_61_305 VGND VGND VPWR VPWR sky130_fd_sc_hd__fill_2
XFILLER_73_165 VGND VGND VPWR VPWR sky130_fd_sc_hd__decap_3
XTAP_TAPCELL_ROW_84_694 VGND VPWR sky130_fd_sc_hd__tapvpwrvgnd_1
XFILLER_14_298 VGND VGND VPWR VPWR sky130_fd_sc_hd__decap_3
XFILLER_80_41 VGND VGND VPWR VPWR sky130_fd_sc_hd__fill_1
XFILLER_80_63 VGND VGND VPWR VPWR sky130_fd_sc_hd__decap_3
XFILLER_43_6 VGND VGND VPWR VPWR sky130_fd_sc_hd__decap_3
X_2350_ SS4END[9] VGND VGND VPWR VPWR net201 sky130_fd_sc_hd__buf_2
X_2281_ N4END[8] VGND VGND VPWR VPWR net132 sky130_fd_sc_hd__clkbuf_1
X_1301_ net654 E1END[0] N2END[0] EE4END[0] Inst_SimpleCLB_ConfigMem.Inst_frame4_bit23.Q
+ Inst_SimpleCLB_ConfigMem.Inst_frame4_bit22.Q VGND VGND VPWR VPWR _0378_ sky130_fd_sc_hd__mux4_1
X_1232_ Inst_SimpleCLB_ConfigMem.Inst_frame9_bit9.Q _0315_ VGND VGND VPWR VPWR _0316_
+ sky130_fd_sc_hd__nor2_1
XFILLER_49_151 VGND VGND VPWR VPWR sky130_fd_sc_hd__decap_3
X_1163_ _0250_ Inst_SimpleCLB_ConfigMem.Inst_frame3_bit20.Q Inst_SimpleCLB_ConfigMem.Inst_frame3_bit21.Q
+ VGND VGND VPWR VPWR _0251_ sky130_fd_sc_hd__a21boi_1
XFILLER_49_195 VGND VGND VPWR VPWR sky130_fd_sc_hd__decap_3
XFILLER_64_132 VGND VGND VPWR VPWR sky130_fd_sc_hd__decap_3
X_1094_ _0176_ _0175_ Inst_SimpleCLB_ConfigMem.Inst_frame8_bit2.Q VGND VGND VPWR VPWR
+ _0186_ sky130_fd_sc_hd__mux2_4
XFILLER_52_305 VGND VGND VPWR VPWR sky130_fd_sc_hd__decap_3
XFILLER_20_224 VGND VGND VPWR VPWR sky130_fd_sc_hd__decap_3
XTAP_TAPCELL_ROW_15_282 VGND VPWR sky130_fd_sc_hd__tapvpwrvgnd_1
X_1996_ net737 net675 VGND VGND VPWR VPWR Inst_SimpleCLB_ConfigMem.Inst_frame4_bit7.Q
+ sky130_fd_sc_hd__dlxtp_1
X_0947_ _0046_ _0047_ Inst_SimpleCLB_ConfigMem.Inst_frame3_bit12.Q VGND VGND VPWR
+ VPWR _0048_ sky130_fd_sc_hd__mux2_1
XFILLER_20_268 VGND VGND VPWR VPWR sky130_fd_sc_hd__decap_3
X_0878_ WW4END[1] net639 net643 net620 Inst_SimpleCLB_ConfigMem.Inst_frame4_bit3.Q
+ Inst_SimpleCLB_ConfigMem.Inst_frame4_bit2.Q VGND VGND VPWR VPWR _0705_ sky130_fd_sc_hd__mux4_1
XFILLER_28_302 VGND VGND VPWR VPWR sky130_fd_sc_hd__fill_2
XFILLER_18_57 VGND VGND VPWR VPWR sky130_fd_sc_hd__decap_3
XFILLER_55_121 VGND VGND VPWR VPWR sky130_fd_sc_hd__decap_3
XFILLER_18_79 VGND VGND VPWR VPWR sky130_fd_sc_hd__decap_3
XFILLER_43_316 VGND VGND VPWR VPWR sky130_fd_sc_hd__fill_1
XFILLER_55_165 VGND VGND VPWR VPWR sky130_fd_sc_hd__decap_3
XFILLER_55_176 VGND VGND VPWR VPWR sky130_fd_sc_hd__decap_3
XFILLER_34_12 VGND VGND VPWR VPWR sky130_fd_sc_hd__decap_3
XFILLER_70_168 VGND VGND VPWR VPWR sky130_fd_sc_hd__decap_3
XFILLER_11_202 VGND VGND VPWR VPWR sky130_fd_sc_hd__decap_3
XFILLER_34_56 VGND VGND VPWR VPWR sky130_fd_sc_hd__decap_3
XTAP_TAPCELL_ROW_81_675 VGND VPWR sky130_fd_sc_hd__tapvpwrvgnd_1
XFILLER_11_279 VGND VGND VPWR VPWR sky130_fd_sc_hd__fill_1
XFILLER_11_268 VGND VGND VPWR VPWR sky130_fd_sc_hd__fill_2
XFILLER_7_228 VGND VGND VPWR VPWR sky130_fd_sc_hd__decap_3
XFILLER_50_88 VGND VGND VPWR VPWR sky130_fd_sc_hd__decap_3
XFILLER_78_246 VGND VGND VPWR VPWR sky130_fd_sc_hd__decap_3
XFILLER_19_346 VGND VGND VPWR VPWR sky130_fd_sc_hd__fill_1
XTAP_TAPCELL_ROW_29_363 VGND VPWR sky130_fd_sc_hd__tapvpwrvgnd_1
XTAP_TAPCELL_ROW_72_620 VGND VPWR sky130_fd_sc_hd__tapvpwrvgnd_1
X_1850_ net771 net657 VGND VGND VPWR VPWR Inst_SimpleCLB_ConfigMem.Inst_frame9_bit21.Q
+ sky130_fd_sc_hd__dlxtp_1
X_0801_ _0566_ _0632_ VGND VGND VPWR VPWR _0634_ sky130_fd_sc_hd__or2_1
X_1781_ net785 net722 VGND VGND VPWR VPWR Inst_SimpleCLB_ConfigMem.Inst_frame11_bit16.Q
+ sky130_fd_sc_hd__dlxtp_1
XTAP_TAPCELL_ROW_12_263 VGND VPWR sky130_fd_sc_hd__tapvpwrvgnd_1
X_0732_ Inst_SimpleCLB_ConfigMem.Inst_frame3_bit9.Q VGND VGND VPWR VPWR _0568_ sky130_fd_sc_hd__inv_1
X_2402_ WW4END[12] VGND VGND VPWR VPWR net253 sky130_fd_sc_hd__clkbuf_2
XFILLER_41_3 VGND VGND VPWR VPWR sky130_fd_sc_hd__decap_3
X_2333_ S4END[8] VGND VGND VPWR VPWR net184 sky130_fd_sc_hd__buf_4
X_2264_ Inst_SimpleCLB_switch_matrix.JN2BEG3 VGND VGND VPWR VPWR net109 sky130_fd_sc_hd__buf_2
X_1215_ net313 VGND VGND VPWR VPWR _0300_ sky130_fd_sc_hd__inv_2
X_2195_ EE4END[10] VGND VGND VPWR VPWR net46 sky130_fd_sc_hd__clkbuf_1
X_1146_ net618 net624 net634 net316 Inst_SimpleCLB_ConfigMem.Inst_frame2_bit18.Q Inst_SimpleCLB_ConfigMem.Inst_frame2_bit19.Q
+ VGND VGND VPWR VPWR _0235_ sky130_fd_sc_hd__mux4_2
XFILLER_1_93 VGND VGND VPWR VPWR sky130_fd_sc_hd__decap_3
X_1077_ net259 _0167_ VGND VGND VPWR VPWR _0170_ sky130_fd_sc_hd__and2_1
XTAP_TAPCELL_ROW_35_399 VGND VPWR sky130_fd_sc_hd__tapvpwrvgnd_1
X_1979_ net768 net674 VGND VGND VPWR VPWR Inst_SimpleCLB_ConfigMem.Inst_frame5_bit22.Q
+ sky130_fd_sc_hd__dlxtp_1
XFILLER_4_209 VGND VGND VPWR VPWR sky130_fd_sc_hd__fill_2
XFILLER_20_69 VGND VGND VPWR VPWR sky130_fd_sc_hd__decap_3
XFILLER_75_205 VGND VGND VPWR VPWR sky130_fd_sc_hd__decap_3
XFILLER_28_121 VGND VGND VPWR VPWR sky130_fd_sc_hd__decap_3
XFILLER_75_249 VGND VGND VPWR VPWR sky130_fd_sc_hd__decap_3
XFILLER_43_113 VGND VGND VPWR VPWR sky130_fd_sc_hd__fill_1
XFILLER_45_55 VGND VGND VPWR VPWR sky130_fd_sc_hd__fill_1
XTAP_TAPCELL_ROW_26_344 VGND VPWR sky130_fd_sc_hd__tapvpwrvgnd_1
XFILLER_61_21 VGND VGND VPWR VPWR sky130_fd_sc_hd__decap_3
XFILLER_61_87 VGND VGND VPWR VPWR sky130_fd_sc_hd__decap_3
XANTENNA_9 E6END[7] VGND VGND VPWR VPWR sky130_fd_sc_hd__diode_2
XFILLER_6_27 VGND VGND VPWR VPWR sky130_fd_sc_hd__fill_1
XFILLER_3_231 VGND VGND VPWR VPWR sky130_fd_sc_hd__decap_3
XFILLER_19_165 VGND VGND VPWR VPWR sky130_fd_sc_hd__decap_3
XFILLER_19_143 VGND VGND VPWR VPWR sky130_fd_sc_hd__decap_3
X_1000_ _0727_ _0728_ VGND VGND VPWR VPWR _0097_ sky130_fd_sc_hd__nand2b_1
X_1902_ net733 net663 VGND VGND VPWR VPWR Inst_SimpleCLB_ConfigMem.Inst_frame7_bit9.Q
+ sky130_fd_sc_hd__dlxtp_1
XFILLER_89_3 VGND VGND VPWR VPWR sky130_fd_sc_hd__fill_1
X_1833_ net743 net655 VGND VGND VPWR VPWR Inst_SimpleCLB_ConfigMem.Inst_frame9_bit4.Q
+ sky130_fd_sc_hd__dlxtp_1
X_1764_ net747 net716 VGND VGND VPWR VPWR Inst_SimpleCLB_ConfigMem.Inst_frame12_bit31.Q
+ sky130_fd_sc_hd__dlxtp_1
X_1695_ net760 net710 VGND VGND VPWR VPWR Inst_SimpleCLB_ConfigMem.Inst_frame14_bit26.Q
+ sky130_fd_sc_hd__dlxtp_1
X_2316_ Inst_SimpleCLB_switch_matrix.JS2BEG3 VGND VGND VPWR VPWR net161 sky130_fd_sc_hd__clkbuf_1
X_2247_ net728 VGND VGND VPWR VPWR net83 sky130_fd_sc_hd__buf_1
XPHY_EDGE_ROW_69_Left_160 VGND VGND VPWR VPWR sky130_fd_sc_hd__decap_3
X_2178_ E6END[3] VGND VGND VPWR VPWR net25 sky130_fd_sc_hd__buf_1
XFILLER_25_113 VGND VGND VPWR VPWR sky130_fd_sc_hd__decap_3
XTAP_TAPCELL_ROW_48_480 VGND VPWR sky130_fd_sc_hd__tapvpwrvgnd_1
X_1129_ net618 net624 net633 net610 Inst_SimpleCLB_ConfigMem.Inst_frame4_bit18.Q Inst_SimpleCLB_ConfigMem.Inst_frame4_bit19.Q
+ VGND VGND VPWR VPWR _0219_ sky130_fd_sc_hd__mux4_1
XFILLER_15_69 VGND VGND VPWR VPWR sky130_fd_sc_hd__fill_2
XFILLER_40_127 VGND VGND VPWR VPWR sky130_fd_sc_hd__decap_3
XFILLER_31_57 VGND VGND VPWR VPWR sky130_fd_sc_hd__decap_3
XFILLER_31_79 VGND VGND VPWR VPWR sky130_fd_sc_hd__fill_1
Xoutput13 Inst_SimpleCLB_switch_matrix.E2BEG7 VGND VGND VPWR VPWR E2BEG[7] sky130_fd_sc_hd__buf_6
Xoutput24 Inst_SimpleCLB_switch_matrix.E6BEG1 VGND VGND VPWR VPWR E6BEG[11] sky130_fd_sc_hd__buf_8
Xoutput46 net46 VGND VGND VPWR VPWR EE4BEG[6] sky130_fd_sc_hd__buf_2
Xoutput35 net35 VGND VGND VPWR VPWR EE4BEG[10] sky130_fd_sc_hd__buf_2
Xoutput57 net57 VGND VGND VPWR VPWR FrameData_O[16] sky130_fd_sc_hd__buf_2
Xoutput79 net79 VGND VGND VPWR VPWR FrameData_O[7] sky130_fd_sc_hd__buf_2
Xoutput68 net68 VGND VGND VPWR VPWR FrameData_O[26] sky130_fd_sc_hd__buf_2
XFILLER_56_32 VGND VGND VPWR VPWR sky130_fd_sc_hd__decap_3
XFILLER_56_54 VGND VGND VPWR VPWR sky130_fd_sc_hd__fill_1
XFILLER_56_76 VGND VGND VPWR VPWR sky130_fd_sc_hd__decap_3
XFILLER_56_282 VGND VGND VPWR VPWR sky130_fd_sc_hd__decap_3
XPHY_EDGE_ROW_19_Right_19 VGND VGND VPWR VPWR sky130_fd_sc_hd__decap_3
XFILLER_16_168 VGND VGND VPWR VPWR sky130_fd_sc_hd__decap_3
XFILLER_31_116 VGND VGND VPWR VPWR sky130_fd_sc_hd__decap_3
XFILLER_72_53 VGND VGND VPWR VPWR sky130_fd_sc_hd__decap_3
XFILLER_8_334 VGND VGND VPWR VPWR sky130_fd_sc_hd__decap_3
XPHY_EDGE_ROW_28_Right_28 VGND VGND VPWR VPWR sky130_fd_sc_hd__decap_3
X_1480_ net623 _0126_ Inst_SimpleCLB_switch_matrix.JN2BEG0 _0142_ Inst_SimpleCLB_ConfigMem.Inst_frame13_bit24.Q
+ Inst_SimpleCLB_ConfigMem.Inst_frame13_bit25.Q VGND VGND VPWR VPWR Inst_SimpleCLB_switch_matrix.E1BEG1
+ sky130_fd_sc_hd__mux4_1
X_2101_ net784 net689 VGND VGND VPWR VPWR Inst_SimpleCLB_ConfigMem.Inst_frame1_bit16.Q
+ sky130_fd_sc_hd__dlxtp_1
X_2032_ net794 net681 VGND VGND VPWR VPWR Inst_SimpleCLB_ConfigMem.Inst_frame3_bit11.Q
+ sky130_fd_sc_hd__dlxtp_1
XPHY_EDGE_ROW_37_Right_37 VGND VGND VPWR VPWR sky130_fd_sc_hd__decap_3
XFILLER_47_293 VGND VGND VPWR VPWR sky130_fd_sc_hd__decap_3
XFILLER_62_241 VGND VGND VPWR VPWR sky130_fd_sc_hd__decap_3
XTAP_TAPCELL_ROW_45_461 VGND VPWR sky130_fd_sc_hd__tapvpwrvgnd_1
XFILLER_22_138 VGND VGND VPWR VPWR sky130_fd_sc_hd__fill_2
XFILLER_15_190 VGND VGND VPWR VPWR sky130_fd_sc_hd__decap_3
XFILLER_30_171 VGND VGND VPWR VPWR sky130_fd_sc_hd__decap_3
X_1816_ net779 net725 VGND VGND VPWR VPWR Inst_SimpleCLB_ConfigMem.Inst_frame10_bit19.Q
+ sky130_fd_sc_hd__dlxtp_1
XPHY_EDGE_ROW_46_Right_46 VGND VGND VPWR VPWR sky130_fd_sc_hd__decap_3
X_1747_ net788 net719 VGND VGND VPWR VPWR Inst_SimpleCLB_ConfigMem.Inst_frame12_bit14.Q
+ sky130_fd_sc_hd__dlxtp_1
X_1678_ FrameData[9] net707 VGND VGND VPWR VPWR Inst_LH_LUT4c_frame_config_dffesr.inst_cus_mux161_buf.A2
+ sky130_fd_sc_hd__dlxtp_1
XPHY_EDGE_ROW_55_Right_55 VGND VGND VPWR VPWR sky130_fd_sc_hd__decap_3
XANTENNA_207 net651 VGND VGND VPWR VPWR sky130_fd_sc_hd__diode_2
XTAP_TAPCELL_ROW_68_597 VGND VPWR sky130_fd_sc_hd__tapvpwrvgnd_1
XANTENNA_229 net248 VGND VGND VPWR VPWR sky130_fd_sc_hd__diode_2
XFILLER_53_230 VGND VGND VPWR VPWR sky130_fd_sc_hd__decap_3
XANTENNA_218 net55 VGND VGND VPWR VPWR sky130_fd_sc_hd__diode_2
XFILLER_13_138 VGND VGND VPWR VPWR sky130_fd_sc_hd__decap_3
XFILLER_53_296 VGND VGND VPWR VPWR sky130_fd_sc_hd__decap_3
XTAP_TAPCELL_ROW_51_497 VGND VPWR sky130_fd_sc_hd__tapvpwrvgnd_1
XPHY_EDGE_ROW_64_Right_64 VGND VGND VPWR VPWR sky130_fd_sc_hd__decap_3
XFILLER_5_337 VGND VGND VPWR VPWR sky130_fd_sc_hd__decap_3
XFILLER_3_39 VGND VGND VPWR VPWR sky130_fd_sc_hd__fill_2
XFILLER_67_42 VGND VGND VPWR VPWR sky130_fd_sc_hd__decap_3
XPHY_EDGE_ROW_73_Right_73 VGND VGND VPWR VPWR sky130_fd_sc_hd__decap_3
XTAP_TAPCELL_ROW_59_542 VGND VPWR sky130_fd_sc_hd__tapvpwrvgnd_1
XFILLER_67_86 VGND VGND VPWR VPWR sky130_fd_sc_hd__fill_1
XFILLER_29_260 VGND VGND VPWR VPWR sky130_fd_sc_hd__decap_3
XFILLER_83_52 VGND VGND VPWR VPWR sky130_fd_sc_hd__decap_3
XPHY_EDGE_ROW_82_Right_82 VGND VGND VPWR VPWR sky130_fd_sc_hd__decap_3
X_0980_ Inst_LC_LUT4c_frame_config_dffesr.inst_cus_mux161_buf.A8 _0056_ VGND VGND
+ VPWR VPWR _0078_ sky130_fd_sc_hd__or2_1
XTAP_TAPCELL_ROW_42_442 VGND VPWR sky130_fd_sc_hd__tapvpwrvgnd_1
XFILLER_12_193 VGND VGND VPWR VPWR sky130_fd_sc_hd__decap_3
XFILLER_8_197 VGND VGND VPWR VPWR sky130_fd_sc_hd__decap_3
XFILLER_8_164 VGND VGND VPWR VPWR sky130_fd_sc_hd__decap_3
X_1601_ net757 net696 VGND VGND VPWR VPWR Inst_LD_LUT4c_frame_config_dffesr.inst_cus_mux161_buf.A1
+ sky130_fd_sc_hd__dlxtp_1
X_1532_ Inst_SimpleCLB_ConfigMem.Inst_frame9_bit26.Q _0539_ VGND VGND VPWR VPWR _0557_
+ sky130_fd_sc_hd__nand2_1
X_1463_ net647 net634 Inst_SimpleCLB_ConfigMem.Inst_frame13_bit10.Q VGND VGND VPWR
+ VPWR _0519_ sky130_fd_sc_hd__mux2_1
X_1394_ _0456_ _0599_ Inst_SimpleCLB_ConfigMem.Inst_frame12_bit17.Q VGND VGND VPWR
+ VPWR _0459_ sky130_fd_sc_hd__o21a_1
XFILLER_27_219 VGND VGND VPWR VPWR sky130_fd_sc_hd__decap_3
X_2015_ net760 net678 VGND VGND VPWR VPWR Inst_SimpleCLB_ConfigMem.Inst_frame4_bit26.Q
+ sky130_fd_sc_hd__dlxtp_1
XFILLER_35_252 VGND VGND VPWR VPWR sky130_fd_sc_hd__fill_1
XFILLER_50_200 VGND VGND VPWR VPWR sky130_fd_sc_hd__fill_2
XTAP_TAPCELL_ROW_65_578 VGND VPWR sky130_fd_sc_hd__tapvpwrvgnd_1
XFILLER_50_244 VGND VGND VPWR VPWR sky130_fd_sc_hd__decap_3
XFILLER_10_119 VGND VGND VPWR VPWR sky130_fd_sc_hd__decap_3
XFILLER_2_307 VGND VGND VPWR VPWR sky130_fd_sc_hd__fill_1
Xhold142 Inst_LF_LUT4c_frame_config_dffesr.LUT_flop VGND VGND VPWR VPWR net396 sky130_fd_sc_hd__dlygate4sd3_1
Xfanout611 net286 VGND VGND VPWR VPWR net611 sky130_fd_sc_hd__buf_8
Xfanout622 net623 VGND VGND VPWR VPWR net622 sky130_fd_sc_hd__clkbuf_2
Xfanout633 net634 VGND VGND VPWR VPWR net633 sky130_fd_sc_hd__buf_4
Xfanout644 Inst_LA_LUT4c_frame_config_dffesr.O VGND VGND VPWR VPWR net644 sky130_fd_sc_hd__clkbuf_4
Xfanout655 FrameStrobe[9] VGND VGND VPWR VPWR net655 sky130_fd_sc_hd__clkbuf_2
XFILLER_58_333 VGND VGND VPWR VPWR sky130_fd_sc_hd__fill_2
Xfanout666 FrameStrobe[7] VGND VGND VPWR VPWR net666 sky130_fd_sc_hd__dlymetal6s2s_1
Xfanout688 FrameStrobe[1] VGND VGND VPWR VPWR net688 sky130_fd_sc_hd__buf_2
Xfanout699 net701 VGND VGND VPWR VPWR net699 sky130_fd_sc_hd__clkbuf_2
Xfanout677 net678 VGND VGND VPWR VPWR net677 sky130_fd_sc_hd__clkbuf_2
XFILLER_37_78 VGND VGND VPWR VPWR sky130_fd_sc_hd__decap_3
XFILLER_41_211 VGND VGND VPWR VPWR sky130_fd_sc_hd__fill_1
XFILLER_41_255 VGND VGND VPWR VPWR sky130_fd_sc_hd__decap_3
XFILLER_53_66 VGND VGND VPWR VPWR sky130_fd_sc_hd__fill_1
XFILLER_5_178 VGND VGND VPWR VPWR sky130_fd_sc_hd__decap_3
XFILLER_5_156 VGND VGND VPWR VPWR sky130_fd_sc_hd__decap_3
XFILLER_78_52 VGND VGND VPWR VPWR sky130_fd_sc_hd__decap_3
XFILLER_78_85 VGND VGND VPWR VPWR sky130_fd_sc_hd__decap_3
XFILLER_76_130 VGND VGND VPWR VPWR sky130_fd_sc_hd__decap_3
XFILLER_76_141 VGND VGND VPWR VPWR sky130_fd_sc_hd__decap_3
XFILLER_17_252 VGND VGND VPWR VPWR sky130_fd_sc_hd__decap_3
XFILLER_17_274 VGND VGND VPWR VPWR sky130_fd_sc_hd__decap_3
XFILLER_32_200 VGND VGND VPWR VPWR sky130_fd_sc_hd__fill_2
XFILLER_32_211 VGND VGND VPWR VPWR sky130_fd_sc_hd__decap_3
XFILLER_32_277 VGND VGND VPWR VPWR sky130_fd_sc_hd__decap_3
X_0963_ _0062_ Inst_SimpleCLB_ConfigMem.Inst_frame1_bit4.Q Inst_SimpleCLB_ConfigMem.Inst_frame1_bit5.Q
+ VGND VGND VPWR VPWR _0063_ sky130_fd_sc_hd__a21boi_2
XFILLER_71_3 VGND VGND VPWR VPWR sky130_fd_sc_hd__decap_3
X_0894_ N1END[1] N2END[5] E1END[1] E2END[5] Inst_SimpleCLB_ConfigMem.Inst_frame4_bit10.Q
+ Inst_SimpleCLB_ConfigMem.Inst_frame4_bit11.Q VGND VGND VPWR VPWR _0720_ sky130_fd_sc_hd__mux4_1
Xoutput225 net225 VGND VGND VPWR VPWR W2BEGb[6] sky130_fd_sc_hd__buf_2
Xoutput214 net214 VGND VGND VPWR VPWR W2BEG[3] sky130_fd_sc_hd__clkbuf_4
Xoutput203 net203 VGND VGND VPWR VPWR SS4BEG[7] sky130_fd_sc_hd__buf_2
X_1515_ Inst_SimpleCLB_ConfigMem.Inst_frame10_bit18.Q _0539_ VGND VGND VPWR VPWR _0544_
+ sky130_fd_sc_hd__and2_1
Xoutput247 net247 VGND VGND VPWR VPWR WW4BEG[2] sky130_fd_sc_hd__buf_2
Xoutput236 net236 VGND VGND VPWR VPWR W6BEG[7] sky130_fd_sc_hd__buf_2
X_1446_ Inst_SimpleCLB_ConfigMem.Inst_frame13_bit17.Q _0503_ VGND VGND VPWR VPWR _0504_
+ sky130_fd_sc_hd__nand2b_1
X_1377_ net613 _0609_ Inst_SimpleCLB_ConfigMem.Inst_frame11_bit2.Q VGND VGND VPWR
+ VPWR _0443_ sky130_fd_sc_hd__mux2_1
XFILLER_67_196 VGND VGND VPWR VPWR sky130_fd_sc_hd__fill_2
XFILLER_70_306 VGND VGND VPWR VPWR sky130_fd_sc_hd__fill_2
XFILLER_23_222 VGND VGND VPWR VPWR sky130_fd_sc_hd__fill_2
XFILLER_23_244 VGND VGND VPWR VPWR sky130_fd_sc_hd__decap_3
XFILLER_2_137 VGND VGND VPWR VPWR sky130_fd_sc_hd__decap_3
XFILLER_58_141 VGND VGND VPWR VPWR sky130_fd_sc_hd__decap_3
XFILLER_48_88 VGND VGND VPWR VPWR sky130_fd_sc_hd__fill_1
XFILLER_0_29 VGND VGND VPWR VPWR sky130_fd_sc_hd__decap_3
XFILLER_0_18 VGND VGND VPWR VPWR sky130_fd_sc_hd__decap_3
XFILLER_73_122 VGND VGND VPWR VPWR sky130_fd_sc_hd__fill_1
XPHY_EDGE_ROW_14_Left_105 VGND VGND VPWR VPWR sky130_fd_sc_hd__decap_3
XTAP_TAPCELL_ROW_84_695 VGND VPWR sky130_fd_sc_hd__tapvpwrvgnd_1
XFILLER_61_328 VGND VGND VPWR VPWR sky130_fd_sc_hd__fill_1
XPHY_EDGE_ROW_23_Left_114 VGND VGND VPWR VPWR sky130_fd_sc_hd__decap_3
X_2280_ N4END[7] VGND VGND VPWR VPWR net131 sky130_fd_sc_hd__clkbuf_1
XFILLER_36_6 VGND VGND VPWR VPWR sky130_fd_sc_hd__fill_1
X_1300_ Inst_SimpleCLB_ConfigMem.Inst_frame4_bit24.Q _0374_ Inst_SimpleCLB_ConfigMem.Inst_frame4_bit25.Q
+ VGND VGND VPWR VPWR _0377_ sky130_fd_sc_hd__o21a_1
X_1231_ _0723_ _0724_ Inst_SimpleCLB_ConfigMem.Inst_frame9_bit8.Q VGND VGND VPWR VPWR
+ _0315_ sky130_fd_sc_hd__mux2_1
XFILLER_49_163 VGND VGND VPWR VPWR sky130_fd_sc_hd__decap_3
X_1162_ net620 net625 net634 net611 Inst_SimpleCLB_ConfigMem.Inst_frame3_bit18.Q Inst_SimpleCLB_ConfigMem.Inst_frame3_bit19.Q
+ VGND VGND VPWR VPWR _0250_ sky130_fd_sc_hd__mux4_1
XPHY_EDGE_ROW_32_Left_123 VGND VGND VPWR VPWR sky130_fd_sc_hd__decap_3
XFILLER_64_111 VGND VGND VPWR VPWR sky130_fd_sc_hd__decap_3
X_1093_ N2MID[1] E2MID[1] S2MID[1] W2MID[1] Inst_SimpleCLB_ConfigMem.Inst_frame6_bit16.Q
+ Inst_SimpleCLB_ConfigMem.Inst_frame6_bit17.Q VGND VGND VPWR VPWR _0185_ sky130_fd_sc_hd__mux4_2
XFILLER_64_144 VGND VGND VPWR VPWR sky130_fd_sc_hd__decap_3
XTAP_TAPCELL_ROW_75_640 VGND VPWR sky130_fd_sc_hd__tapvpwrvgnd_1
XTAP_TAPCELL_ROW_15_283 VGND VPWR sky130_fd_sc_hd__tapvpwrvgnd_1
X_1995_ net739 net675 VGND VGND VPWR VPWR Inst_SimpleCLB_ConfigMem.Inst_frame4_bit6.Q
+ sky130_fd_sc_hd__dlxtp_1
X_0946_ S1END[1] S2END[5] S1END[3] W1END[1] Inst_SimpleCLB_ConfigMem.Inst_frame3_bit11.Q
+ Inst_SimpleCLB_ConfigMem.Inst_frame3_bit10.Q VGND VGND VPWR VPWR _0047_ sky130_fd_sc_hd__mux4_1
XFILLER_9_281 VGND VGND VPWR VPWR sky130_fd_sc_hd__decap_3
XPHY_EDGE_ROW_41_Left_132 VGND VGND VPWR VPWR sky130_fd_sc_hd__decap_3
X_0877_ _0704_ Inst_LA_LUT4c_frame_config_dffesr.LUT_flop Inst_LA_LUT4c_frame_config_dffesr.c_out_mux
+ VGND VGND VPWR VPWR Inst_LA_LUT4c_frame_config_dffesr.O sky130_fd_sc_hd__mux2_4
X_1429_ net317 _0609_ Inst_SimpleCLB_ConfigMem.Inst_frame13_bit30.Q VGND VGND VPWR
+ VPWR _0489_ sky130_fd_sc_hd__mux2_4
XPHY_EDGE_ROW_50_Left_141 VGND VGND VPWR VPWR sky130_fd_sc_hd__decap_3
XFILLER_28_325 VGND VGND VPWR VPWR sky130_fd_sc_hd__decap_3
XFILLER_55_111 VGND VGND VPWR VPWR sky130_fd_sc_hd__fill_1
XFILLER_55_199 VGND VGND VPWR VPWR sky130_fd_sc_hd__decap_3
XFILLER_34_35 VGND VGND VPWR VPWR sky130_fd_sc_hd__decap_3
XTAP_TAPCELL_ROW_81_676 VGND VPWR sky130_fd_sc_hd__tapvpwrvgnd_1
XFILLER_34_68 VGND VGND VPWR VPWR sky130_fd_sc_hd__decap_3
XFILLER_7_207 VGND VGND VPWR VPWR sky130_fd_sc_hd__decap_3
XFILLER_50_12 VGND VGND VPWR VPWR sky130_fd_sc_hd__decap_3
XFILLER_50_34 VGND VGND VPWR VPWR sky130_fd_sc_hd__decap_3
XFILLER_50_78 VGND VGND VPWR VPWR sky130_fd_sc_hd__decap_3
XFILLER_59_10 VGND VGND VPWR VPWR sky130_fd_sc_hd__fill_2
XFILLER_1_3 VGND VGND VPWR VPWR sky130_fd_sc_hd__decap_3
XFILLER_46_144 VGND VGND VPWR VPWR sky130_fd_sc_hd__decap_3
XTAP_TAPCELL_ROW_29_364 VGND VPWR sky130_fd_sc_hd__tapvpwrvgnd_1
XTAP_TAPCELL_ROW_72_621 VGND VPWR sky130_fd_sc_hd__tapvpwrvgnd_1
X_1780_ net787 net722 VGND VGND VPWR VPWR Inst_SimpleCLB_ConfigMem.Inst_frame11_bit15.Q
+ sky130_fd_sc_hd__dlxtp_1
X_0800_ _0632_ VGND VGND VPWR VPWR _0633_ sky130_fd_sc_hd__inv_1
X_0731_ Inst_SimpleCLB_ConfigMem.Inst_frame3_bit8.Q VGND VGND VPWR VPWR _0567_ sky130_fd_sc_hd__inv_1
XTAP_TAPCELL_ROW_12_264 VGND VPWR sky130_fd_sc_hd__tapvpwrvgnd_1
XFILLER_6_251 VGND VGND VPWR VPWR sky130_fd_sc_hd__fill_1
X_2401_ WW4END[11] VGND VGND VPWR VPWR net252 sky130_fd_sc_hd__clkbuf_2
X_2332_ S4END[7] VGND VGND VPWR VPWR net183 sky130_fd_sc_hd__buf_4
XFILLER_69_225 VGND VGND VPWR VPWR sky130_fd_sc_hd__fill_1
XFILLER_69_269 VGND VGND VPWR VPWR sky130_fd_sc_hd__decap_3
X_2263_ Inst_SimpleCLB_switch_matrix.JN2BEG2 VGND VGND VPWR VPWR net108 sky130_fd_sc_hd__buf_6
X_2194_ EE4END[9] VGND VGND VPWR VPWR net45 sky130_fd_sc_hd__buf_1
XFILLER_1_50 VGND VGND VPWR VPWR sky130_fd_sc_hd__decap_3
X_1214_ _0273_ _0275_ _0265_ _0263_ Inst_SimpleCLB_ConfigMem.Inst_frame8_bit22.Q Inst_SimpleCLB_ConfigMem.Inst_frame8_bit23.Q
+ VGND VGND VPWR VPWR _0299_ sky130_fd_sc_hd__mux4_2
X_1145_ net285 _0172_ _0581_ _0228_ _0233_ VGND VGND VPWR VPWR _0234_ sky130_fd_sc_hd__o32a_4
XFILLER_37_199 VGND VGND VPWR VPWR sky130_fd_sc_hd__decap_3
XFILLER_52_136 VGND VGND VPWR VPWR sky130_fd_sc_hd__decap_3
X_1076_ net259 _0168_ VGND VGND VPWR VPWR _0169_ sky130_fd_sc_hd__or2_1
X_1978_ net770 net673 VGND VGND VPWR VPWR Inst_SimpleCLB_ConfigMem.Inst_frame5_bit21.Q
+ sky130_fd_sc_hd__dlxtp_1
X_0929_ N2MID[4] E2MID[4] S2MID[4] Inst_SimpleCLB_switch_matrix.JS2BEG4 Inst_SimpleCLB_ConfigMem.Inst_frame7_bit6.Q
+ Inst_SimpleCLB_ConfigMem.Inst_frame7_bit7.Q VGND VGND VPWR VPWR _0031_ sky130_fd_sc_hd__mux4_2
XTAP_TAPCELL_ROW_3_210 VGND VPWR sky130_fd_sc_hd__tapvpwrvgnd_1
XFILLER_29_57 VGND VGND VPWR VPWR sky130_fd_sc_hd__fill_1
XFILLER_75_217 VGND VGND VPWR VPWR sky130_fd_sc_hd__decap_3
XFILLER_90_209 VGND VGND VPWR VPWR sky130_fd_sc_hd__decap_3
XFILLER_16_328 VGND VGND VPWR VPWR sky130_fd_sc_hd__decap_3
XTAP_TAPCELL_ROW_26_345 VGND VPWR sky130_fd_sc_hd__tapvpwrvgnd_1
XFILLER_51_180 VGND VGND VPWR VPWR sky130_fd_sc_hd__decap_3
XPHY_EDGE_ROW_7_Left_98 VGND VGND VPWR VPWR sky130_fd_sc_hd__decap_3
XFILLER_3_243 VGND VGND VPWR VPWR sky130_fd_sc_hd__decap_3
XFILLER_10_81 VGND VGND VPWR VPWR sky130_fd_sc_hd__decap_3
XFILLER_66_217 VGND VGND VPWR VPWR sky130_fd_sc_hd__fill_2
XFILLER_86_85 VGND VGND VPWR VPWR sky130_fd_sc_hd__fill_1
XFILLER_19_122 VGND VGND VPWR VPWR sky130_fd_sc_hd__decap_3
XFILLER_19_111 VGND VGND VPWR VPWR sky130_fd_sc_hd__fill_1
XFILLER_19_90 VGND VGND VPWR VPWR sky130_fd_sc_hd__decap_3
XFILLER_74_250 VGND VGND VPWR VPWR sky130_fd_sc_hd__fill_2
XFILLER_19_188 VGND VGND VPWR VPWR sky130_fd_sc_hd__decap_3
XFILLER_19_177 VGND VGND VPWR VPWR sky130_fd_sc_hd__fill_2
X_1901_ net735 net663 VGND VGND VPWR VPWR Inst_SimpleCLB_ConfigMem.Inst_frame7_bit8.Q
+ sky130_fd_sc_hd__dlxtp_1
XFILLER_42_191 VGND VGND VPWR VPWR sky130_fd_sc_hd__decap_3
X_1832_ net746 net656 VGND VGND VPWR VPWR Inst_SimpleCLB_ConfigMem.Inst_frame9_bit3.Q
+ sky130_fd_sc_hd__dlxtp_1
X_1763_ net750 net716 VGND VGND VPWR VPWR Inst_SimpleCLB_ConfigMem.Inst_frame12_bit30.Q
+ sky130_fd_sc_hd__dlxtp_1
X_1694_ net763 net707 VGND VGND VPWR VPWR Inst_LH_LUT4c_frame_config_dffesr.c_reset_value
+ sky130_fd_sc_hd__dlxtp_1
X_2315_ net266 VGND VGND VPWR VPWR net160 sky130_fd_sc_hd__clkbuf_1
X_2246_ net658 VGND VGND VPWR VPWR net101 sky130_fd_sc_hd__clkbuf_1
XFILLER_65_250 VGND VGND VPWR VPWR sky130_fd_sc_hd__decap_3
X_2177_ E6END[2] VGND VGND VPWR VPWR net22 sky130_fd_sc_hd__buf_1
XFILLER_25_147 VGND VGND VPWR VPWR sky130_fd_sc_hd__fill_2
XTAP_TAPCELL_ROW_48_481 VGND VPWR sky130_fd_sc_hd__tapvpwrvgnd_1
X_1128_ _0163_ _0160_ _0155_ _0170_ _0157_ VGND VGND VPWR VPWR _0218_ sky130_fd_sc_hd__a311oi_4
XFILLER_25_169 VGND VGND VPWR VPWR sky130_fd_sc_hd__decap_3
XFILLER_40_106 VGND VGND VPWR VPWR sky130_fd_sc_hd__decap_3
X_1059_ N2MID[5] E2MID[5] S2MID[5] W2MID[5] Inst_SimpleCLB_ConfigMem.Inst_frame6_bit14.Q
+ Inst_SimpleCLB_ConfigMem.Inst_frame6_bit15.Q VGND VGND VPWR VPWR _0152_ sky130_fd_sc_hd__mux4_1
XTAP_TAPCELL_ROW_23_326 VGND VPWR sky130_fd_sc_hd__tapvpwrvgnd_1
XFILLER_40_139 VGND VGND VPWR VPWR sky130_fd_sc_hd__fill_1
Xoutput14 net14 VGND VGND VPWR VPWR E2BEGb[0] sky130_fd_sc_hd__buf_2
Xoutput25 net25 VGND VGND VPWR VPWR E6BEG[1] sky130_fd_sc_hd__buf_2
Xoutput36 net36 VGND VGND VPWR VPWR EE4BEG[11] sky130_fd_sc_hd__buf_2
Xoutput47 net47 VGND VGND VPWR VPWR EE4BEG[7] sky130_fd_sc_hd__buf_2
Xoutput58 net58 VGND VGND VPWR VPWR FrameData_O[17] sky130_fd_sc_hd__buf_2
Xoutput69 net69 VGND VGND VPWR VPWR FrameData_O[27] sky130_fd_sc_hd__buf_2
XFILLER_0_279 VGND VGND VPWR VPWR sky130_fd_sc_hd__fill_1
XFILLER_48_206 VGND VGND VPWR VPWR sky130_fd_sc_hd__decap_3
XFILLER_56_99 VGND VGND VPWR VPWR sky130_fd_sc_hd__decap_3
XFILLER_72_32 VGND VGND VPWR VPWR sky130_fd_sc_hd__decap_3
XFILLER_68_9 VGND VGND VPWR VPWR sky130_fd_sc_hd__decap_3
XFILLER_21_80 VGND VGND VPWR VPWR sky130_fd_sc_hd__decap_3
XFILLER_39_217 VGND VGND VPWR VPWR sky130_fd_sc_hd__decap_3
XFILLER_39_228 VGND VGND VPWR VPWR sky130_fd_sc_hd__fill_2
X_2100_ net786 net689 VGND VGND VPWR VPWR Inst_SimpleCLB_ConfigMem.Inst_frame1_bit15.Q
+ sky130_fd_sc_hd__dlxtp_1
X_2031_ net796 net681 VGND VGND VPWR VPWR Inst_SimpleCLB_ConfigMem.Inst_frame3_bit10.Q
+ sky130_fd_sc_hd__dlxtp_1
XFILLER_54_209 VGND VGND VPWR VPWR sky130_fd_sc_hd__decap_3
XTAP_TAPCELL_ROW_45_462 VGND VPWR sky130_fd_sc_hd__tapvpwrvgnd_1
X_1815_ net781 net725 VGND VGND VPWR VPWR Inst_SimpleCLB_ConfigMem.Inst_frame10_bit18.Q
+ sky130_fd_sc_hd__dlxtp_1
XFILLER_30_183 VGND VGND VPWR VPWR sky130_fd_sc_hd__decap_3
XFILLER_7_60 VGND VGND VPWR VPWR sky130_fd_sc_hd__fill_2
X_1746_ net791 net718 VGND VGND VPWR VPWR Inst_SimpleCLB_ConfigMem.Inst_frame12_bit13.Q
+ sky130_fd_sc_hd__dlxtp_1
X_1677_ FrameData[8] net708 VGND VGND VPWR VPWR Inst_LH_LUT4c_frame_config_dffesr.inst_cus_mux161_buf.A1
+ sky130_fd_sc_hd__dlxtp_1
XFILLER_45_209 VGND VGND VPWR VPWR sky130_fd_sc_hd__decap_3
X_2229_ net765 VGND VGND VPWR VPWR net66 sky130_fd_sc_hd__buf_1
XTAP_TAPCELL_ROW_68_598 VGND VPWR sky130_fd_sc_hd__tapvpwrvgnd_1
XANTENNA_219 net67 VGND VGND VPWR VPWR sky130_fd_sc_hd__diode_2
XANTENNA_208 net651 VGND VGND VPWR VPWR sky130_fd_sc_hd__diode_2
XFILLER_13_106 VGND VGND VPWR VPWR sky130_fd_sc_hd__decap_3
XFILLER_53_242 VGND VGND VPWR VPWR sky130_fd_sc_hd__fill_2
XFILLER_53_275 VGND VGND VPWR VPWR sky130_fd_sc_hd__decap_3
XFILLER_42_35 VGND VGND VPWR VPWR sky130_fd_sc_hd__decap_3
XTAP_TAPCELL_ROW_51_498 VGND VPWR sky130_fd_sc_hd__tapvpwrvgnd_1
XFILLER_21_183 VGND VGND VPWR VPWR sky130_fd_sc_hd__decap_3
XFILLER_67_21 VGND VGND VPWR VPWR sky130_fd_sc_hd__decap_3
XFILLER_67_54 VGND VGND VPWR VPWR sky130_fd_sc_hd__fill_2
XTAP_TAPCELL_ROW_59_543 VGND VPWR sky130_fd_sc_hd__tapvpwrvgnd_1
XFILLER_44_231 VGND VGND VPWR VPWR sky130_fd_sc_hd__decap_3
XFILLER_44_253 VGND VGND VPWR VPWR sky130_fd_sc_hd__fill_1
XFILLER_44_264 VGND VGND VPWR VPWR sky130_fd_sc_hd__decap_3
XFILLER_44_286 VGND VGND VPWR VPWR sky130_fd_sc_hd__decap_3
XPHY_EDGE_ROW_88_Left_179 VGND VGND VPWR VPWR sky130_fd_sc_hd__decap_3
XTAP_TAPCELL_ROW_42_443 VGND VPWR sky130_fd_sc_hd__tapvpwrvgnd_1
XFILLER_80_8 VGND VGND VPWR VPWR sky130_fd_sc_hd__fill_2
XFILLER_8_132 VGND VGND VPWR VPWR sky130_fd_sc_hd__decap_3
X_1600_ net758 net696 VGND VGND VPWR VPWR Inst_LD_LUT4c_frame_config_dffesr.inst_cus_mux161_buf.A0
+ sky130_fd_sc_hd__dlxtp_1
X_1531_ Inst_SimpleCLB_ConfigMem.Inst_frame9_bit27.Q _0530_ VGND VGND VPWR VPWR _0556_
+ sky130_fd_sc_hd__nand2_1
X_1462_ _0565_ Inst_SimpleCLB_ConfigMem.Inst_frame13_bit10.Q Inst_SimpleCLB_ConfigMem.Inst_frame13_bit11.Q
+ _0517_ VGND VGND VPWR VPWR _0518_ sky130_fd_sc_hd__a211o_1
XFILLER_67_323 VGND VGND VPWR VPWR sky130_fd_sc_hd__fill_1
X_1393_ Inst_SimpleCLB_ConfigMem.Inst_frame12_bit16.Q _0457_ VGND VGND VPWR VPWR _0458_
+ sky130_fd_sc_hd__or2_1
X_2014_ net763 net676 VGND VGND VPWR VPWR Inst_SimpleCLB_ConfigMem.Inst_frame4_bit25.Q
+ sky130_fd_sc_hd__dlxtp_1
XTAP_TAPCELL_ROW_65_579 VGND VPWR sky130_fd_sc_hd__tapvpwrvgnd_1
XFILLER_50_223 VGND VGND VPWR VPWR sky130_fd_sc_hd__fill_2
XFILLER_50_234 VGND VGND VPWR VPWR sky130_fd_sc_hd__decap_3
XFILLER_50_256 VGND VGND VPWR VPWR sky130_fd_sc_hd__decap_3
XFILLER_12_27 VGND VGND VPWR VPWR sky130_fd_sc_hd__fill_1
Xhold143 Inst_LC_LUT4c_frame_config_dffesr.LUT_flop VGND VGND VPWR VPWR net397 sky130_fd_sc_hd__dlygate4sd3_1
X_1729_ net757 net711 VGND VGND VPWR VPWR Inst_SimpleCLB_ConfigMem.Inst_frame13_bit28.Q
+ sky130_fd_sc_hd__dlxtp_1
Xfanout612 net613 VGND VGND VPWR VPWR net612 sky130_fd_sc_hd__clkbuf_4
Xfanout623 Inst_LE_LUT4c_frame_config_dffesr.O VGND VGND VPWR VPWR net623 sky130_fd_sc_hd__buf_2
XFILLER_77_109 VGND VGND VPWR VPWR sky130_fd_sc_hd__decap_3
Xfanout667 FrameStrobe[6] VGND VGND VPWR VPWR net667 sky130_fd_sc_hd__buf_2
Xfanout656 FrameStrobe[9] VGND VGND VPWR VPWR net656 sky130_fd_sc_hd__clkbuf_2
Xfanout634 net635 VGND VGND VPWR VPWR net634 sky130_fd_sc_hd__buf_2
Xfanout645 _0256_ VGND VGND VPWR VPWR net645 sky130_fd_sc_hd__buf_4
XFILLER_85_131 VGND VGND VPWR VPWR sky130_fd_sc_hd__decap_3
Xfanout678 FrameStrobe[4] VGND VGND VPWR VPWR net678 sky130_fd_sc_hd__clkbuf_2
Xfanout689 net690 VGND VGND VPWR VPWR net689 sky130_fd_sc_hd__clkbuf_2
XFILLER_85_175 VGND VGND VPWR VPWR sky130_fd_sc_hd__fill_2
XFILLER_85_164 VGND VGND VPWR VPWR sky130_fd_sc_hd__decap_3
XFILLER_18_209 VGND VGND VPWR VPWR sky130_fd_sc_hd__decap_3
XFILLER_37_57 VGND VGND VPWR VPWR sky130_fd_sc_hd__decap_3
XTAP_TAPCELL_ROW_56_524 VGND VPWR sky130_fd_sc_hd__tapvpwrvgnd_1
XFILLER_26_253 VGND VGND VPWR VPWR sky130_fd_sc_hd__decap_3
XFILLER_5_113 VGND VGND VPWR VPWR sky130_fd_sc_hd__decap_3
XFILLER_5_135 VGND VGND VPWR VPWR sky130_fd_sc_hd__decap_3
XFILLER_1_330 VGND VGND VPWR VPWR sky130_fd_sc_hd__fill_1
XFILLER_78_64 VGND VGND VPWR VPWR sky130_fd_sc_hd__fill_2
XFILLER_76_153 VGND VGND VPWR VPWR sky130_fd_sc_hd__decap_3
XFILLER_17_231 VGND VGND VPWR VPWR sky130_fd_sc_hd__decap_3
XFILLER_32_223 VGND VGND VPWR VPWR sky130_fd_sc_hd__decap_3
XFILLER_32_245 VGND VGND VPWR VPWR sky130_fd_sc_hd__decap_3
XFILLER_32_256 VGND VGND VPWR VPWR sky130_fd_sc_hd__decap_3
X_0962_ net624 net614 net633 net610 Inst_SimpleCLB_ConfigMem.Inst_frame1_bit3.Q Inst_SimpleCLB_ConfigMem.Inst_frame1_bit2.Q
+ VGND VGND VPWR VPWR _0062_ sky130_fd_sc_hd__mux4_1
X_0893_ Inst_SimpleCLB_ConfigMem.Inst_frame4_bit12.Q _0718_ Inst_SimpleCLB_ConfigMem.Inst_frame4_bit13.Q
+ VGND VGND VPWR VPWR _0719_ sky130_fd_sc_hd__a21bo_1
Xoutput215 net215 VGND VGND VPWR VPWR W2BEG[4] sky130_fd_sc_hd__buf_8
Xoutput204 net204 VGND VGND VPWR VPWR SS4BEG[8] sky130_fd_sc_hd__buf_2
Xoutput226 net226 VGND VGND VPWR VPWR W2BEGb[7] sky130_fd_sc_hd__buf_2
Xoutput248 net248 VGND VGND VPWR VPWR WW4BEG[3] sky130_fd_sc_hd__buf_2
Xoutput237 net237 VGND VGND VPWR VPWR W6BEG[8] sky130_fd_sc_hd__buf_2
X_1514_ net398 Inst_SimpleCLB_ConfigMem.Inst_frame8_bit25.Q _0530_ _0542_ _0543_ VGND
+ VGND VPWR VPWR _0000_ sky130_fd_sc_hd__a32o_1
XFILLER_4_50 VGND VGND VPWR VPWR sky130_fd_sc_hd__fill_1
X_1445_ net654 E1END[0] Inst_SimpleCLB_ConfigMem.Inst_frame13_bit16.Q VGND VGND VPWR
+ VPWR _0503_ sky130_fd_sc_hd__mux2_1
X_1376_ Inst_SimpleCLB_ConfigMem.Inst_frame11_bit2.Q _0050_ _0441_ Inst_SimpleCLB_ConfigMem.Inst_frame11_bit3.Q
+ VGND VGND VPWR VPWR _0442_ sky130_fd_sc_hd__o211a_1
XFILLER_67_142 VGND VGND VPWR VPWR sky130_fd_sc_hd__decap_3
XTAP_TAPCELL_ROW_78_660 VGND VPWR sky130_fd_sc_hd__tapvpwrvgnd_1
XFILLER_82_145 VGND VGND VPWR VPWR sky130_fd_sc_hd__fill_2
XFILLER_23_234 VGND VGND VPWR VPWR sky130_fd_sc_hd__fill_1
XFILLER_48_12 VGND VGND VPWR VPWR sky130_fd_sc_hd__decap_3
XFILLER_58_131 VGND VGND VPWR VPWR sky130_fd_sc_hd__decap_3
XFILLER_58_153 VGND VGND VPWR VPWR sky130_fd_sc_hd__fill_1
XFILLER_58_197 VGND VGND VPWR VPWR sky130_fd_sc_hd__decap_3
XTAP_TAPCELL_ROW_84_696 VGND VPWR sky130_fd_sc_hd__tapvpwrvgnd_1
XFILLER_14_245 VGND VGND VPWR VPWR sky130_fd_sc_hd__decap_3
XFILLER_64_99 VGND VGND VPWR VPWR sky130_fd_sc_hd__decap_3
XFILLER_50_9 VGND VGND VPWR VPWR sky130_fd_sc_hd__fill_1
XFILLER_49_131 VGND VGND VPWR VPWR sky130_fd_sc_hd__decap_3
X_1230_ _0314_ Inst_LH_LUT4c_frame_config_dffesr.LUT_flop Inst_LH_LUT4c_frame_config_dffesr.c_out_mux
+ VGND VGND VPWR VPWR Inst_LH_LUT4c_frame_config_dffesr.O sky130_fd_sc_hd__mux2_4
X_1161_ Inst_SimpleCLB_ConfigMem.Inst_frame3_bit20.Q _0248_ VGND VGND VPWR VPWR _0249_
+ sky130_fd_sc_hd__nand2b_4
XFILLER_37_337 VGND VGND VPWR VPWR sky130_fd_sc_hd__fill_1
XFILLER_49_186 VGND VGND VPWR VPWR sky130_fd_sc_hd__decap_3
X_1092_ E2MID[0] S2MID[0] W2MID[0] Inst_SimpleCLB_switch_matrix.JW2BEG5 Inst_SimpleCLB_ConfigMem.Inst_frame7_bit16.Q
+ Inst_SimpleCLB_ConfigMem.Inst_frame7_bit17.Q VGND VGND VPWR VPWR _0184_ sky130_fd_sc_hd__mux4_2
XTAP_TAPCELL_ROW_75_641 VGND VPWR sky130_fd_sc_hd__tapvpwrvgnd_1
XFILLER_20_248 VGND VGND VPWR VPWR sky130_fd_sc_hd__decap_3
X_1994_ net742 net677 VGND VGND VPWR VPWR Inst_SimpleCLB_ConfigMem.Inst_frame4_bit5.Q
+ sky130_fd_sc_hd__dlxtp_1
XFILLER_20_259 VGND VGND VPWR VPWR sky130_fd_sc_hd__decap_3
X_0945_ N1END[1] N2END[5] E1END[1] E2END[5] Inst_SimpleCLB_ConfigMem.Inst_frame3_bit10.Q
+ Inst_SimpleCLB_ConfigMem.Inst_frame3_bit11.Q VGND VGND VPWR VPWR _0046_ sky130_fd_sc_hd__mux4_1
X_0876_ _0696_ _0703_ _0692_ VGND VGND VPWR VPWR _0704_ sky130_fd_sc_hd__mux2_4
X_1428_ Inst_SimpleCLB_ConfigMem.Inst_frame13_bit31.Q _0487_ VGND VGND VPWR VPWR _0488_
+ sky130_fd_sc_hd__nand2_1
X_1359_ _0598_ _0680_ VGND VGND VPWR VPWR _0428_ sky130_fd_sc_hd__or2_1
XFILLER_70_115 VGND VGND VPWR VPWR sky130_fd_sc_hd__decap_3
XFILLER_34_25 VGND VGND VPWR VPWR sky130_fd_sc_hd__decap_3
XFILLER_70_159 VGND VGND VPWR VPWR sky130_fd_sc_hd__decap_3
XTAP_TAPCELL_ROW_81_677 VGND VPWR sky130_fd_sc_hd__tapvpwrvgnd_1
XFILLER_34_47 VGND VGND VPWR VPWR sky130_fd_sc_hd__decap_3
XFILLER_7_219 VGND VGND VPWR VPWR sky130_fd_sc_hd__decap_3
XFILLER_50_24 VGND VGND VPWR VPWR sky130_fd_sc_hd__decap_3
XTAP_TAPCELL_ROW_89_722 VGND VPWR sky130_fd_sc_hd__tapvpwrvgnd_1
XFILLER_19_315 VGND VGND VPWR VPWR sky130_fd_sc_hd__decap_3
XFILLER_19_337 VGND VGND VPWR VPWR sky130_fd_sc_hd__decap_3
XFILLER_46_123 VGND VGND VPWR VPWR sky130_fd_sc_hd__decap_3
XFILLER_75_98 VGND VGND VPWR VPWR sky130_fd_sc_hd__decap_3
XTAP_TAPCELL_ROW_29_365 VGND VPWR sky130_fd_sc_hd__tapvpwrvgnd_1
XTAP_TAPCELL_ROW_72_622 VGND VPWR sky130_fd_sc_hd__tapvpwrvgnd_1
XFILLER_61_137 VGND VGND VPWR VPWR sky130_fd_sc_hd__fill_1
XTAP_TAPCELL_ROW_12_265 VGND VPWR sky130_fd_sc_hd__tapvpwrvgnd_1
X_0730_ Inst_SimpleCLB_ConfigMem.Inst_frame10_bit10.Q VGND VGND VPWR VPWR _0566_ sky130_fd_sc_hd__inv_2
XFILLER_6_230 VGND VGND VPWR VPWR sky130_fd_sc_hd__decap_3
XFILLER_6_263 VGND VGND VPWR VPWR sky130_fd_sc_hd__decap_3
X_2400_ WW4END[10] VGND VGND VPWR VPWR net251 sky130_fd_sc_hd__clkbuf_2
X_2331_ S4END[6] VGND VGND VPWR VPWR net182 sky130_fd_sc_hd__buf_4
X_2262_ Inst_SimpleCLB_switch_matrix.JN2BEG1 VGND VGND VPWR VPWR net107 sky130_fd_sc_hd__buf_2
XFILLER_69_259 VGND VGND VPWR VPWR sky130_fd_sc_hd__decap_3
X_1213_ Inst_LH_LUT4c_frame_config_dffesr.inst_cus_mux161_buf.A6 _0293_ _0295_ Inst_LH_LUT4c_frame_config_dffesr.inst_cus_mux161_buf.A0
+ _0297_ VGND VGND VPWR VPWR _0298_ sky130_fd_sc_hd__o221ai_1
XFILLER_27_3 VGND VGND VPWR VPWR sky130_fd_sc_hd__decap_3
XFILLER_1_40 VGND VGND VPWR VPWR sky130_fd_sc_hd__fill_1
X_2193_ EE4END[8] VGND VGND VPWR VPWR net44 sky130_fd_sc_hd__buf_1
XFILLER_77_281 VGND VGND VPWR VPWR sky130_fd_sc_hd__decap_3
X_1144_ Inst_SimpleCLB_ConfigMem.Inst_frame8_bit7.Q _0230_ _0232_ Inst_LG_LUT4c_frame_config_dffesr.c_I0mux
+ VGND VGND VPWR VPWR _0233_ sky130_fd_sc_hd__a31o_1
X_1075_ _0167_ VGND VGND VPWR VPWR _0168_ sky130_fd_sc_hd__inv_2
X_1977_ net773 net673 VGND VGND VPWR VPWR Inst_SimpleCLB_ConfigMem.Inst_frame5_bit20.Q
+ sky130_fd_sc_hd__dlxtp_1
X_0928_ _0026_ _0027_ _0030_ Inst_SimpleCLB_ConfigMem.Inst_frame2_bit13.Q VGND VGND
+ VPWR VPWR Inst_SimpleCLB_switch_matrix.JS2BEG4 sky130_fd_sc_hd__o22a_1
X_0859_ _0684_ _0682_ _0687_ Inst_SimpleCLB_ConfigMem.Inst_frame1_bit9.Q VGND VGND
+ VPWR VPWR Inst_SimpleCLB_switch_matrix.JW2BEG3 sky130_fd_sc_hd__o22a_4
XTAP_TAPCELL_ROW_3_211 VGND VPWR sky130_fd_sc_hd__tapvpwrvgnd_1
XFILLER_29_47 VGND VGND VPWR VPWR sky130_fd_sc_hd__decap_3
XFILLER_68_270 VGND VGND VPWR VPWR sky130_fd_sc_hd__fill_2
XFILLER_83_240 VGND VGND VPWR VPWR sky130_fd_sc_hd__decap_3
XFILLER_83_284 VGND VGND VPWR VPWR sky130_fd_sc_hd__decap_3
XFILLER_45_46 VGND VGND VPWR VPWR sky130_fd_sc_hd__decap_3
XTAP_TAPCELL_ROW_26_346 VGND VPWR sky130_fd_sc_hd__tapvpwrvgnd_1
XFILLER_45_68 VGND VGND VPWR VPWR sky130_fd_sc_hd__decap_3
XFILLER_6_29 VGND VGND VPWR VPWR sky130_fd_sc_hd__decap_3
XFILLER_6_18 VGND VGND VPWR VPWR sky130_fd_sc_hd__decap_3
XFILLER_3_200 VGND VGND VPWR VPWR sky130_fd_sc_hd__decap_3
XFILLER_3_222 VGND VGND VPWR VPWR sky130_fd_sc_hd__fill_2
XFILLER_3_299 VGND VGND VPWR VPWR sky130_fd_sc_hd__decap_3
XFILLER_34_104 VGND VGND VPWR VPWR sky130_fd_sc_hd__decap_3
XFILLER_34_137 VGND VGND VPWR VPWR sky130_fd_sc_hd__decap_3
XFILLER_15_340 VGND VGND VPWR VPWR sky130_fd_sc_hd__decap_3
X_1900_ net738 net665 VGND VGND VPWR VPWR Inst_SimpleCLB_ConfigMem.Inst_frame7_bit7.Q
+ sky130_fd_sc_hd__dlxtp_1
X_1831_ net752 net656 VGND VGND VPWR VPWR Inst_SimpleCLB_ConfigMem.Inst_frame9_bit2.Q
+ sky130_fd_sc_hd__dlxtp_1
X_1762_ net753 net717 VGND VGND VPWR VPWR Inst_SimpleCLB_ConfigMem.Inst_frame12_bit29.Q
+ sky130_fd_sc_hd__dlxtp_1
X_1693_ FrameData[24] net707 VGND VGND VPWR VPWR Inst_LH_LUT4c_frame_config_dffesr.c_I0mux
+ sky130_fd_sc_hd__dlxtp_1
X_2314_ Inst_SimpleCLB_switch_matrix.JS2BEG1 VGND VGND VPWR VPWR net159 sky130_fd_sc_hd__buf_1
X_2245_ net660 VGND VGND VPWR VPWR net100 sky130_fd_sc_hd__clkbuf_1
X_2176_ E2MID[7] VGND VGND VPWR VPWR net21 sky130_fd_sc_hd__clkbuf_1
X_1127_ _0217_ Inst_LE_LUT4c_frame_config_dffesr.LUT_flop Inst_LE_LUT4c_frame_config_dffesr.c_out_mux
+ VGND VGND VPWR VPWR Inst_LE_LUT4c_frame_config_dffesr.O sky130_fd_sc_hd__mux2_4
XFILLER_65_262 VGND VGND VPWR VPWR sky130_fd_sc_hd__fill_1
XFILLER_65_284 VGND VGND VPWR VPWR sky130_fd_sc_hd__decap_3
XFILLER_80_243 VGND VGND VPWR VPWR sky130_fd_sc_hd__decap_3
X_1058_ N2MID[4] W2MID[4] S2MID[4] Inst_SimpleCLB_switch_matrix.JS2BEG5 Inst_SimpleCLB_ConfigMem.Inst_frame7_bit15.Q
+ Inst_SimpleCLB_ConfigMem.Inst_frame7_bit14.Q VGND VGND VPWR VPWR _0151_ sky130_fd_sc_hd__mux4_2
XTAP_TAPCELL_ROW_23_327 VGND VPWR sky130_fd_sc_hd__tapvpwrvgnd_1
XFILLER_40_118 VGND VGND VPWR VPWR sky130_fd_sc_hd__decap_3
XFILLER_21_343 VGND VGND VPWR VPWR sky130_fd_sc_hd__decap_3
XFILLER_31_48 VGND VGND VPWR VPWR sky130_fd_sc_hd__decap_3
XPHY_EDGE_ROW_1_Right_1 VGND VGND VPWR VPWR sky130_fd_sc_hd__decap_3
Xoutput15 net15 VGND VGND VPWR VPWR E2BEGb[1] sky130_fd_sc_hd__buf_2
Xoutput48 net48 VGND VGND VPWR VPWR EE4BEG[8] sky130_fd_sc_hd__buf_2
Xoutput26 net26 VGND VGND VPWR VPWR E6BEG[2] sky130_fd_sc_hd__buf_2
Xoutput37 net37 VGND VGND VPWR VPWR EE4BEG[12] sky130_fd_sc_hd__buf_8
Xoutput59 net59 VGND VGND VPWR VPWR FrameData_O[18] sky130_fd_sc_hd__buf_2
XFILLER_48_218 VGND VGND VPWR VPWR sky130_fd_sc_hd__decap_3
XFILLER_16_104 VGND VGND VPWR VPWR sky130_fd_sc_hd__fill_1
XFILLER_71_243 VGND VGND VPWR VPWR sky130_fd_sc_hd__decap_3
XFILLER_71_265 VGND VGND VPWR VPWR sky130_fd_sc_hd__decap_3
XFILLER_72_44 VGND VGND VPWR VPWR sky130_fd_sc_hd__decap_3
XFILLER_24_170 VGND VGND VPWR VPWR sky130_fd_sc_hd__decap_3
XFILLER_71_298 VGND VGND VPWR VPWR sky130_fd_sc_hd__decap_3
XFILLER_72_66 VGND VGND VPWR VPWR sky130_fd_sc_hd__decap_3
X_2030_ net733 net679 VGND VGND VPWR VPWR Inst_SimpleCLB_ConfigMem.Inst_frame3_bit9.Q
+ sky130_fd_sc_hd__dlxtp_1
XFILLER_47_284 VGND VGND VPWR VPWR sky130_fd_sc_hd__fill_2
XTAP_TAPCELL_ROW_45_463 VGND VPWR sky130_fd_sc_hd__tapvpwrvgnd_1
XFILLER_62_265 VGND VGND VPWR VPWR sky130_fd_sc_hd__decap_3
XTAP_TAPCELL_ROW_20_308 VGND VPWR sky130_fd_sc_hd__tapvpwrvgnd_1
XFILLER_30_162 VGND VGND VPWR VPWR sky130_fd_sc_hd__decap_3
X_1814_ net783 net725 VGND VGND VPWR VPWR Inst_SimpleCLB_ConfigMem.Inst_frame10_bit17.Q
+ sky130_fd_sc_hd__dlxtp_1
XFILLER_30_195 VGND VGND VPWR VPWR sky130_fd_sc_hd__fill_1
X_1745_ FrameData[12] net719 VGND VGND VPWR VPWR Inst_SimpleCLB_ConfigMem.Inst_frame12_bit12.Q
+ sky130_fd_sc_hd__dlxtp_1
XFILLER_7_83 VGND VGND VPWR VPWR sky130_fd_sc_hd__fill_2
X_1676_ FrameData[7] net708 VGND VGND VPWR VPWR Inst_LH_LUT4c_frame_config_dffesr.inst_cus_mux161_buf.A0
+ sky130_fd_sc_hd__dlxtp_1
XFILLER_85_313 VGND VGND VPWR VPWR sky130_fd_sc_hd__fill_2
XFILLER_38_251 VGND VGND VPWR VPWR sky130_fd_sc_hd__fill_1
XFILLER_38_273 VGND VGND VPWR VPWR sky130_fd_sc_hd__decap_3
X_2228_ net766 VGND VGND VPWR VPWR net65 sky130_fd_sc_hd__clkbuf_1
XFILLER_53_221 VGND VGND VPWR VPWR sky130_fd_sc_hd__decap_3
XTAP_TAPCELL_ROW_68_599 VGND VPWR sky130_fd_sc_hd__tapvpwrvgnd_1
XANTENNA_209 net651 VGND VGND VPWR VPWR sky130_fd_sc_hd__diode_2
XFILLER_53_287 VGND VGND VPWR VPWR sky130_fd_sc_hd__decap_3
XFILLER_21_151 VGND VGND VPWR VPWR sky130_fd_sc_hd__decap_3
XFILLER_21_162 VGND VGND VPWR VPWR sky130_fd_sc_hd__decap_3
XTAP_TAPCELL_ROW_51_499 VGND VPWR sky130_fd_sc_hd__tapvpwrvgnd_1
XFILLER_88_162 VGND VGND VPWR VPWR sky130_fd_sc_hd__decap_3
XTAP_TAPCELL_ROW_59_544 VGND VPWR sky130_fd_sc_hd__tapvpwrvgnd_1
XFILLER_67_77 VGND VGND VPWR VPWR sky130_fd_sc_hd__decap_3
XFILLER_67_99 VGND VGND VPWR VPWR sky130_fd_sc_hd__decap_3
XFILLER_29_251 VGND VGND VPWR VPWR sky130_fd_sc_hd__decap_3
XFILLER_83_21 VGND VGND VPWR VPWR sky130_fd_sc_hd__decap_3
XFILLER_44_221 VGND VGND VPWR VPWR sky130_fd_sc_hd__fill_1
XFILLER_44_243 VGND VGND VPWR VPWR sky130_fd_sc_hd__decap_3
XFILLER_16_70 VGND VGND VPWR VPWR sky130_fd_sc_hd__fill_2
XTAP_TAPCELL_ROW_42_444 VGND VPWR sky130_fd_sc_hd__tapvpwrvgnd_1
XFILLER_12_162 VGND VGND VPWR VPWR sky130_fd_sc_hd__fill_1
XFILLER_8_100 VGND VGND VPWR VPWR sky130_fd_sc_hd__decap_3
XFILLER_12_184 VGND VGND VPWR VPWR sky130_fd_sc_hd__decap_3
XFILLER_73_8 VGND VGND VPWR VPWR sky130_fd_sc_hd__decap_3
XFILLER_32_80 VGND VGND VPWR VPWR sky130_fd_sc_hd__decap_3
X_1530_ net394 _0555_ _0553_ VGND VGND VPWR VPWR _0004_ sky130_fd_sc_hd__mux2_1
X_1461_ net650 Inst_SimpleCLB_ConfigMem.Inst_frame13_bit10.Q VGND VGND VPWR VPWR _0517_
+ sky130_fd_sc_hd__nor2_1
X_1392_ net625 net317 net634 net264 Inst_SimpleCLB_ConfigMem.Inst_frame12_bit15.Q
+ Inst_SimpleCLB_ConfigMem.Inst_frame12_bit14.Q VGND VGND VPWR VPWR _0457_ sky130_fd_sc_hd__mux4_1
XFILLER_79_173 VGND VGND VPWR VPWR sky130_fd_sc_hd__fill_2
X_2013_ net765 net676 VGND VGND VPWR VPWR Inst_SimpleCLB_ConfigMem.Inst_frame4_bit24.Q
+ sky130_fd_sc_hd__dlxtp_1
XFILLER_35_265 VGND VGND VPWR VPWR sky130_fd_sc_hd__fill_1
XFILLER_35_298 VGND VGND VPWR VPWR sky130_fd_sc_hd__decap_3
X_1728_ net759 net711 VGND VGND VPWR VPWR Inst_SimpleCLB_ConfigMem.Inst_frame13_bit27.Q
+ sky130_fd_sc_hd__dlxtp_1
Xhold144 Inst_LH_LUT4c_frame_config_dffesr.LUT_flop VGND VGND VPWR VPWR net398 sky130_fd_sc_hd__dlygate4sd3_1
X_1659_ net768 net705 VGND VGND VPWR VPWR Inst_LG_LUT4c_frame_config_dffesr.inst_cus_mux161_buf.A2
+ sky130_fd_sc_hd__dlxtp_1
Xfanout613 net312 VGND VGND VPWR VPWR net613 sky130_fd_sc_hd__buf_6
Xfanout624 net625 VGND VGND VPWR VPWR net624 sky130_fd_sc_hd__buf_6
Xfanout646 W1END[3] VGND VGND VPWR VPWR net646 sky130_fd_sc_hd__clkbuf_4
Xfanout657 net658 VGND VGND VPWR VPWR net657 sky130_fd_sc_hd__clkbuf_2
Xfanout635 Inst_LF_LUT4c_frame_config_dffesr.O VGND VGND VPWR VPWR net635 sky130_fd_sc_hd__buf_8
Xfanout679 net680 VGND VGND VPWR VPWR net679 sky130_fd_sc_hd__buf_2
Xfanout668 net670 VGND VGND VPWR VPWR net668 sky130_fd_sc_hd__clkbuf_2
XFILLER_85_198 VGND VGND VPWR VPWR sky130_fd_sc_hd__decap_3
XFILLER_26_210 VGND VGND VPWR VPWR sky130_fd_sc_hd__decap_3
XFILLER_37_69 VGND VGND VPWR VPWR sky130_fd_sc_hd__decap_3
XTAP_TAPCELL_ROW_56_525 VGND VPWR sky130_fd_sc_hd__tapvpwrvgnd_1
XFILLER_41_279 VGND VGND VPWR VPWR sky130_fd_sc_hd__fill_1
XFILLER_5_169 VGND VGND VPWR VPWR sky130_fd_sc_hd__decap_3
XFILLER_5_147 VGND VGND VPWR VPWR sky130_fd_sc_hd__decap_3
XFILLER_78_43 VGND VGND VPWR VPWR sky130_fd_sc_hd__decap_3
XFILLER_49_335 VGND VGND VPWR VPWR sky130_fd_sc_hd__fill_1
XFILLER_17_210 VGND VGND VPWR VPWR sky130_fd_sc_hd__fill_2
XFILLER_32_268 VGND VGND VPWR VPWR sky130_fd_sc_hd__decap_3
X_0961_ Inst_SimpleCLB_ConfigMem.Inst_frame1_bit4.Q _0060_ VGND VGND VPWR VPWR _0061_
+ sky130_fd_sc_hd__nand2b_1
X_0892_ net619 net348 net633 net611 Inst_SimpleCLB_ConfigMem.Inst_frame4_bit11.Q Inst_SimpleCLB_ConfigMem.Inst_frame4_bit10.Q
+ VGND VGND VPWR VPWR _0718_ sky130_fd_sc_hd__mux4_1
Xoutput216 net216 VGND VGND VPWR VPWR W2BEG[5] sky130_fd_sc_hd__buf_6
Xoutput205 net205 VGND VGND VPWR VPWR SS4BEG[9] sky130_fd_sc_hd__buf_2
XFILLER_57_3 VGND VGND VPWR VPWR sky130_fd_sc_hd__decap_3
Xoutput249 net249 VGND VGND VPWR VPWR WW4BEG[4] sky130_fd_sc_hd__buf_2
Xoutput227 net227 VGND VGND VPWR VPWR W6BEG[0] sky130_fd_sc_hd__buf_2
Xoutput238 net238 VGND VGND VPWR VPWR W6BEG[9] sky130_fd_sc_hd__buf_2
X_1513_ Inst_SimpleCLB_ConfigMem.Inst_frame8_bit25.Q _0530_ _0541_ Inst_LH_LUT4c_frame_config_dffesr.c_reset_value
+ VGND VGND VPWR VPWR _0543_ sky130_fd_sc_hd__o2bb2a_1
XFILLER_4_180 VGND VGND VPWR VPWR sky130_fd_sc_hd__decap_3
X_1444_ Inst_SimpleCLB_ConfigMem.Inst_frame13_bit17.Q _0501_ _0499_ Inst_SimpleCLB_ConfigMem.Inst_frame13_bit18.Q
+ VGND VGND VPWR VPWR _0502_ sky130_fd_sc_hd__o211a_1
X_1375_ Inst_SimpleCLB_ConfigMem.Inst_frame11_bit2.Q _0265_ VGND VGND VPWR VPWR _0441_
+ sky130_fd_sc_hd__nand2_1
XTAP_TAPCELL_ROW_78_661 VGND VPWR sky130_fd_sc_hd__tapvpwrvgnd_1
XFILLER_82_135 VGND VGND VPWR VPWR sky130_fd_sc_hd__decap_3
XFILLER_23_213 VGND VGND VPWR VPWR sky130_fd_sc_hd__decap_3
XTAP_TAPCELL_ROW_53_506 VGND VPWR sky130_fd_sc_hd__tapvpwrvgnd_1
XFILLER_90_190 VGND VGND VPWR VPWR sky130_fd_sc_hd__decap_3
XFILLER_2_106 VGND VGND VPWR VPWR sky130_fd_sc_hd__decap_3
XFILLER_48_57 VGND VGND VPWR VPWR sky130_fd_sc_hd__fill_1
XFILLER_58_110 VGND VGND VPWR VPWR sky130_fd_sc_hd__decap_3
XFILLER_48_79 VGND VGND VPWR VPWR sky130_fd_sc_hd__decap_3
XFILLER_73_113 VGND VGND VPWR VPWR sky130_fd_sc_hd__decap_3
XTAP_TAPCELL_ROW_84_697 VGND VPWR sky130_fd_sc_hd__tapvpwrvgnd_1
XTAP_TAPCELL_ROW_1_194 VGND VPWR sky130_fd_sc_hd__tapvpwrvgnd_1
XFILLER_80_66 VGND VGND VPWR VPWR sky130_fd_sc_hd__decap_3
XFILLER_13_60 VGND VGND VPWR VPWR sky130_fd_sc_hd__fill_2
XFILLER_22_290 VGND VGND VPWR VPWR sky130_fd_sc_hd__fill_2
XFILLER_13_82 VGND VGND VPWR VPWR sky130_fd_sc_hd__decap_3
XFILLER_89_53 VGND VGND VPWR VPWR sky130_fd_sc_hd__decap_3
XFILLER_43_9 VGND VGND VPWR VPWR sky130_fd_sc_hd__decap_3
X_1160_ W2END[7] net639 net643 net630 Inst_SimpleCLB_ConfigMem.Inst_frame3_bit19.Q
+ Inst_SimpleCLB_ConfigMem.Inst_frame3_bit18.Q VGND VGND VPWR VPWR _0248_ sky130_fd_sc_hd__mux4_2
XFILLER_49_154 VGND VGND VPWR VPWR sky130_fd_sc_hd__decap_3
XFILLER_49_198 VGND VGND VPWR VPWR sky130_fd_sc_hd__decap_3
XFILLER_64_102 VGND VGND VPWR VPWR sky130_fd_sc_hd__decap_3
X_1091_ _0179_ _0180_ _0183_ Inst_SimpleCLB_ConfigMem.Inst_frame1_bit17.Q VGND VGND
+ VPWR VPWR Inst_SimpleCLB_switch_matrix.JW2BEG5 sky130_fd_sc_hd__o22a_4
XFILLER_64_135 VGND VGND VPWR VPWR sky130_fd_sc_hd__decap_3
XTAP_TAPCELL_ROW_75_642 VGND VPWR sky130_fd_sc_hd__tapvpwrvgnd_1
XFILLER_20_227 VGND VGND VPWR VPWR sky130_fd_sc_hd__decap_3
X_1993_ net744 net677 VGND VGND VPWR VPWR Inst_SimpleCLB_ConfigMem.Inst_frame4_bit4.Q
+ sky130_fd_sc_hd__dlxtp_1
X_0944_ _0044_ Inst_SimpleCLB_ConfigMem.Inst_frame3_bit12.Q Inst_SimpleCLB_ConfigMem.Inst_frame3_bit13.Q
+ VGND VGND VPWR VPWR _0045_ sky130_fd_sc_hd__a21bo_1
XFILLER_13_290 VGND VGND VPWR VPWR sky130_fd_sc_hd__decap_3
X_0875_ _0702_ _0699_ _0670_ VGND VGND VPWR VPWR _0703_ sky130_fd_sc_hd__mux2_1
X_1427_ _0050_ _0231_ Inst_SimpleCLB_ConfigMem.Inst_frame13_bit30.Q VGND VGND VPWR
+ VPWR _0487_ sky130_fd_sc_hd__mux2_1
XFILLER_18_27 VGND VGND VPWR VPWR sky130_fd_sc_hd__fill_1
XFILLER_55_102 VGND VGND VPWR VPWR sky130_fd_sc_hd__decap_3
X_1358_ net652 E1END[1] W1END[1] net620 Inst_SimpleCLB_ConfigMem.Inst_frame11_bit11.Q
+ Inst_SimpleCLB_ConfigMem.Inst_frame11_bit12.Q VGND VGND VPWR VPWR _0427_ sky130_fd_sc_hd__mux4_1
X_1289_ W6END[1] net627 net637 net616 Inst_SimpleCLB_ConfigMem.Inst_frame4_bit27.Q
+ Inst_SimpleCLB_ConfigMem.Inst_frame4_bit26.Q VGND VGND VPWR VPWR _0367_ sky130_fd_sc_hd__mux4_1
XFILLER_55_179 VGND VGND VPWR VPWR sky130_fd_sc_hd__decap_3
XTAP_TAPCELL_ROW_81_678 VGND VPWR sky130_fd_sc_hd__tapvpwrvgnd_1
XFILLER_11_205 VGND VGND VPWR VPWR sky130_fd_sc_hd__decap_3
XFILLER_34_59 VGND VGND VPWR VPWR sky130_fd_sc_hd__decap_3
XTAP_TAPCELL_ROW_89_723 VGND VPWR sky130_fd_sc_hd__tapvpwrvgnd_1
XFILLER_78_249 VGND VGND VPWR VPWR sky130_fd_sc_hd__decap_3
XFILLER_86_260 VGND VGND VPWR VPWR sky130_fd_sc_hd__fill_1
XTAP_TAPCELL_ROW_29_366 VGND VPWR sky130_fd_sc_hd__tapvpwrvgnd_1
XFILLER_46_168 VGND VGND VPWR VPWR sky130_fd_sc_hd__decap_3
XTAP_TAPCELL_ROW_72_623 VGND VPWR sky130_fd_sc_hd__tapvpwrvgnd_1
XFILLER_24_81 VGND VGND VPWR VPWR sky130_fd_sc_hd__decap_3
XFILLER_6_242 VGND VGND VPWR VPWR sky130_fd_sc_hd__decap_3
XFILLER_41_6 VGND VGND VPWR VPWR sky130_fd_sc_hd__fill_1
X_2330_ S4END[5] VGND VGND VPWR VPWR net181 sky130_fd_sc_hd__buf_4
X_2261_ Inst_SimpleCLB_switch_matrix.JN2BEG0 VGND VGND VPWR VPWR net106 sky130_fd_sc_hd__clkbuf_2
X_1212_ Inst_LH_LUT4c_frame_config_dffesr.inst_cus_mux161_buf.A2 _0292_ _0294_ Inst_LH_LUT4c_frame_config_dffesr.inst_cus_mux161_buf.A4
+ VGND VGND VPWR VPWR _0297_ sky130_fd_sc_hd__o22a_1
X_2192_ EE4END[7] VGND VGND VPWR VPWR net43 sky130_fd_sc_hd__clkbuf_1
X_1143_ _0580_ _0231_ VGND VGND VPWR VPWR _0232_ sky130_fd_sc_hd__nand2_1
XFILLER_1_96 VGND VGND VPWR VPWR sky130_fd_sc_hd__decap_3
X_1074_ _0139_ _0140_ _0131_ _0130_ Inst_SimpleCLB_ConfigMem.Inst_frame9_bit30.Q Inst_SimpleCLB_ConfigMem.Inst_frame9_bit31.Q
+ VGND VGND VPWR VPWR _0167_ sky130_fd_sc_hd__mux4_2
XFILLER_60_171 VGND VGND VPWR VPWR sky130_fd_sc_hd__fill_1
X_1976_ net779 net673 VGND VGND VPWR VPWR Inst_SimpleCLB_ConfigMem.Inst_frame5_bit19.Q
+ sky130_fd_sc_hd__dlxtp_1
X_0927_ _0028_ _0029_ Inst_SimpleCLB_ConfigMem.Inst_frame2_bit12.Q VGND VGND VPWR
+ VPWR _0030_ sky130_fd_sc_hd__mux2_1
XFILLER_20_39 VGND VGND VPWR VPWR sky130_fd_sc_hd__fill_2
X_0858_ _0685_ _0686_ Inst_SimpleCLB_ConfigMem.Inst_frame1_bit8.Q VGND VGND VPWR VPWR
+ _0687_ sky130_fd_sc_hd__mux2_1
X_0789_ _0622_ Inst_SimpleCLB_ConfigMem.Inst_frame4_bit8.Q Inst_SimpleCLB_ConfigMem.Inst_frame4_bit9.Q
+ VGND VGND VPWR VPWR _0623_ sky130_fd_sc_hd__a21boi_1
XTAP_TAPCELL_ROW_86_704 VGND VPWR sky130_fd_sc_hd__tapvpwrvgnd_1
XFILLER_75_208 VGND VGND VPWR VPWR sky130_fd_sc_hd__decap_3
XFILLER_28_102 VGND VGND VPWR VPWR sky130_fd_sc_hd__decap_3
XFILLER_28_124 VGND VGND VPWR VPWR sky130_fd_sc_hd__decap_3
XTAP_TAPCELL_ROW_26_347 VGND VPWR sky130_fd_sc_hd__tapvpwrvgnd_1
XFILLER_36_190 VGND VGND VPWR VPWR sky130_fd_sc_hd__decap_3
XFILLER_61_24 VGND VGND VPWR VPWR sky130_fd_sc_hd__decap_3
XFILLER_61_57 VGND VGND VPWR VPWR sky130_fd_sc_hd__decap_3
XFILLER_3_234 VGND VGND VPWR VPWR sky130_fd_sc_hd__decap_3
XFILLER_86_21 VGND VGND VPWR VPWR sky130_fd_sc_hd__decap_3
XFILLER_86_32 VGND VGND VPWR VPWR sky130_fd_sc_hd__fill_1
XFILLER_19_102 VGND VGND VPWR VPWR sky130_fd_sc_hd__decap_3
XFILLER_19_146 VGND VGND VPWR VPWR sky130_fd_sc_hd__decap_3
XFILLER_19_81 VGND VGND VPWR VPWR sky130_fd_sc_hd__decap_3
XFILLER_59_293 VGND VGND VPWR VPWR sky130_fd_sc_hd__decap_3
XFILLER_42_171 VGND VGND VPWR VPWR sky130_fd_sc_hd__decap_3
XFILLER_42_182 VGND VGND VPWR VPWR sky130_fd_sc_hd__decap_3
X_1830_ net777 net656 VGND VGND VPWR VPWR Inst_SimpleCLB_ConfigMem.Inst_frame9_bit1.Q
+ sky130_fd_sc_hd__dlxtp_1
X_1761_ net756 net717 VGND VGND VPWR VPWR Inst_SimpleCLB_ConfigMem.Inst_frame12_bit28.Q
+ sky130_fd_sc_hd__dlxtp_1
X_1692_ net766 net707 VGND VGND VPWR VPWR Inst_LH_LUT4c_frame_config_dffesr.c_out_mux
+ sky130_fd_sc_hd__dlxtp_1
X_2313_ Inst_SimpleCLB_switch_matrix.JS2BEG0 VGND VGND VPWR VPWR net158 sky130_fd_sc_hd__buf_1
XPHY_EDGE_ROW_29_Left_120 VGND VGND VPWR VPWR sky130_fd_sc_hd__decap_3
X_2244_ net665 VGND VGND VPWR VPWR net99 sky130_fd_sc_hd__buf_1
XFILLER_65_241 VGND VGND VPWR VPWR sky130_fd_sc_hd__decap_3
X_2175_ E2MID[6] VGND VGND VPWR VPWR net20 sky130_fd_sc_hd__buf_1
X_1126_ _0216_ _0211_ _0208_ VGND VGND VPWR VPWR _0217_ sky130_fd_sc_hd__mux2_4
XFILLER_25_116 VGND VGND VPWR VPWR sky130_fd_sc_hd__fill_2
X_1057_ _0145_ _0147_ _0150_ Inst_SimpleCLB_ConfigMem.Inst_frame2_bit17.Q VGND VGND
+ VPWR VPWR Inst_SimpleCLB_switch_matrix.JS2BEG5 sky130_fd_sc_hd__o22a_4
XTAP_TAPCELL_ROW_23_328 VGND VPWR sky130_fd_sc_hd__tapvpwrvgnd_1
X_1959_ net751 net673 VGND VGND VPWR VPWR Inst_SimpleCLB_ConfigMem.Inst_frame5_bit2.Q
+ sky130_fd_sc_hd__dlxtp_1
Xoutput16 net16 VGND VGND VPWR VPWR E2BEGb[2] sky130_fd_sc_hd__buf_2
Xoutput49 net49 VGND VGND VPWR VPWR EE4BEG[9] sky130_fd_sc_hd__buf_2
Xoutput38 net38 VGND VGND VPWR VPWR EE4BEG[13] sky130_fd_sc_hd__buf_8
Xoutput27 net27 VGND VGND VPWR VPWR E6BEG[3] sky130_fd_sc_hd__buf_2
XFILLER_56_35 VGND VGND VPWR VPWR sky130_fd_sc_hd__decap_3
XFILLER_56_79 VGND VGND VPWR VPWR sky130_fd_sc_hd__fill_1
XFILLER_31_119 VGND VGND VPWR VPWR sky130_fd_sc_hd__decap_3
XFILLER_72_56 VGND VGND VPWR VPWR sky130_fd_sc_hd__fill_1
XFILLER_12_322 VGND VGND VPWR VPWR sky130_fd_sc_hd__decap_3
XFILLER_24_182 VGND VGND VPWR VPWR sky130_fd_sc_hd__decap_3
XFILLER_8_337 VGND VGND VPWR VPWR sky130_fd_sc_hd__decap_3
XFILLER_47_274 VGND VGND VPWR VPWR sky130_fd_sc_hd__decap_3
XFILLER_47_296 VGND VGND VPWR VPWR sky130_fd_sc_hd__decap_3
XFILLER_62_244 VGND VGND VPWR VPWR sky130_fd_sc_hd__decap_3
XFILLER_15_160 VGND VGND VPWR VPWR sky130_fd_sc_hd__decap_3
XFILLER_15_193 VGND VGND VPWR VPWR sky130_fd_sc_hd__fill_1
XFILLER_87_3 VGND VGND VPWR VPWR sky130_fd_sc_hd__fill_1
XTAP_TAPCELL_ROW_20_309 VGND VPWR sky130_fd_sc_hd__tapvpwrvgnd_1
XFILLER_30_141 VGND VGND VPWR VPWR sky130_fd_sc_hd__decap_3
X_1813_ net785 net724 VGND VGND VPWR VPWR Inst_SimpleCLB_ConfigMem.Inst_frame10_bit16.Q
+ sky130_fd_sc_hd__dlxtp_1
XFILLER_30_174 VGND VGND VPWR VPWR sky130_fd_sc_hd__decap_3
XFILLER_7_51 VGND VGND VPWR VPWR sky130_fd_sc_hd__decap_3
X_1744_ net794 net719 VGND VGND VPWR VPWR Inst_SimpleCLB_ConfigMem.Inst_frame12_bit11.Q
+ sky130_fd_sc_hd__dlxtp_1
XFILLER_89_119 VGND VGND VPWR VPWR sky130_fd_sc_hd__fill_1
X_1675_ net740 net709 VGND VGND VPWR VPWR Inst_LG_LUT4c_frame_config_dffesr.c_reset_value
+ sky130_fd_sc_hd__dlxtp_1
XPHY_EDGE_ROW_15_Right_15 VGND VGND VPWR VPWR sky130_fd_sc_hd__decap_3
X_2227_ net768 VGND VGND VPWR VPWR net64 sky130_fd_sc_hd__clkbuf_1
X_2158_ Inst_SimpleCLB_switch_matrix.E1BEG1 VGND VGND VPWR VPWR net3 sky130_fd_sc_hd__clkbuf_2
XFILLER_26_38 VGND VGND VPWR VPWR sky130_fd_sc_hd__fill_2
XPHY_EDGE_ROW_24_Right_24 VGND VGND VPWR VPWR sky130_fd_sc_hd__decap_3
X_2089_ net744 net690 VGND VGND VPWR VPWR Inst_SimpleCLB_ConfigMem.Inst_frame1_bit4.Q
+ sky130_fd_sc_hd__dlxtp_1
XFILLER_53_233 VGND VGND VPWR VPWR sky130_fd_sc_hd__decap_3
X_1109_ _0125_ _0126_ _0128_ _0127_ Inst_SimpleCLB_ConfigMem.Inst_frame9_bit18.Q Inst_SimpleCLB_ConfigMem.Inst_frame9_bit19.Q
+ VGND VGND VPWR VPWR _0200_ sky130_fd_sc_hd__mux4_1
XPHY_EDGE_ROW_33_Right_33 VGND VGND VPWR VPWR sky130_fd_sc_hd__decap_3
XFILLER_67_12 VGND VGND VPWR VPWR sky130_fd_sc_hd__decap_3
XFILLER_67_45 VGND VGND VPWR VPWR sky130_fd_sc_hd__decap_3
XFILLER_76_303 VGND VGND VPWR VPWR sky130_fd_sc_hd__fill_1
XTAP_TAPCELL_ROW_59_545 VGND VPWR sky130_fd_sc_hd__tapvpwrvgnd_1
XFILLER_76_336 VGND VGND VPWR VPWR sky130_fd_sc_hd__fill_1
XFILLER_29_263 VGND VGND VPWR VPWR sky130_fd_sc_hd__decap_3
XPHY_EDGE_ROW_42_Right_42 VGND VGND VPWR VPWR sky130_fd_sc_hd__decap_3
XFILLER_44_200 VGND VGND VPWR VPWR sky130_fd_sc_hd__decap_3
XFILLER_83_55 VGND VGND VPWR VPWR sky130_fd_sc_hd__fill_1
XTAP_TAPCELL_ROW_42_445 VGND VPWR sky130_fd_sc_hd__tapvpwrvgnd_1
XFILLER_12_130 VGND VGND VPWR VPWR sky130_fd_sc_hd__decap_3
XFILLER_8_167 VGND VGND VPWR VPWR sky130_fd_sc_hd__decap_3
XPHY_EDGE_ROW_51_Right_51 VGND VGND VPWR VPWR sky130_fd_sc_hd__decap_3
X_1460_ Inst_SimpleCLB_ConfigMem.Inst_frame13_bit11.Q _0515_ _0513_ Inst_SimpleCLB_ConfigMem.Inst_frame13_bit12.Q
+ VGND VGND VPWR VPWR _0516_ sky130_fd_sc_hd__o211a_1
X_1391_ _0667_ net297 _0151_ _0241_ Inst_SimpleCLB_ConfigMem.Inst_frame12_bit14.Q
+ Inst_SimpleCLB_ConfigMem.Inst_frame12_bit15.Q VGND VGND VPWR VPWR _0456_ sky130_fd_sc_hd__mux4_2
XFILLER_79_141 VGND VGND VPWR VPWR sky130_fd_sc_hd__decap_3
XPHY_EDGE_ROW_60_Right_60 VGND VGND VPWR VPWR sky130_fd_sc_hd__decap_3
XFILLER_82_339 VGND VGND VPWR VPWR sky130_fd_sc_hd__fill_1
XFILLER_35_222 VGND VGND VPWR VPWR sky130_fd_sc_hd__fill_2
X_2012_ net766 net676 VGND VGND VPWR VPWR Inst_SimpleCLB_ConfigMem.Inst_frame4_bit23.Q
+ sky130_fd_sc_hd__dlxtp_1
XFILLER_50_247 VGND VGND VPWR VPWR sky130_fd_sc_hd__decap_3
X_1727_ net761 net711 VGND VGND VPWR VPWR Inst_SimpleCLB_ConfigMem.Inst_frame13_bit26.Q
+ sky130_fd_sc_hd__dlxtp_1
X_1658_ net770 net706 VGND VGND VPWR VPWR Inst_LG_LUT4c_frame_config_dffesr.inst_cus_mux161_buf.A1
+ sky130_fd_sc_hd__dlxtp_1
Xfanout614 net615 VGND VGND VPWR VPWR net614 sky130_fd_sc_hd__buf_8
Xfanout636 Inst_LB_LUT4c_frame_config_dffesr.O VGND VGND VPWR VPWR net636 sky130_fd_sc_hd__buf_8
X_1589_ net785 net694 VGND VGND VPWR VPWR Inst_LC_LUT4c_frame_config_dffesr.inst_cus_mux161_buf.A8
+ sky130_fd_sc_hd__dlxtp_1
Xfanout658 FrameStrobe[9] VGND VGND VPWR VPWR net658 sky130_fd_sc_hd__dlymetal6s2s_1
Xfanout625 Inst_LE_LUT4c_frame_config_dffesr.O VGND VGND VPWR VPWR net625 sky130_fd_sc_hd__buf_8
Xfanout647 W1END[2] VGND VGND VPWR VPWR net647 sky130_fd_sc_hd__clkbuf_4
XFILLER_37_15 VGND VGND VPWR VPWR sky130_fd_sc_hd__fill_1
Xfanout669 net670 VGND VGND VPWR VPWR net669 sky130_fd_sc_hd__buf_1
XFILLER_85_144 VGND VGND VPWR VPWR sky130_fd_sc_hd__decap_3
XFILLER_26_200 VGND VGND VPWR VPWR sky130_fd_sc_hd__decap_3
XTAP_TAPCELL_ROW_56_526 VGND VPWR sky130_fd_sc_hd__tapvpwrvgnd_1
XFILLER_26_233 VGND VGND VPWR VPWR sky130_fd_sc_hd__decap_3
XFILLER_26_288 VGND VGND VPWR VPWR sky130_fd_sc_hd__decap_3
XFILLER_41_258 VGND VGND VPWR VPWR sky130_fd_sc_hd__decap_3
XFILLER_5_159 VGND VGND VPWR VPWR sky130_fd_sc_hd__decap_3
XFILLER_1_321 VGND VGND VPWR VPWR sky130_fd_sc_hd__decap_3
XFILLER_78_55 VGND VGND VPWR VPWR sky130_fd_sc_hd__decap_3
XFILLER_76_100 VGND VGND VPWR VPWR sky130_fd_sc_hd__decap_3
XFILLER_78_88 VGND VGND VPWR VPWR sky130_fd_sc_hd__decap_3
XFILLER_76_133 VGND VGND VPWR VPWR sky130_fd_sc_hd__decap_3
XFILLER_64_306 VGND VGND VPWR VPWR sky130_fd_sc_hd__fill_2
XFILLER_76_144 VGND VGND VPWR VPWR sky130_fd_sc_hd__decap_3
XFILLER_76_188 VGND VGND VPWR VPWR sky130_fd_sc_hd__decap_3
XFILLER_17_255 VGND VGND VPWR VPWR sky130_fd_sc_hd__decap_3
XFILLER_32_214 VGND VGND VPWR VPWR sky130_fd_sc_hd__decap_3
X_0960_ W6END[1] net639 net644 net618 Inst_SimpleCLB_ConfigMem.Inst_frame1_bit3.Q
+ Inst_SimpleCLB_ConfigMem.Inst_frame1_bit2.Q VGND VGND VPWR VPWR _0060_ sky130_fd_sc_hd__mux4_1
XFILLER_43_91 VGND VGND VPWR VPWR sky130_fd_sc_hd__fill_1
X_0891_ Inst_SimpleCLB_ConfigMem.Inst_frame4_bit12.Q _0716_ VGND VGND VPWR VPWR _0717_
+ sky130_fd_sc_hd__and2b_1
Xoutput206 net206 VGND VGND VPWR VPWR UserCLKo sky130_fd_sc_hd__buf_1
Xoutput217 net217 VGND VGND VPWR VPWR W2BEG[6] sky130_fd_sc_hd__buf_6
Xoutput239 net239 VGND VGND VPWR VPWR WW4BEG[0] sky130_fd_sc_hd__buf_2
Xoutput228 net228 VGND VGND VPWR VPWR W6BEG[10] sky130_fd_sc_hd__buf_4
X_1512_ net314 net318 _0541_ VGND VGND VPWR VPWR _0542_ sky130_fd_sc_hd__o21ai_1
XFILLER_4_192 VGND VGND VPWR VPWR sky130_fd_sc_hd__decap_3
X_1443_ _0500_ VGND VGND VPWR VPWR _0501_ sky130_fd_sc_hd__inv_1
X_1374_ _0439_ _0440_ Inst_SimpleCLB_ConfigMem.Inst_frame11_bit7.Q VGND VGND VPWR
+ VPWR Inst_SimpleCLB_switch_matrix.SS4BEG1 sky130_fd_sc_hd__mux2_4
XFILLER_67_111 VGND VGND VPWR VPWR sky130_fd_sc_hd__fill_1
XFILLER_67_133 VGND VGND VPWR VPWR sky130_fd_sc_hd__decap_3
XFILLER_82_103 VGND VGND VPWR VPWR sky130_fd_sc_hd__fill_2
XFILLER_70_309 VGND VGND VPWR VPWR sky130_fd_sc_hd__fill_1
XTAP_TAPCELL_ROW_53_507 VGND VPWR sky130_fd_sc_hd__tapvpwrvgnd_1
XFILLER_23_225 VGND VGND VPWR VPWR sky130_fd_sc_hd__decap_3
XFILLER_23_247 VGND VGND VPWR VPWR sky130_fd_sc_hd__decap_3
XFILLER_48_36 VGND VGND VPWR VPWR sky130_fd_sc_hd__decap_3
XFILLER_58_122 VGND VGND VPWR VPWR sky130_fd_sc_hd__decap_3
XFILLER_58_144 VGND VGND VPWR VPWR sky130_fd_sc_hd__decap_3
XFILLER_46_317 VGND VGND VPWR VPWR sky130_fd_sc_hd__decap_3
XFILLER_46_339 VGND VGND VPWR VPWR sky130_fd_sc_hd__decap_3
XTAP_TAPCELL_ROW_1_195 VGND VPWR sky130_fd_sc_hd__tapvpwrvgnd_1
XFILLER_49_100 VGND VGND VPWR VPWR sky130_fd_sc_hd__decap_3
XFILLER_49_122 VGND VGND VPWR VPWR sky130_fd_sc_hd__decap_3
XFILLER_49_166 VGND VGND VPWR VPWR sky130_fd_sc_hd__fill_2
XFILLER_37_317 VGND VGND VPWR VPWR sky130_fd_sc_hd__fill_1
XFILLER_64_114 VGND VGND VPWR VPWR sky130_fd_sc_hd__decap_3
X_1090_ _0182_ _0181_ Inst_SimpleCLB_ConfigMem.Inst_frame1_bit16.Q VGND VGND VPWR
+ VPWR _0183_ sky130_fd_sc_hd__mux2_1
XFILLER_64_147 VGND VGND VPWR VPWR sky130_fd_sc_hd__fill_2
XTAP_TAPCELL_ROW_75_643 VGND VPWR sky130_fd_sc_hd__tapvpwrvgnd_1
X_1992_ net745 net677 VGND VGND VPWR VPWR Inst_SimpleCLB_ConfigMem.Inst_frame4_bit3.Q
+ sky130_fd_sc_hd__dlxtp_1
X_0943_ net619 net614 net634 net611 Inst_SimpleCLB_ConfigMem.Inst_frame3_bit11.Q Inst_SimpleCLB_ConfigMem.Inst_frame3_bit10.Q
+ VGND VGND VPWR VPWR _0044_ sky130_fd_sc_hd__mux4_2
X_0874_ _0701_ _0700_ _0619_ VGND VGND VPWR VPWR _0702_ sky130_fd_sc_hd__mux2_1
XFILLER_9_284 VGND VGND VPWR VPWR sky130_fd_sc_hd__fill_2
XPHY_EDGE_ROW_10_Left_101 VGND VGND VPWR VPWR sky130_fd_sc_hd__decap_3
XFILLER_87_206 VGND VGND VPWR VPWR sky130_fd_sc_hd__decap_3
X_1426_ Inst_SimpleCLB_ConfigMem.Inst_frame12_bit3.Q _0482_ _0485_ _0486_ VGND VGND
+ VPWR VPWR Inst_SimpleCLB_switch_matrix.EE4BEG1 sky130_fd_sc_hd__o22a_1
X_1357_ _0424_ _0426_ _0422_ VGND VGND VPWR VPWR Inst_SimpleCLB_switch_matrix.WW4BEG0
+ sky130_fd_sc_hd__a21oi_1
XFILLER_28_328 VGND VGND VPWR VPWR sky130_fd_sc_hd__decap_3
X_1288_ _0361_ _0363_ _0366_ _0591_ VGND VGND VPWR VPWR Inst_SimpleCLB_switch_matrix.E2BEG7
+ sky130_fd_sc_hd__a22o_4
XTAP_TAPCELL_ROW_81_679 VGND VPWR sky130_fd_sc_hd__tapvpwrvgnd_1
XFILLER_34_38 VGND VGND VPWR VPWR sky130_fd_sc_hd__decap_3
XFILLER_50_15 VGND VGND VPWR VPWR sky130_fd_sc_hd__decap_3
XFILLER_50_37 VGND VGND VPWR VPWR sky130_fd_sc_hd__decap_3
XFILLER_1_6 VGND VGND VPWR VPWR sky130_fd_sc_hd__fill_2
XFILLER_59_57 VGND VGND VPWR VPWR sky130_fd_sc_hd__decap_3
XTAP_TAPCELL_ROW_89_724 VGND VPWR sky130_fd_sc_hd__tapvpwrvgnd_1
XFILLER_78_228 VGND VGND VPWR VPWR sky130_fd_sc_hd__decap_3
XFILLER_75_89 VGND VGND VPWR VPWR sky130_fd_sc_hd__decap_3
XTAP_TAPCELL_ROW_29_367 VGND VPWR sky130_fd_sc_hd__tapvpwrvgnd_1
XTAP_TAPCELL_ROW_72_624 VGND VPWR sky130_fd_sc_hd__tapvpwrvgnd_1
XFILLER_54_191 VGND VGND VPWR VPWR sky130_fd_sc_hd__decap_3
XFILLER_24_60 VGND VGND VPWR VPWR sky130_fd_sc_hd__decap_3
XFILLER_10_250 VGND VGND VPWR VPWR sky130_fd_sc_hd__fill_2
XFILLER_6_221 VGND VGND VPWR VPWR sky130_fd_sc_hd__decap_3
XFILLER_69_217 VGND VGND VPWR VPWR sky130_fd_sc_hd__decap_3
X_2260_ Inst_SimpleCLB_switch_matrix.N1BEG3 VGND VGND VPWR VPWR net105 sky130_fd_sc_hd__clkbuf_2
X_1211_ _0295_ VGND VGND VPWR VPWR _0296_ sky130_fd_sc_hd__inv_2
X_2191_ EE4END[6] VGND VGND VPWR VPWR net42 sky130_fd_sc_hd__buf_1
XFILLER_1_20 VGND VGND VPWR VPWR sky130_fd_sc_hd__fill_2
X_1142_ N2END[7] E2END[7] S2END[7] WW4END[0] Inst_SimpleCLB_ConfigMem.Inst_frame5_bit18.Q
+ Inst_SimpleCLB_ConfigMem.Inst_frame5_bit19.Q VGND VGND VPWR VPWR _0231_ sky130_fd_sc_hd__mux4_2
XFILLER_1_53 VGND VGND VPWR VPWR sky130_fd_sc_hd__decap_3
XFILLER_37_125 VGND VGND VPWR VPWR sky130_fd_sc_hd__decap_3
X_1073_ _0151_ _0152_ _0143_ _0142_ Inst_SimpleCLB_ConfigMem.Inst_frame8_bit0.Q Inst_SimpleCLB_ConfigMem.Inst_frame8_bit1.Q
+ VGND VGND VPWR VPWR _0166_ sky130_fd_sc_hd__mux4_2
XFILLER_52_139 VGND VGND VPWR VPWR sky130_fd_sc_hd__fill_1
XANTENNA_190 FrameData[4] VGND VGND VPWR VPWR sky130_fd_sc_hd__diode_2
X_1975_ net781 net674 VGND VGND VPWR VPWR Inst_SimpleCLB_ConfigMem.Inst_frame5_bit18.Q
+ sky130_fd_sc_hd__dlxtp_1
X_0926_ S1END[1] S2END[5] W1END[1] net646 Inst_SimpleCLB_ConfigMem.Inst_frame2_bit10.Q
+ Inst_SimpleCLB_ConfigMem.Inst_frame2_bit11.Q VGND VGND VPWR VPWR _0029_ sky130_fd_sc_hd__mux4_1
X_0857_ net801 S2END[4] S4END[0] W2END[4] Inst_SimpleCLB_ConfigMem.Inst_frame1_bit6.Q
+ Inst_SimpleCLB_ConfigMem.Inst_frame1_bit7.Q VGND VGND VPWR VPWR _0686_ sky130_fd_sc_hd__mux4_1
X_0788_ net621 net612 net631 net608 Inst_SimpleCLB_ConfigMem.Inst_frame4_bit7.Q Inst_SimpleCLB_ConfigMem.Inst_frame4_bit6.Q
+ VGND VGND VPWR VPWR _0622_ sky130_fd_sc_hd__mux4_1
XPHY_EDGE_ROW_89_Right_89 VGND VGND VPWR VPWR sky130_fd_sc_hd__decap_3
XTAP_TAPCELL_ROW_86_705 VGND VPWR sky130_fd_sc_hd__tapvpwrvgnd_1
XFILLER_29_38 VGND VGND VPWR VPWR sky130_fd_sc_hd__decap_3
X_1409_ Inst_SimpleCLB_ConfigMem.Inst_frame12_bit12.Q _0463_ _0465_ Inst_SimpleCLB_ConfigMem.Inst_frame12_bit13.Q
+ _0461_ VGND VGND VPWR VPWR _0473_ sky130_fd_sc_hd__a311o_1
X_2389_ W6END[9] VGND VGND VPWR VPWR net236 sky130_fd_sc_hd__clkbuf_2
XFILLER_83_231 VGND VGND VPWR VPWR sky130_fd_sc_hd__decap_3
XFILLER_45_15 VGND VGND VPWR VPWR sky130_fd_sc_hd__decap_3
XFILLER_24_331 VGND VGND VPWR VPWR sky130_fd_sc_hd__decap_3
XTAP_TAPCELL_ROW_26_348 VGND VPWR sky130_fd_sc_hd__tapvpwrvgnd_1
XFILLER_51_172 VGND VGND VPWR VPWR sky130_fd_sc_hd__decap_3
XTAP_TAPCELL_ROW_34_392 VGND VPWR sky130_fd_sc_hd__tapvpwrvgnd_1
XFILLER_51_183 VGND VGND VPWR VPWR sky130_fd_sc_hd__fill_1
XFILLER_10_51 VGND VGND VPWR VPWR sky130_fd_sc_hd__decap_3
XFILLER_3_246 VGND VGND VPWR VPWR sky130_fd_sc_hd__fill_2
XFILLER_3_279 VGND VGND VPWR VPWR sky130_fd_sc_hd__fill_1
XFILLER_74_220 VGND VGND VPWR VPWR sky130_fd_sc_hd__decap_3
XFILLER_19_169 VGND VGND VPWR VPWR sky130_fd_sc_hd__fill_1
XFILLER_19_93 VGND VGND VPWR VPWR sky130_fd_sc_hd__decap_3
XFILLER_15_320 VGND VGND VPWR VPWR sky130_fd_sc_hd__fill_1
XFILLER_30_301 VGND VGND VPWR VPWR sky130_fd_sc_hd__decap_3
XFILLER_42_194 VGND VGND VPWR VPWR sky130_fd_sc_hd__fill_2
X_1760_ net758 net716 VGND VGND VPWR VPWR Inst_SimpleCLB_ConfigMem.Inst_frame12_bit27.Q
+ sky130_fd_sc_hd__dlxtp_1
X_1691_ net768 net707 VGND VGND VPWR VPWR Inst_LH_LUT4c_frame_config_dffesr.inst_cus_mux161_buf.A15
+ sky130_fd_sc_hd__dlxtp_1
X_2312_ Inst_SimpleCLB_switch_matrix.S1BEG3 VGND VGND VPWR VPWR net157 sky130_fd_sc_hd__buf_1
XFILLER_32_3 VGND VGND VPWR VPWR sky130_fd_sc_hd__fill_2
X_2243_ net669 VGND VGND VPWR VPWR net98 sky130_fd_sc_hd__buf_1
X_2174_ E2MID[5] VGND VGND VPWR VPWR net19 sky130_fd_sc_hd__clkbuf_1
XFILLER_65_220 VGND VGND VPWR VPWR sky130_fd_sc_hd__decap_3
X_1125_ _0213_ _0215_ _0201_ VGND VGND VPWR VPWR _0216_ sky130_fd_sc_hd__mux2_1
XFILLER_65_253 VGND VGND VPWR VPWR sky130_fd_sc_hd__decap_3
XFILLER_65_275 VGND VGND VPWR VPWR sky130_fd_sc_hd__decap_3
XFILLER_25_139 VGND VGND VPWR VPWR sky130_fd_sc_hd__fill_2
XFILLER_80_234 VGND VGND VPWR VPWR sky130_fd_sc_hd__decap_3
X_1056_ _0148_ _0149_ Inst_SimpleCLB_ConfigMem.Inst_frame2_bit16.Q VGND VGND VPWR
+ VPWR _0150_ sky130_fd_sc_hd__mux2_1
XTAP_TAPCELL_ROW_23_329 VGND VPWR sky130_fd_sc_hd__tapvpwrvgnd_1
XFILLER_33_161 VGND VGND VPWR VPWR sky130_fd_sc_hd__decap_3
XFILLER_40_109 VGND VGND VPWR VPWR sky130_fd_sc_hd__decap_3
X_1958_ net776 net672 VGND VGND VPWR VPWR Inst_SimpleCLB_ConfigMem.Inst_frame5_bit1.Q
+ sky130_fd_sc_hd__dlxtp_1
X_0909_ _0011_ _0012_ VGND VGND VPWR VPWR _0013_ sky130_fd_sc_hd__nand2_2
X_1889_ net756 net659 VGND VGND VPWR VPWR Inst_SimpleCLB_ConfigMem.Inst_frame8_bit28.Q
+ sky130_fd_sc_hd__dlxtp_1
Xoutput17 net17 VGND VGND VPWR VPWR E2BEGb[3] sky130_fd_sc_hd__buf_2
Xoutput39 net39 VGND VGND VPWR VPWR EE4BEG[14] sky130_fd_sc_hd__buf_6
Xoutput28 net28 VGND VGND VPWR VPWR E6BEG[4] sky130_fd_sc_hd__buf_2
XFILLER_88_323 VGND VGND VPWR VPWR sky130_fd_sc_hd__fill_1
XFILLER_88_301 VGND VGND VPWR VPWR sky130_fd_sc_hd__fill_2
XFILLER_48_209 VGND VGND VPWR VPWR sky130_fd_sc_hd__decap_3
XFILLER_56_253 VGND VGND VPWR VPWR sky130_fd_sc_hd__decap_3
XFILLER_72_24 VGND VGND VPWR VPWR sky130_fd_sc_hd__decap_3
XFILLER_71_289 VGND VGND VPWR VPWR sky130_fd_sc_hd__decap_3
XFILLER_72_35 VGND VGND VPWR VPWR sky130_fd_sc_hd__decap_3
XFILLER_12_334 VGND VGND VPWR VPWR sky130_fd_sc_hd__decap_3
XANTENNA_90 NN4END[6] VGND VGND VPWR VPWR sky130_fd_sc_hd__diode_2
XFILLER_21_83 VGND VGND VPWR VPWR sky130_fd_sc_hd__decap_3
XFILLER_46_91 VGND VGND VPWR VPWR sky130_fd_sc_hd__decap_3
XFILLER_15_183 VGND VGND VPWR VPWR sky130_fd_sc_hd__decap_3
XFILLER_30_120 VGND VGND VPWR VPWR sky130_fd_sc_hd__decap_3
XFILLER_7_30 VGND VGND VPWR VPWR sky130_fd_sc_hd__decap_3
X_1812_ net787 net724 VGND VGND VPWR VPWR Inst_SimpleCLB_ConfigMem.Inst_frame10_bit15.Q
+ sky130_fd_sc_hd__dlxtp_1
XFILLER_30_186 VGND VGND VPWR VPWR sky130_fd_sc_hd__decap_3
XFILLER_30_197 VGND VGND VPWR VPWR sky130_fd_sc_hd__decap_3
X_1743_ net796 net719 VGND VGND VPWR VPWR Inst_SimpleCLB_ConfigMem.Inst_frame12_bit10.Q
+ sky130_fd_sc_hd__dlxtp_1
X_1674_ net742 net709 VGND VGND VPWR VPWR Inst_LG_LUT4c_frame_config_dffesr.c_I0mux
+ sky130_fd_sc_hd__dlxtp_1
XFILLER_85_337 VGND VGND VPWR VPWR sky130_fd_sc_hd__fill_2
X_2226_ net770 VGND VGND VPWR VPWR net63 sky130_fd_sc_hd__clkbuf_1
XFILLER_38_242 VGND VGND VPWR VPWR sky130_fd_sc_hd__decap_3
XFILLER_38_253 VGND VGND VPWR VPWR sky130_fd_sc_hd__fill_2
X_2157_ Inst_SimpleCLB_switch_matrix.E1BEG0 VGND VGND VPWR VPWR net2 sky130_fd_sc_hd__clkbuf_2
XFILLER_53_212 VGND VGND VPWR VPWR sky130_fd_sc_hd__decap_3
X_1108_ _0163_ _0160_ Inst_LE_LUT4c_frame_config_dffesr.c_I0mux VGND VGND VPWR VPWR
+ _0199_ sky130_fd_sc_hd__a21bo_1
X_2088_ net745 net689 VGND VGND VPWR VPWR Inst_SimpleCLB_ConfigMem.Inst_frame1_bit3.Q
+ sky130_fd_sc_hd__dlxtp_1
XFILLER_13_109 VGND VGND VPWR VPWR sky130_fd_sc_hd__decap_3
XFILLER_53_278 VGND VGND VPWR VPWR sky130_fd_sc_hd__fill_2
X_1039_ net620 net615 net625 net309 Inst_SimpleCLB_ConfigMem.Inst_frame3_bit15.Q Inst_SimpleCLB_ConfigMem.Inst_frame3_bit14.Q
+ VGND VGND VPWR VPWR _0134_ sky130_fd_sc_hd__mux4_2
XFILLER_21_186 VGND VGND VPWR VPWR sky130_fd_sc_hd__decap_3
XFILLER_67_24 VGND VGND VPWR VPWR sky130_fd_sc_hd__decap_3
XTAP_TAPCELL_ROW_59_546 VGND VPWR sky130_fd_sc_hd__tapvpwrvgnd_1
XFILLER_29_242 VGND VGND VPWR VPWR sky130_fd_sc_hd__decap_3
XPHY_EDGE_ROW_48_Left_139 VGND VGND VPWR VPWR sky130_fd_sc_hd__decap_3
XFILLER_44_212 VGND VGND VPWR VPWR sky130_fd_sc_hd__decap_3
XFILLER_44_234 VGND VGND VPWR VPWR sky130_fd_sc_hd__decap_3
XTAP_TAPCELL_ROW_67_590 VGND VPWR sky130_fd_sc_hd__tapvpwrvgnd_1
XFILLER_44_267 VGND VGND VPWR VPWR sky130_fd_sc_hd__fill_1
XFILLER_44_289 VGND VGND VPWR VPWR sky130_fd_sc_hd__decap_3
XFILLER_12_175 VGND VGND VPWR VPWR sky130_fd_sc_hd__decap_3
XFILLER_8_135 VGND VGND VPWR VPWR sky130_fd_sc_hd__decap_3
XFILLER_12_197 VGND VGND VPWR VPWR sky130_fd_sc_hd__decap_3
XFILLER_32_71 VGND VGND VPWR VPWR sky130_fd_sc_hd__decap_3
XTAP_TAPCELL_ROW_50_490 VGND VPWR sky130_fd_sc_hd__tapvpwrvgnd_1
XPHY_EDGE_ROW_57_Left_148 VGND VGND VPWR VPWR sky130_fd_sc_hd__decap_3
X_1390_ Inst_SimpleCLB_ConfigMem.Inst_frame12_bit16.Q _0452_ _0454_ _0448_ _0450_
+ VGND VGND VPWR VPWR _0455_ sky130_fd_sc_hd__a32o_1
XPHY_EDGE_ROW_66_Left_157 VGND VGND VPWR VPWR sky130_fd_sc_hd__decap_3
X_2011_ net768 net676 VGND VGND VPWR VPWR Inst_SimpleCLB_ConfigMem.Inst_frame4_bit22.Q
+ sky130_fd_sc_hd__dlxtp_1
XFILLER_90_340 VGND VGND VPWR VPWR sky130_fd_sc_hd__fill_1
XFILLER_50_259 VGND VGND VPWR VPWR sky130_fd_sc_hd__decap_3
XPHY_EDGE_ROW_75_Left_166 VGND VGND VPWR VPWR sky130_fd_sc_hd__decap_3
X_1726_ net762 net715 VGND VGND VPWR VPWR Inst_SimpleCLB_ConfigMem.Inst_frame13_bit25.Q
+ sky130_fd_sc_hd__dlxtp_1
X_1657_ net773 net705 VGND VGND VPWR VPWR Inst_LG_LUT4c_frame_config_dffesr.inst_cus_mux161_buf.A0
+ sky130_fd_sc_hd__dlxtp_1
X_1588_ net787 net694 VGND VGND VPWR VPWR Inst_LC_LUT4c_frame_config_dffesr.inst_cus_mux161_buf.A7
+ sky130_fd_sc_hd__dlxtp_1
Xfanout615 Inst_LG_LUT4c_frame_config_dffesr.O VGND VGND VPWR VPWR net615 sky130_fd_sc_hd__buf_8
XPHY_EDGE_ROW_84_Left_175 VGND VGND VPWR VPWR sky130_fd_sc_hd__decap_3
Xfanout637 Inst_LB_LUT4c_frame_config_dffesr.O VGND VGND VPWR VPWR net637 sky130_fd_sc_hd__clkbuf_2
Xfanout626 net628 VGND VGND VPWR VPWR net626 sky130_fd_sc_hd__buf_6
Xfanout648 net649 VGND VGND VPWR VPWR net648 sky130_fd_sc_hd__buf_2
XFILLER_85_134 VGND VGND VPWR VPWR sky130_fd_sc_hd__decap_3
Xfanout659 FrameStrobe[8] VGND VGND VPWR VPWR net659 sky130_fd_sc_hd__buf_2
XFILLER_85_167 VGND VGND VPWR VPWR sky130_fd_sc_hd__fill_1
XTAP_TAPCELL_ROW_56_527 VGND VPWR sky130_fd_sc_hd__tapvpwrvgnd_1
X_2209_ net744 VGND VGND VPWR VPWR net76 sky130_fd_sc_hd__buf_1
XFILLER_26_256 VGND VGND VPWR VPWR sky130_fd_sc_hd__decap_3
XFILLER_5_116 VGND VGND VPWR VPWR sky130_fd_sc_hd__fill_1
XFILLER_5_138 VGND VGND VPWR VPWR sky130_fd_sc_hd__decap_3
XFILLER_1_300 VGND VGND VPWR VPWR sky130_fd_sc_hd__decap_3
XFILLER_49_315 VGND VGND VPWR VPWR sky130_fd_sc_hd__fill_2
XFILLER_49_326 VGND VGND VPWR VPWR sky130_fd_sc_hd__fill_1
XFILLER_76_156 VGND VGND VPWR VPWR sky130_fd_sc_hd__fill_2
XFILLER_17_234 VGND VGND VPWR VPWR sky130_fd_sc_hd__decap_3
XFILLER_32_226 VGND VGND VPWR VPWR sky130_fd_sc_hd__decap_3
XFILLER_32_248 VGND VGND VPWR VPWR sky130_fd_sc_hd__decap_3
XFILLER_32_259 VGND VGND VPWR VPWR sky130_fd_sc_hd__decap_3
X_0890_ W2END[5] net638 net642 net629 Inst_SimpleCLB_ConfigMem.Inst_frame4_bit11.Q
+ Inst_SimpleCLB_ConfigMem.Inst_frame4_bit10.Q VGND VGND VPWR VPWR _0716_ sky130_fd_sc_hd__mux4_1
Xoutput207 net207 VGND VGND VPWR VPWR W1BEG[0] sky130_fd_sc_hd__buf_4
Xoutput218 net218 VGND VGND VPWR VPWR W2BEG[7] sky130_fd_sc_hd__clkbuf_4
Xoutput229 Inst_SimpleCLB_switch_matrix.W6BEG1 VGND VGND VPWR VPWR W6BEG[11] sky130_fd_sc_hd__buf_6
X_1511_ _0540_ VGND VGND VPWR VPWR _0541_ sky130_fd_sc_hd__inv_2
X_1442_ net629 _0140_ Inst_SimpleCLB_ConfigMem.Inst_frame13_bit16.Q VGND VGND VPWR
+ VPWR _0500_ sky130_fd_sc_hd__mux2_1
X_1373_ net609 _0667_ net255 _0176_ Inst_SimpleCLB_ConfigMem.Inst_frame11_bit5.Q Inst_SimpleCLB_ConfigMem.Inst_frame11_bit6.Q
+ VGND VGND VPWR VPWR _0440_ sky130_fd_sc_hd__mux4_2
XTAP_TAPCELL_ROW_53_508 VGND VPWR sky130_fd_sc_hd__tapvpwrvgnd_1
XFILLER_90_181 VGND VGND VPWR VPWR sky130_fd_sc_hd__decap_3
XFILLER_31_281 VGND VGND VPWR VPWR sky130_fd_sc_hd__decap_3
X_1709_ net735 net711 VGND VGND VPWR VPWR Inst_SimpleCLB_ConfigMem.Inst_frame13_bit8.Q
+ sky130_fd_sc_hd__dlxtp_1
XFILLER_48_15 VGND VGND VPWR VPWR sky130_fd_sc_hd__decap_3
XFILLER_58_101 VGND VGND VPWR VPWR sky130_fd_sc_hd__fill_2
XFILLER_58_134 VGND VGND VPWR VPWR sky130_fd_sc_hd__decap_3
XTAP_TAPCELL_ROW_1_196 VGND VPWR sky130_fd_sc_hd__tapvpwrvgnd_1
XFILLER_14_248 VGND VGND VPWR VPWR sky130_fd_sc_hd__decap_3
XFILLER_89_66 VGND VGND VPWR VPWR sky130_fd_sc_hd__fill_1
XFILLER_1_141 VGND VGND VPWR VPWR sky130_fd_sc_hd__fill_2
XFILLER_49_134 VGND VGND VPWR VPWR sky130_fd_sc_hd__fill_2
XFILLER_38_81 VGND VGND VPWR VPWR sky130_fd_sc_hd__decap_3
XFILLER_49_189 VGND VGND VPWR VPWR sky130_fd_sc_hd__decap_3
XFILLER_64_126 VGND VGND VPWR VPWR sky130_fd_sc_hd__decap_3
X_1991_ net751 net677 VGND VGND VPWR VPWR Inst_SimpleCLB_ConfigMem.Inst_frame4_bit2.Q
+ sky130_fd_sc_hd__dlxtp_1
X_0942_ Inst_SimpleCLB_ConfigMem.Inst_frame3_bit12.Q _0042_ VGND VGND VPWR VPWR _0043_
+ sky130_fd_sc_hd__and2b_1
X_0873_ Inst_LA_LUT4c_frame_config_dffesr.inst_cus_mux161_buf.A8 Inst_LA_LUT4c_frame_config_dffesr.inst_cus_mux161_buf.A9
+ _0648_ VGND VGND VPWR VPWR _0701_ sky130_fd_sc_hd__mux2_1
X_1425_ _0483_ Inst_SimpleCLB_ConfigMem.Inst_frame12_bit2.Q Inst_SimpleCLB_ConfigMem.Inst_frame12_bit3.Q
+ VGND VGND VPWR VPWR _0486_ sky130_fd_sc_hd__a21bo_1
X_1356_ Inst_SimpleCLB_ConfigMem.Inst_frame11_bit23.Q _0425_ Inst_SimpleCLB_ConfigMem.Inst_frame11_bit24.Q
+ VGND VGND VPWR VPWR _0426_ sky130_fd_sc_hd__a21oi_1
XFILLER_28_307 VGND VGND VPWR VPWR sky130_fd_sc_hd__fill_1
X_1287_ _0364_ _0365_ Inst_SimpleCLB_ConfigMem.Inst_frame3_bit24.Q VGND VGND VPWR
+ VPWR _0366_ sky130_fd_sc_hd__mux2_1
XFILLER_70_118 VGND VGND VPWR VPWR sky130_fd_sc_hd__decap_3
XFILLER_50_27 VGND VGND VPWR VPWR sky130_fd_sc_hd__fill_1
XTAP_TAPCELL_ROW_89_725 VGND VPWR sky130_fd_sc_hd__tapvpwrvgnd_1
XFILLER_86_251 VGND VGND VPWR VPWR sky130_fd_sc_hd__fill_1
XFILLER_19_318 VGND VGND VPWR VPWR sky130_fd_sc_hd__fill_1
XFILLER_46_126 VGND VGND VPWR VPWR sky130_fd_sc_hd__fill_2
XFILLER_75_57 VGND VGND VPWR VPWR sky130_fd_sc_hd__fill_2
XFILLER_27_340 VGND VGND VPWR VPWR sky130_fd_sc_hd__decap_3
XTAP_TAPCELL_ROW_72_625 VGND VPWR sky130_fd_sc_hd__tapvpwrvgnd_1
XFILLER_6_200 VGND VGND VPWR VPWR sky130_fd_sc_hd__decap_3
XFILLER_6_233 VGND VGND VPWR VPWR sky130_fd_sc_hd__decap_3
X_1210_ _0291_ _0290_ VGND VGND VPWR VPWR _0295_ sky130_fd_sc_hd__or2_4
X_2190_ EE4END[5] VGND VGND VPWR VPWR net41 sky130_fd_sc_hd__buf_1
XFILLER_27_6 VGND VGND VPWR VPWR sky130_fd_sc_hd__decap_3
X_1141_ Inst_SimpleCLB_ConfigMem.Inst_frame8_bit6.Q _0229_ VGND VGND VPWR VPWR _0230_
+ sky130_fd_sc_hd__nand2_1
XFILLER_77_284 VGND VGND VPWR VPWR sky130_fd_sc_hd__decap_3
XFILLER_18_340 VGND VGND VPWR VPWR sky130_fd_sc_hd__decap_3
X_1072_ _0129_ _0164_ Inst_LF_LUT4c_frame_config_dffesr.c_I0mux VGND VGND VPWR VPWR
+ _0165_ sky130_fd_sc_hd__mux2_1
XFILLER_45_181 VGND VGND VPWR VPWR sky130_fd_sc_hd__fill_2
XANTENNA_191 FrameData[4] VGND VGND VPWR VPWR sky130_fd_sc_hd__diode_2
XANTENNA_180 net790 VGND VGND VPWR VPWR sky130_fd_sc_hd__diode_2
X_1974_ net783 net671 VGND VGND VPWR VPWR Inst_SimpleCLB_ConfigMem.Inst_frame5_bit17.Q
+ sky130_fd_sc_hd__dlxtp_1
X_0925_ N1END[1] N2END[5] E1END[1] E2END[5] Inst_SimpleCLB_ConfigMem.Inst_frame2_bit10.Q
+ Inst_SimpleCLB_ConfigMem.Inst_frame2_bit11.Q VGND VGND VPWR VPWR _0028_ sky130_fd_sc_hd__mux4_1
X_0856_ net653 N2END[4] net650 E2END[4] Inst_SimpleCLB_ConfigMem.Inst_frame1_bit7.Q
+ Inst_SimpleCLB_ConfigMem.Inst_frame1_bit6.Q VGND VGND VPWR VPWR _0685_ sky130_fd_sc_hd__mux4_1
X_0787_ Inst_SimpleCLB_ConfigMem.Inst_frame4_bit8.Q _0620_ VGND VGND VPWR VPWR _0621_
+ sky130_fd_sc_hd__nand2b_1
XTAP_TAPCELL_ROW_86_706 VGND VPWR sky130_fd_sc_hd__tapvpwrvgnd_1
X_1408_ Inst_SimpleCLB_ConfigMem.Inst_frame12_bit11.Q _0469_ _0471_ Inst_SimpleCLB_ConfigMem.Inst_frame12_bit12.Q
+ VGND VGND VPWR VPWR _0472_ sky130_fd_sc_hd__o211a_1
X_2388_ W6END[8] VGND VGND VPWR VPWR net235 sky130_fd_sc_hd__clkbuf_2
XFILLER_68_251 VGND VGND VPWR VPWR sky130_fd_sc_hd__fill_1
XFILLER_28_115 VGND VGND VPWR VPWR sky130_fd_sc_hd__decap_3
X_1339_ Inst_SimpleCLB_ConfigMem.Inst_frame11_bit29.Q _0410_ VGND VGND VPWR VPWR _0411_
+ sky130_fd_sc_hd__nand2_1
XFILLER_83_243 VGND VGND VPWR VPWR sky130_fd_sc_hd__decap_3
XFILLER_45_49 VGND VGND VPWR VPWR sky130_fd_sc_hd__decap_3
XTAP_TAPCELL_ROW_26_349 VGND VPWR sky130_fd_sc_hd__tapvpwrvgnd_1
XTAP_TAPCELL_ROW_34_393 VGND VPWR sky130_fd_sc_hd__tapvpwrvgnd_1
XFILLER_3_203 VGND VGND VPWR VPWR sky130_fd_sc_hd__fill_1
XFILLER_3_225 VGND VGND VPWR VPWR sky130_fd_sc_hd__decap_3
XFILLER_10_85 VGND VGND VPWR VPWR sky130_fd_sc_hd__fill_1
XFILLER_19_137 VGND VGND VPWR VPWR sky130_fd_sc_hd__decap_3
XFILLER_19_72 VGND VGND VPWR VPWR sky130_fd_sc_hd__decap_3
XFILLER_74_265 VGND VGND VPWR VPWR sky130_fd_sc_hd__fill_1
XFILLER_34_107 VGND VGND VPWR VPWR sky130_fd_sc_hd__fill_2
XFILLER_15_343 VGND VGND VPWR VPWR sky130_fd_sc_hd__decap_3
XFILLER_27_192 VGND VGND VPWR VPWR sky130_fd_sc_hd__decap_3
XFILLER_35_60 VGND VGND VPWR VPWR sky130_fd_sc_hd__decap_3
X_1690_ net771 net708 VGND VGND VPWR VPWR Inst_LH_LUT4c_frame_config_dffesr.inst_cus_mux161_buf.A14
+ sky130_fd_sc_hd__dlxtp_1
X_2242_ net673 VGND VGND VPWR VPWR net97 sky130_fd_sc_hd__buf_1
X_2173_ E2MID[4] VGND VGND VPWR VPWR net18 sky130_fd_sc_hd__clkbuf_2
X_1124_ Inst_LE_LUT4c_frame_config_dffesr.inst_cus_mux161_buf.A0 _0155_ _0156_ Inst_LE_LUT4c_frame_config_dffesr.inst_cus_mux161_buf.A6
+ _0214_ VGND VGND VPWR VPWR _0215_ sky130_fd_sc_hd__o221a_1
X_1055_ S1END[2] W1END[0] S2END[6] W1END[2] Inst_SimpleCLB_ConfigMem.Inst_frame2_bit15.Q
+ Inst_SimpleCLB_ConfigMem.Inst_frame2_bit14.Q VGND VGND VPWR VPWR _0149_ sky130_fd_sc_hd__mux4_1
XFILLER_65_287 VGND VGND VPWR VPWR sky130_fd_sc_hd__decap_3
XFILLER_80_246 VGND VGND VPWR VPWR sky130_fd_sc_hd__decap_3
XFILLER_33_140 VGND VGND VPWR VPWR sky130_fd_sc_hd__decap_3
XFILLER_21_335 VGND VGND VPWR VPWR sky130_fd_sc_hd__fill_1
XFILLER_21_346 VGND VGND VPWR VPWR sky130_fd_sc_hd__fill_1
X_1957_ net798 net672 VGND VGND VPWR VPWR Inst_SimpleCLB_ConfigMem.Inst_frame5_bit0.Q
+ sky130_fd_sc_hd__dlxtp_1
XTAP_TAPCELL_ROW_31_374 VGND VPWR sky130_fd_sc_hd__tapvpwrvgnd_1
X_0908_ Ci _0670_ VGND VGND VPWR VPWR _0012_ sky130_fd_sc_hd__nand2_1
X_1888_ net758 net659 VGND VGND VPWR VPWR Inst_SimpleCLB_ConfigMem.Inst_frame8_bit27.Q
+ sky130_fd_sc_hd__dlxtp_1
X_0839_ N2MID[5] E2MID[5] S2MID[5] W2MID[5] Inst_SimpleCLB_ConfigMem.Inst_frame7_bit30.Q
+ Inst_SimpleCLB_ConfigMem.Inst_frame7_bit31.Q VGND VGND VPWR VPWR _0669_ sky130_fd_sc_hd__mux4_2
Xoutput18 net18 VGND VGND VPWR VPWR E2BEGb[4] sky130_fd_sc_hd__buf_2
Xoutput29 net29 VGND VGND VPWR VPWR E6BEG[5] sky130_fd_sc_hd__buf_2
XFILLER_56_243 VGND VGND VPWR VPWR sky130_fd_sc_hd__decap_3
XFILLER_71_246 VGND VGND VPWR VPWR sky130_fd_sc_hd__decap_3
XFILLER_24_173 VGND VGND VPWR VPWR sky130_fd_sc_hd__decap_3
XANTENNA_80 NN4END[11] VGND VGND VPWR VPWR sky130_fd_sc_hd__diode_2
XANTENNA_91 NN4END[7] VGND VGND VPWR VPWR sky130_fd_sc_hd__diode_2
XFILLER_47_210 VGND VGND VPWR VPWR sky130_fd_sc_hd__decap_3
XFILLER_15_151 VGND VGND VPWR VPWR sky130_fd_sc_hd__decap_3
XFILLER_62_268 VGND VGND VPWR VPWR sky130_fd_sc_hd__decap_3
X_1811_ net789 net724 VGND VGND VPWR VPWR Inst_SimpleCLB_ConfigMem.Inst_frame10_bit14.Q
+ sky130_fd_sc_hd__dlxtp_1
XFILLER_30_165 VGND VGND VPWR VPWR sky130_fd_sc_hd__decap_3
XFILLER_7_42 VGND VGND VPWR VPWR sky130_fd_sc_hd__decap_3
X_1742_ net734 net718 VGND VGND VPWR VPWR Inst_SimpleCLB_ConfigMem.Inst_frame12_bit9.Q
+ sky130_fd_sc_hd__dlxtp_1
XFILLER_7_97 VGND VGND VPWR VPWR sky130_fd_sc_hd__decap_3
X_1673_ net744 net709 VGND VGND VPWR VPWR Inst_LG_LUT4c_frame_config_dffesr.c_out_mux
+ sky130_fd_sc_hd__dlxtp_1
X_2225_ net773 VGND VGND VPWR VPWR net62 sky130_fd_sc_hd__buf_1
XFILLER_38_221 VGND VGND VPWR VPWR sky130_fd_sc_hd__fill_2
XFILLER_38_276 VGND VGND VPWR VPWR sky130_fd_sc_hd__decap_3
X_2156_ clknet_1_1__leaf_UserCLK_regs _0007_ VGND VGND VPWR VPWR Inst_LG_LUT4c_frame_config_dffesr.LUT_flop
+ sky130_fd_sc_hd__dfxtp_1
XPHY_EDGE_ROW_5_Right_5 VGND VGND VPWR VPWR sky130_fd_sc_hd__decap_3
X_2087_ net751 net689 VGND VGND VPWR VPWR Inst_SimpleCLB_ConfigMem.Inst_frame1_bit2.Q
+ sky130_fd_sc_hd__dlxtp_1
X_1107_ _0198_ Inst_LF_LUT4c_frame_config_dffesr.LUT_flop Inst_LF_LUT4c_frame_config_dffesr.c_out_mux
+ VGND VGND VPWR VPWR Inst_LF_LUT4c_frame_config_dffesr.O sky130_fd_sc_hd__mux2_4
X_1038_ Inst_SimpleCLB_ConfigMem.Inst_frame3_bit16.Q _0132_ VGND VGND VPWR VPWR _0133_
+ sky130_fd_sc_hd__and2b_1
XFILLER_21_154 VGND VGND VPWR VPWR sky130_fd_sc_hd__fill_1
XFILLER_21_165 VGND VGND VPWR VPWR sky130_fd_sc_hd__decap_3
XFILLER_88_165 VGND VGND VPWR VPWR sky130_fd_sc_hd__fill_1
XFILLER_29_254 VGND VGND VPWR VPWR sky130_fd_sc_hd__decap_3
XTAP_TAPCELL_ROW_59_547 VGND VPWR sky130_fd_sc_hd__tapvpwrvgnd_1
XFILLER_83_24 VGND VGND VPWR VPWR sky130_fd_sc_hd__decap_3
XFILLER_83_57 VGND VGND VPWR VPWR sky130_fd_sc_hd__fill_1
XFILLER_44_246 VGND VGND VPWR VPWR sky130_fd_sc_hd__decap_3
XTAP_TAPCELL_ROW_67_591 VGND VPWR sky130_fd_sc_hd__tapvpwrvgnd_1
XFILLER_83_79 VGND VGND VPWR VPWR sky130_fd_sc_hd__decap_3
XFILLER_8_103 VGND VGND VPWR VPWR sky130_fd_sc_hd__decap_3
XFILLER_12_187 VGND VGND VPWR VPWR sky130_fd_sc_hd__decap_3
XFILLER_32_83 VGND VGND VPWR VPWR sky130_fd_sc_hd__fill_1
XTAP_TAPCELL_ROW_50_491 VGND VPWR sky130_fd_sc_hd__tapvpwrvgnd_1
XFILLER_79_110 VGND VGND VPWR VPWR sky130_fd_sc_hd__fill_2
XFILLER_79_132 VGND VGND VPWR VPWR sky130_fd_sc_hd__decap_3
X_2010_ net770 net677 VGND VGND VPWR VPWR Inst_SimpleCLB_ConfigMem.Inst_frame4_bit21.Q
+ sky130_fd_sc_hd__dlxtp_1
X_1725_ net764 net715 VGND VGND VPWR VPWR Inst_SimpleCLB_ConfigMem.Inst_frame13_bit24.Q
+ sky130_fd_sc_hd__dlxtp_1
X_1656_ net778 net703 VGND VGND VPWR VPWR Inst_LF_LUT4c_frame_config_dffesr.c_reset_value
+ sky130_fd_sc_hd__dlxtp_1
X_1587_ net789 net695 VGND VGND VPWR VPWR Inst_LC_LUT4c_frame_config_dffesr.inst_cus_mux161_buf.A6
+ sky130_fd_sc_hd__dlxtp_1
Xfanout627 net628 VGND VGND VPWR VPWR net627 sky130_fd_sc_hd__clkbuf_2
Xfanout616 Inst_LD_LUT4c_frame_config_dffesr.O VGND VGND VPWR VPWR net616 sky130_fd_sc_hd__buf_2
Xfanout649 N1END[3] VGND VGND VPWR VPWR net649 sky130_fd_sc_hd__clkbuf_2
Xfanout638 net639 VGND VGND VPWR VPWR net638 sky130_fd_sc_hd__buf_2
XFILLER_26_213 VGND VGND VPWR VPWR sky130_fd_sc_hd__decap_3
XTAP_TAPCELL_ROW_56_528 VGND VPWR sky130_fd_sc_hd__tapvpwrvgnd_1
X_2208_ net745 VGND VGND VPWR VPWR net75 sky130_fd_sc_hd__buf_1
X_2139_ net768 net731 VGND VGND VPWR VPWR Inst_SimpleCLB_ConfigMem.Inst_frame0_bit22.Q
+ sky130_fd_sc_hd__dlxtp_1
XTAP_TAPCELL_ROW_64_572 VGND VPWR sky130_fd_sc_hd__tapvpwrvgnd_1
XFILLER_78_46 VGND VGND VPWR VPWR sky130_fd_sc_hd__decap_3
XFILLER_1_345 VGND VGND VPWR VPWR sky130_fd_sc_hd__fill_2
XFILLER_76_124 VGND VGND VPWR VPWR sky130_fd_sc_hd__decap_3
XFILLER_27_72 VGND VGND VPWR VPWR sky130_fd_sc_hd__decap_3
XFILLER_17_268 VGND VGND VPWR VPWR sky130_fd_sc_hd__decap_3
XFILLER_43_82 VGND VGND VPWR VPWR sky130_fd_sc_hd__decap_3
Xoutput208 net208 VGND VGND VPWR VPWR W1BEG[1] sky130_fd_sc_hd__buf_4
Xoutput219 net219 VGND VGND VPWR VPWR W2BEGb[0] sky130_fd_sc_hd__buf_2
XFILLER_57_6 VGND VGND VPWR VPWR sky130_fd_sc_hd__decap_3
X_1510_ Inst_SimpleCLB_ConfigMem.Inst_frame8_bit24.Q _0539_ VGND VGND VPWR VPWR _0540_
+ sky130_fd_sc_hd__and2_1
XFILLER_4_183 VGND VGND VPWR VPWR sky130_fd_sc_hd__decap_3
X_1441_ Inst_SimpleCLB_ConfigMem.Inst_frame13_bit17.Q _0498_ VGND VGND VPWR VPWR _0499_
+ sky130_fd_sc_hd__nand2_1
X_1372_ net649 net802 net646 net305 Inst_SimpleCLB_ConfigMem.Inst_frame11_bit5.Q Inst_SimpleCLB_ConfigMem.Inst_frame11_bit6.Q
+ VGND VGND VPWR VPWR _0439_ sky130_fd_sc_hd__mux4_1
XFILLER_67_102 VGND VGND VPWR VPWR sky130_fd_sc_hd__decap_3
XFILLER_55_319 VGND VGND VPWR VPWR sky130_fd_sc_hd__fill_2
XFILLER_82_138 VGND VGND VPWR VPWR sky130_fd_sc_hd__fill_2
XTAP_TAPCELL_ROW_53_509 VGND VPWR sky130_fd_sc_hd__tapvpwrvgnd_1
XFILLER_23_216 VGND VGND VPWR VPWR sky130_fd_sc_hd__decap_3
XFILLER_23_238 VGND VGND VPWR VPWR sky130_fd_sc_hd__decap_3
XFILLER_90_193 VGND VGND VPWR VPWR sky130_fd_sc_hd__decap_3
XTAP_TAPCELL_ROW_18_296 VGND VPWR sky130_fd_sc_hd__tapvpwrvgnd_1
XFILLER_2_109 VGND VGND VPWR VPWR sky130_fd_sc_hd__fill_2
X_1708_ net738 net713 VGND VGND VPWR VPWR Inst_SimpleCLB_ConfigMem.Inst_frame13_bit7.Q
+ sky130_fd_sc_hd__dlxtp_1
X_1639_ net751 net704 VGND VGND VPWR VPWR Inst_LF_LUT4c_frame_config_dffesr.inst_cus_mux161_buf.A1
+ sky130_fd_sc_hd__dlxtp_1
XFILLER_48_27 VGND VGND VPWR VPWR sky130_fd_sc_hd__fill_1
XFILLER_58_113 VGND VGND VPWR VPWR sky130_fd_sc_hd__decap_3
XFILLER_73_116 VGND VGND VPWR VPWR sky130_fd_sc_hd__decap_3
XTAP_TAPCELL_ROW_1_197 VGND VPWR sky130_fd_sc_hd__tapvpwrvgnd_1
XFILLER_13_52 VGND VGND VPWR VPWR sky130_fd_sc_hd__decap_3
XFILLER_89_12 VGND VGND VPWR VPWR sky130_fd_sc_hd__fill_1
XFILLER_13_85 VGND VGND VPWR VPWR sky130_fd_sc_hd__decap_3
XTAP_TAPCELL_ROW_9_242 VGND VPWR sky130_fd_sc_hd__tapvpwrvgnd_1
XFILLER_1_186 VGND VGND VPWR VPWR sky130_fd_sc_hd__fill_2
XFILLER_1_164 VGND VGND VPWR VPWR sky130_fd_sc_hd__decap_3
XFILLER_49_113 VGND VGND VPWR VPWR sky130_fd_sc_hd__decap_3
XFILLER_49_157 VGND VGND VPWR VPWR sky130_fd_sc_hd__decap_3
XFILLER_38_60 VGND VGND VPWR VPWR sky130_fd_sc_hd__decap_3
XFILLER_64_105 VGND VGND VPWR VPWR sky130_fd_sc_hd__decap_3
XFILLER_64_138 VGND VGND VPWR VPWR sky130_fd_sc_hd__fill_2
X_1990_ net776 net675 VGND VGND VPWR VPWR Inst_SimpleCLB_ConfigMem.Inst_frame4_bit1.Q
+ sky130_fd_sc_hd__dlxtp_1
X_0941_ W2END[5] net638 net642 net629 Inst_SimpleCLB_ConfigMem.Inst_frame3_bit11.Q
+ Inst_SimpleCLB_ConfigMem.Inst_frame3_bit10.Q VGND VGND VPWR VPWR _0042_ sky130_fd_sc_hd__mux4_1
XFILLER_13_293 VGND VGND VPWR VPWR sky130_fd_sc_hd__decap_3
X_0872_ Inst_LA_LUT4c_frame_config_dffesr.inst_cus_mux161_buf.A10 Inst_LA_LUT4c_frame_config_dffesr.inst_cus_mux161_buf.A11
+ _0648_ VGND VGND VPWR VPWR _0700_ sky130_fd_sc_hd__mux2_1
XFILLER_55_3 VGND VGND VPWR VPWR sky130_fd_sc_hd__fill_1
X_1424_ Inst_SimpleCLB_ConfigMem.Inst_frame12_bit1.Q _0668_ _0484_ Inst_SimpleCLB_ConfigMem.Inst_frame12_bit2.Q
+ VGND VGND VPWR VPWR _0485_ sky130_fd_sc_hd__a211oi_1
X_1355_ net647 net633 Inst_SimpleCLB_ConfigMem.Inst_frame11_bit22.Q VGND VGND VPWR
+ VPWR _0425_ sky130_fd_sc_hd__mux2_1
XFILLER_55_105 VGND VGND VPWR VPWR sky130_fd_sc_hd__decap_3
X_1286_ S1END[0] S1END[2] SS4END[0] W2END[0] Inst_SimpleCLB_ConfigMem.Inst_frame3_bit22.Q
+ Inst_SimpleCLB_ConfigMem.Inst_frame3_bit23.Q VGND VGND VPWR VPWR _0365_ sky130_fd_sc_hd__mux4_1
XFILLER_48_190 VGND VGND VPWR VPWR sky130_fd_sc_hd__decap_3
XFILLER_63_160 VGND VGND VPWR VPWR sky130_fd_sc_hd__decap_3
XFILLER_34_29 VGND VGND VPWR VPWR sky130_fd_sc_hd__decap_3
XFILLER_11_208 VGND VGND VPWR VPWR sky130_fd_sc_hd__decap_3
XTAP_TAPCELL_ROW_89_726 VGND VPWR sky130_fd_sc_hd__tapvpwrvgnd_1
XFILLER_86_285 VGND VGND VPWR VPWR sky130_fd_sc_hd__decap_3
XFILLER_24_51 VGND VGND VPWR VPWR sky130_fd_sc_hd__decap_3
XTAP_TAPCELL_ROW_80_670 VGND VPWR sky130_fd_sc_hd__tapvpwrvgnd_1
XFILLER_6_212 VGND VGND VPWR VPWR sky130_fd_sc_hd__decap_3
XFILLER_6_245 VGND VGND VPWR VPWR sky130_fd_sc_hd__decap_3
XFILLER_40_50 VGND VGND VPWR VPWR sky130_fd_sc_hd__decap_3
XFILLER_40_83 VGND VGND VPWR VPWR sky130_fd_sc_hd__fill_1
XFILLER_49_70 VGND VGND VPWR VPWR sky130_fd_sc_hd__decap_3
X_1140_ N4END[3] EE4END[0] S4END[3] Inst_SimpleCLB_switch_matrix.JN2BEG4 Inst_SimpleCLB_ConfigMem.Inst_frame0_bit18.Q
+ Inst_SimpleCLB_ConfigMem.Inst_frame0_bit19.Q VGND VGND VPWR VPWR _0229_ sky130_fd_sc_hd__mux4_1
XFILLER_1_99 VGND VGND VPWR VPWR sky130_fd_sc_hd__fill_1
X_1071_ _0155_ _0160_ _0163_ _0157_ VGND VGND VPWR VPWR _0164_ sky130_fd_sc_hd__a31o_1
XFILLER_65_91 VGND VGND VPWR VPWR sky130_fd_sc_hd__decap_3
XANTENNA_170 net757 VGND VGND VPWR VPWR sky130_fd_sc_hd__diode_2
XFILLER_60_141 VGND VGND VPWR VPWR sky130_fd_sc_hd__fill_1
XANTENNA_181 net802 VGND VGND VPWR VPWR sky130_fd_sc_hd__diode_2
XANTENNA_192 net52 VGND VGND VPWR VPWR sky130_fd_sc_hd__diode_2
X_1973_ net785 net671 VGND VGND VPWR VPWR Inst_SimpleCLB_ConfigMem.Inst_frame5_bit16.Q
+ sky130_fd_sc_hd__dlxtp_1
X_0924_ _0024_ Inst_SimpleCLB_ConfigMem.Inst_frame2_bit12.Q Inst_SimpleCLB_ConfigMem.Inst_frame2_bit13.Q
+ VGND VGND VPWR VPWR _0027_ sky130_fd_sc_hd__a21bo_1
X_0855_ Inst_SimpleCLB_ConfigMem.Inst_frame1_bit8.Q _0683_ Inst_SimpleCLB_ConfigMem.Inst_frame1_bit9.Q
+ VGND VGND VPWR VPWR _0684_ sky130_fd_sc_hd__a21bo_1
X_0786_ W6END[0] net636 net640 net626 Inst_SimpleCLB_ConfigMem.Inst_frame4_bit7.Q
+ Inst_SimpleCLB_ConfigMem.Inst_frame4_bit6.Q VGND VGND VPWR VPWR _0620_ sky130_fd_sc_hd__mux4_1
X_1407_ Inst_SimpleCLB_ConfigMem.Inst_frame12_bit11.Q _0470_ VGND VGND VPWR VPWR _0471_
+ sky130_fd_sc_hd__nand2_1
XTAP_TAPCELL_ROW_86_707 VGND VPWR sky130_fd_sc_hd__tapvpwrvgnd_1
XFILLER_28_105 VGND VGND VPWR VPWR sky130_fd_sc_hd__decap_3
X_2387_ W6END[7] VGND VGND VPWR VPWR net234 sky130_fd_sc_hd__clkbuf_2
XFILLER_68_241 VGND VGND VPWR VPWR sky130_fd_sc_hd__decap_3
XFILLER_28_127 VGND VGND VPWR VPWR sky130_fd_sc_hd__fill_1
X_1338_ net645 _0023_ Inst_SimpleCLB_ConfigMem.Inst_frame11_bit28.Q VGND VGND VPWR
+ VPWR _0410_ sky130_fd_sc_hd__mux2_1
X_1269_ net653 E1END[0] N2END[0] E2END[0] Inst_SimpleCLB_ConfigMem.Inst_frame2_bit23.Q
+ Inst_SimpleCLB_ConfigMem.Inst_frame2_bit22.Q VGND VGND VPWR VPWR _0350_ sky130_fd_sc_hd__mux4_1
XFILLER_24_300 VGND VGND VPWR VPWR sky130_fd_sc_hd__decap_3
XFILLER_24_322 VGND VGND VPWR VPWR sky130_fd_sc_hd__fill_2
XFILLER_36_193 VGND VGND VPWR VPWR sky130_fd_sc_hd__decap_3
XTAP_TAPCELL_ROW_34_394 VGND VPWR sky130_fd_sc_hd__tapvpwrvgnd_1
XFILLER_61_27 VGND VGND VPWR VPWR sky130_fd_sc_hd__decap_3
XFILLER_3_237 VGND VGND VPWR VPWR sky130_fd_sc_hd__decap_3
XFILLER_86_24 VGND VGND VPWR VPWR sky130_fd_sc_hd__decap_3
XFILLER_19_105 VGND VGND VPWR VPWR sky130_fd_sc_hd__decap_3
XFILLER_19_116 VGND VGND VPWR VPWR sky130_fd_sc_hd__decap_3
XFILLER_59_296 VGND VGND VPWR VPWR sky130_fd_sc_hd__decap_3
XFILLER_74_211 VGND VGND VPWR VPWR sky130_fd_sc_hd__decap_3
XFILLER_19_84 VGND VGND VPWR VPWR sky130_fd_sc_hd__decap_3
XFILLER_15_333 VGND VGND VPWR VPWR sky130_fd_sc_hd__decap_3
XFILLER_35_72 VGND VGND VPWR VPWR sky130_fd_sc_hd__decap_3
XFILLER_42_174 VGND VGND VPWR VPWR sky130_fd_sc_hd__fill_1
XFILLER_42_185 VGND VGND VPWR VPWR sky130_fd_sc_hd__decap_3
XFILLER_89_9 VGND VGND VPWR VPWR sky130_fd_sc_hd__fill_1
XFILLER_51_60 VGND VGND VPWR VPWR sky130_fd_sc_hd__decap_3
XFILLER_51_93 VGND VGND VPWR VPWR sky130_fd_sc_hd__decap_3
XPHY_EDGE_ROW_2_Left_93 VGND VGND VPWR VPWR sky130_fd_sc_hd__decap_3
X_2310_ Inst_SimpleCLB_switch_matrix.S1BEG1 VGND VGND VPWR VPWR net155 sky130_fd_sc_hd__buf_1
XFILLER_2_281 VGND VGND VPWR VPWR sky130_fd_sc_hd__fill_2
X_2241_ net678 VGND VGND VPWR VPWR net96 sky130_fd_sc_hd__clkbuf_2
XFILLER_18_3 VGND VGND VPWR VPWR sky130_fd_sc_hd__decap_3
X_2172_ E2MID[3] VGND VGND VPWR VPWR net17 sky130_fd_sc_hd__buf_1
XFILLER_65_211 VGND VGND VPWR VPWR sky130_fd_sc_hd__decap_3
X_1123_ Inst_LE_LUT4c_frame_config_dffesr.inst_cus_mux161_buf.A2 _0202_ _0203_ Inst_LE_LUT4c_frame_config_dffesr.inst_cus_mux161_buf.A4
+ VGND VGND VPWR VPWR _0214_ sky130_fd_sc_hd__o22a_1
XFILLER_65_244 VGND VGND VPWR VPWR sky130_fd_sc_hd__decap_3
X_1054_ net651 N2END[6] E1END[2] E2END[6] Inst_SimpleCLB_ConfigMem.Inst_frame2_bit14.Q
+ Inst_SimpleCLB_ConfigMem.Inst_frame2_bit15.Q VGND VGND VPWR VPWR _0148_ sky130_fd_sc_hd__mux4_1
XFILLER_80_225 VGND VGND VPWR VPWR sky130_fd_sc_hd__decap_3
XFILLER_33_152 VGND VGND VPWR VPWR sky130_fd_sc_hd__decap_3
X_1956_ net747 net667 VGND VGND VPWR VPWR Inst_SimpleCLB_ConfigMem.Inst_frame6_bit31.Q
+ sky130_fd_sc_hd__dlxtp_1
X_0907_ _0670_ Ci _0619_ VGND VGND VPWR VPWR _0011_ sky130_fd_sc_hd__o21ai_4
XTAP_TAPCELL_ROW_31_375 VGND VPWR sky130_fd_sc_hd__tapvpwrvgnd_1
X_1887_ net760 net659 VGND VGND VPWR VPWR Inst_SimpleCLB_ConfigMem.Inst_frame8_bit26.Q
+ sky130_fd_sc_hd__dlxtp_1
X_0838_ _0571_ _0572_ _0575_ _0666_ Inst_SimpleCLB_ConfigMem.Inst_frame8_bit30.Q Inst_SimpleCLB_ConfigMem.Inst_frame8_bit31.Q
+ VGND VGND VPWR VPWR _0668_ sky130_fd_sc_hd__mux4_2
X_0769_ net653 N2END[4] net650 N4END[0] Inst_SimpleCLB_ConfigMem.Inst_frame3_bit7.Q
+ Inst_SimpleCLB_ConfigMem.Inst_frame3_bit6.Q VGND VGND VPWR VPWR _0605_ sky130_fd_sc_hd__mux4_1
Xoutput19 net19 VGND VGND VPWR VPWR E2BEGb[5] sky130_fd_sc_hd__buf_2
XFILLER_56_38 VGND VGND VPWR VPWR sky130_fd_sc_hd__fill_1
XFILLER_56_211 VGND VGND VPWR VPWR sky130_fd_sc_hd__fill_1
XFILLER_24_130 VGND VGND VPWR VPWR sky130_fd_sc_hd__decap_3
XFILLER_24_185 VGND VGND VPWR VPWR sky130_fd_sc_hd__fill_2
XTAP_TAPCELL_ROW_22_320 VGND VPWR sky130_fd_sc_hd__tapvpwrvgnd_1
XANTENNA_92 NN4END[9] VGND VGND VPWR VPWR sky130_fd_sc_hd__diode_2
XANTENNA_81 NN4END[12] VGND VGND VPWR VPWR sky130_fd_sc_hd__diode_2
XANTENNA_70 N4END[14] VGND VGND VPWR VPWR sky130_fd_sc_hd__diode_2
XFILLER_21_74 VGND VGND VPWR VPWR sky130_fd_sc_hd__decap_3
XFILLER_47_222 VGND VGND VPWR VPWR sky130_fd_sc_hd__fill_2
XFILLER_47_277 VGND VGND VPWR VPWR sky130_fd_sc_hd__decap_3
XFILLER_62_214 VGND VGND VPWR VPWR sky130_fd_sc_hd__fill_1
XFILLER_62_247 VGND VGND VPWR VPWR sky130_fd_sc_hd__decap_3
XFILLER_15_163 VGND VGND VPWR VPWR sky130_fd_sc_hd__decap_3
XFILLER_87_6 VGND VGND VPWR VPWR sky130_fd_sc_hd__fill_1
X_1810_ net790 net726 VGND VGND VPWR VPWR Inst_SimpleCLB_ConfigMem.Inst_frame10_bit13.Q
+ sky130_fd_sc_hd__dlxtp_1
XFILLER_7_21 VGND VGND VPWR VPWR sky130_fd_sc_hd__decap_3
XFILLER_30_177 VGND VGND VPWR VPWR sky130_fd_sc_hd__decap_3
XFILLER_7_340 VGND VGND VPWR VPWR sky130_fd_sc_hd__decap_3
XFILLER_7_54 VGND VGND VPWR VPWR sky130_fd_sc_hd__fill_2
X_1741_ net736 net718 VGND VGND VPWR VPWR Inst_SimpleCLB_ConfigMem.Inst_frame12_bit8.Q
+ sky130_fd_sc_hd__dlxtp_1
X_1672_ net746 net709 VGND VGND VPWR VPWR Inst_LG_LUT4c_frame_config_dffesr.inst_cus_mux161_buf.A15
+ sky130_fd_sc_hd__dlxtp_1
X_2224_ net778 VGND VGND VPWR VPWR net60 sky130_fd_sc_hd__clkbuf_2
XFILLER_38_200 VGND VGND VPWR VPWR sky130_fd_sc_hd__decap_3
XFILLER_38_233 VGND VGND VPWR VPWR sky130_fd_sc_hd__decap_3
X_2155_ clknet_1_1__leaf_UserCLK_regs _0006_ VGND VGND VPWR VPWR Inst_LF_LUT4c_frame_config_dffesr.LUT_flop
+ sky130_fd_sc_hd__dfxtp_1
X_1106_ _0197_ _0192_ _0188_ VGND VGND VPWR VPWR _0198_ sky130_fd_sc_hd__mux2_4
X_2086_ net776 net687 VGND VGND VPWR VPWR Inst_SimpleCLB_ConfigMem.Inst_frame1_bit1.Q
+ sky130_fd_sc_hd__dlxtp_1
XFILLER_53_225 VGND VGND VPWR VPWR sky130_fd_sc_hd__fill_2
XFILLER_53_236 VGND VGND VPWR VPWR sky130_fd_sc_hd__decap_3
XFILLER_53_269 VGND VGND VPWR VPWR sky130_fd_sc_hd__decap_3
X_1037_ W2END[6] net639 net643 net630 Inst_SimpleCLB_ConfigMem.Inst_frame3_bit15.Q
+ Inst_SimpleCLB_ConfigMem.Inst_frame3_bit14.Q VGND VGND VPWR VPWR _0132_ sky130_fd_sc_hd__mux4_1
Xclkbuf_1_0__f_UserCLK_regs clknet_0_UserCLK_regs VGND VGND VPWR VPWR clknet_1_0__leaf_UserCLK_regs
+ sky130_fd_sc_hd__clkbuf_16
XFILLER_42_29 VGND VGND VPWR VPWR sky130_fd_sc_hd__decap_3
X_1939_ net789 net668 VGND VGND VPWR VPWR Inst_SimpleCLB_ConfigMem.Inst_frame6_bit14.Q
+ sky130_fd_sc_hd__dlxtp_1
XFILLER_67_15 VGND VGND VPWR VPWR sky130_fd_sc_hd__decap_3
XFILLER_67_48 VGND VGND VPWR VPWR sky130_fd_sc_hd__decap_3
XFILLER_29_233 VGND VGND VPWR VPWR sky130_fd_sc_hd__decap_3
XFILLER_29_266 VGND VGND VPWR VPWR sky130_fd_sc_hd__fill_2
XFILLER_44_203 VGND VGND VPWR VPWR sky130_fd_sc_hd__decap_3
XFILLER_44_225 VGND VGND VPWR VPWR sky130_fd_sc_hd__decap_3
XTAP_TAPCELL_ROW_67_592 VGND VPWR sky130_fd_sc_hd__tapvpwrvgnd_1
XFILLER_16_85 VGND VGND VPWR VPWR sky130_fd_sc_hd__fill_1
XFILLER_12_100 VGND VGND VPWR VPWR sky130_fd_sc_hd__decap_3
XPHY_EDGE_ROW_11_Right_11 VGND VGND VPWR VPWR sky130_fd_sc_hd__decap_3
XFILLER_12_133 VGND VGND VPWR VPWR sky130_fd_sc_hd__decap_3
XTAP_TAPCELL_ROW_50_492 VGND VPWR sky130_fd_sc_hd__tapvpwrvgnd_1
XPHY_EDGE_ROW_20_Right_20 VGND VGND VPWR VPWR sky130_fd_sc_hd__decap_3
XFILLER_79_144 VGND VGND VPWR VPWR sky130_fd_sc_hd__decap_3
XFILLER_57_92 VGND VGND VPWR VPWR sky130_fd_sc_hd__decap_3
XFILLER_85_3 VGND VGND VPWR VPWR sky130_fd_sc_hd__decap_3
X_1724_ net767 net715 VGND VGND VPWR VPWR Inst_SimpleCLB_ConfigMem.Inst_frame13_bit23.Q
+ sky130_fd_sc_hd__dlxtp_1
XFILLER_7_181 VGND VGND VPWR VPWR sky130_fd_sc_hd__decap_3
Xhold137 Inst_LB_LUT4c_frame_config_dffesr.LUT_flop VGND VGND VPWR VPWR net391 sky130_fd_sc_hd__dlygate4sd3_1
X_1655_ net780 net703 VGND VGND VPWR VPWR Inst_LF_LUT4c_frame_config_dffesr.c_I0mux
+ sky130_fd_sc_hd__dlxtp_1
X_1586_ net790 net694 VGND VGND VPWR VPWR Inst_LC_LUT4c_frame_config_dffesr.inst_cus_mux161_buf.A5
+ sky130_fd_sc_hd__dlxtp_1
Xfanout639 Inst_LB_LUT4c_frame_config_dffesr.O VGND VGND VPWR VPWR net639 sky130_fd_sc_hd__clkbuf_4
Xfanout628 Inst_LC_LUT4c_frame_config_dffesr.O VGND VGND VPWR VPWR net628 sky130_fd_sc_hd__buf_6
Xfanout617 Inst_LD_LUT4c_frame_config_dffesr.O VGND VGND VPWR VPWR net617 sky130_fd_sc_hd__buf_6
XFILLER_85_125 VGND VGND VPWR VPWR sky130_fd_sc_hd__decap_3
X_2207_ net751 VGND VGND VPWR VPWR net72 sky130_fd_sc_hd__clkbuf_1
XFILLER_85_169 VGND VGND VPWR VPWR sky130_fd_sc_hd__decap_3
XTAP_TAPCELL_ROW_56_529 VGND VPWR sky130_fd_sc_hd__tapvpwrvgnd_1
XFILLER_26_236 VGND VGND VPWR VPWR sky130_fd_sc_hd__decap_3
X_2138_ net771 net731 VGND VGND VPWR VPWR Inst_SimpleCLB_ConfigMem.Inst_frame0_bit21.Q
+ sky130_fd_sc_hd__dlxtp_1
X_2069_ net784 net685 VGND VGND VPWR VPWR Inst_SimpleCLB_ConfigMem.Inst_frame2_bit16.Q
+ sky130_fd_sc_hd__dlxtp_1
XFILLER_53_28 VGND VGND VPWR VPWR sky130_fd_sc_hd__fill_1
XTAP_TAPCELL_ROW_64_573 VGND VPWR sky130_fd_sc_hd__tapvpwrvgnd_1
XFILLER_1_324 VGND VGND VPWR VPWR sky130_fd_sc_hd__decap_3
XFILLER_78_58 VGND VGND VPWR VPWR sky130_fd_sc_hd__decap_3
XFILLER_76_103 VGND VGND VPWR VPWR sky130_fd_sc_hd__decap_3
XFILLER_76_136 VGND VGND VPWR VPWR sky130_fd_sc_hd__decap_3
XFILLER_76_147 VGND VGND VPWR VPWR sky130_fd_sc_hd__decap_3
XFILLER_17_225 VGND VGND VPWR VPWR sky130_fd_sc_hd__decap_3
XFILLER_17_258 VGND VGND VPWR VPWR sky130_fd_sc_hd__decap_3
XFILLER_72_342 VGND VGND VPWR VPWR sky130_fd_sc_hd__fill_1
XFILLER_32_217 VGND VGND VPWR VPWR sky130_fd_sc_hd__decap_3
Xoutput209 Inst_SimpleCLB_switch_matrix.W1BEG2 VGND VGND VPWR VPWR W1BEG[2] sky130_fd_sc_hd__buf_6
XFILLER_4_22 VGND VGND VPWR VPWR sky130_fd_sc_hd__decap_3
XFILLER_4_162 VGND VGND VPWR VPWR sky130_fd_sc_hd__decap_3
X_1440_ net645 _0041_ Inst_SimpleCLB_ConfigMem.Inst_frame13_bit16.Q VGND VGND VPWR
+ VPWR _0498_ sky130_fd_sc_hd__mux2_1
XFILLER_4_195 VGND VGND VPWR VPWR sky130_fd_sc_hd__fill_1
X_1371_ Inst_SimpleCLB_ConfigMem.Inst_frame11_bit10.Q _0438_ _0437_ VGND VGND VPWR
+ VPWR Inst_SimpleCLB_switch_matrix.SS4BEG2 sky130_fd_sc_hd__o21ba_1
XFILLER_67_136 VGND VGND VPWR VPWR sky130_fd_sc_hd__decap_3
XFILLER_23_228 VGND VGND VPWR VPWR sky130_fd_sc_hd__decap_3
XTAP_TAPCELL_ROW_18_297 VGND VPWR sky130_fd_sc_hd__tapvpwrvgnd_1
XTAP_TAPCELL_ROW_61_554 VGND VPWR sky130_fd_sc_hd__tapvpwrvgnd_1
X_1707_ FrameData[6] net713 VGND VGND VPWR VPWR Inst_SimpleCLB_ConfigMem.Inst_frame13_bit6.Q
+ sky130_fd_sc_hd__dlxtp_1
X_1638_ net777 net704 VGND VGND VPWR VPWR Inst_LF_LUT4c_frame_config_dffesr.inst_cus_mux161_buf.A0
+ sky130_fd_sc_hd__dlxtp_1
X_1569_ net756 net692 VGND VGND VPWR VPWR Inst_LB_LUT4c_frame_config_dffesr.inst_cus_mux161_buf.A7
+ sky130_fd_sc_hd__dlxtp_1
XFILLER_48_39 VGND VGND VPWR VPWR sky130_fd_sc_hd__decap_3
XFILLER_58_125 VGND VGND VPWR VPWR sky130_fd_sc_hd__decap_3
XFILLER_58_147 VGND VGND VPWR VPWR sky130_fd_sc_hd__decap_3
XFILLER_66_191 VGND VGND VPWR VPWR sky130_fd_sc_hd__decap_3
XTAP_TAPCELL_ROW_1_198 VGND VPWR sky130_fd_sc_hd__tapvpwrvgnd_1
XTAP_TAPCELL_ROW_9_243 VGND VPWR sky130_fd_sc_hd__tapvpwrvgnd_1
XFILLER_89_250 VGND VGND VPWR VPWR sky130_fd_sc_hd__decap_3
XFILLER_49_103 VGND VGND VPWR VPWR sky130_fd_sc_hd__decap_3
XFILLER_89_294 VGND VGND VPWR VPWR sky130_fd_sc_hd__fill_1
XFILLER_49_125 VGND VGND VPWR VPWR sky130_fd_sc_hd__decap_3
XFILLER_38_72 VGND VGND VPWR VPWR sky130_fd_sc_hd__decap_3
XFILLER_64_117 VGND VGND VPWR VPWR sky130_fd_sc_hd__decap_3
XTAP_TAPCELL_ROW_83_690 VGND VPWR sky130_fd_sc_hd__tapvpwrvgnd_1
XFILLER_60_345 VGND VGND VPWR VPWR sky130_fd_sc_hd__fill_2
XFILLER_20_209 VGND VGND VPWR VPWR sky130_fd_sc_hd__decap_3
XFILLER_13_261 VGND VGND VPWR VPWR sky130_fd_sc_hd__decap_3
X_0940_ N2END[2] E2END[2] S2END[2] WW4END[2] Inst_SimpleCLB_ConfigMem.Inst_frame5_bit4.Q
+ Inst_SimpleCLB_ConfigMem.Inst_frame5_bit5.Q VGND VGND VPWR VPWR _0041_ sky130_fd_sc_hd__mux4_2
XTAP_TAPCELL_ROW_15_278 VGND VPWR sky130_fd_sc_hd__tapvpwrvgnd_1
XFILLER_9_210 VGND VGND VPWR VPWR sky130_fd_sc_hd__decap_3
X_0871_ _0697_ _0698_ _0619_ VGND VGND VPWR VPWR _0699_ sky130_fd_sc_hd__mux2_1
XFILLER_48_3 VGND VGND VPWR VPWR sky130_fd_sc_hd__decap_3
X_1423_ Inst_SimpleCLB_ConfigMem.Inst_frame12_bit1.Q net264 VGND VGND VPWR VPWR _0484_
+ sky130_fd_sc_hd__nor2_1
X_1354_ Inst_SimpleCLB_ConfigMem.Inst_frame11_bit23.Q _0423_ VGND VGND VPWR VPWR _0424_
+ sky130_fd_sc_hd__nand2b_1
X_1285_ net653 E1END[0] N2END[0] E2END[0] Inst_SimpleCLB_ConfigMem.Inst_frame3_bit23.Q
+ Inst_SimpleCLB_ConfigMem.Inst_frame3_bit22.Q VGND VGND VPWR VPWR _0364_ sky130_fd_sc_hd__mux4_1
XFILLER_28_309 VGND VGND VPWR VPWR sky130_fd_sc_hd__decap_3
XFILLER_63_183 VGND VGND VPWR VPWR sky130_fd_sc_hd__fill_1
XFILLER_50_18 VGND VGND VPWR VPWR sky130_fd_sc_hd__decap_3
XTAP_TAPCELL_ROW_89_727 VGND VPWR sky130_fd_sc_hd__tapvpwrvgnd_1
XTAP_TAPCELL_ROW_6_224 VGND VPWR sky130_fd_sc_hd__tapvpwrvgnd_1
XFILLER_86_220 VGND VGND VPWR VPWR sky130_fd_sc_hd__decap_3
XFILLER_42_345 VGND VGND VPWR VPWR sky130_fd_sc_hd__fill_2
XFILLER_54_194 VGND VGND VPWR VPWR sky130_fd_sc_hd__fill_2
XFILLER_24_85 VGND VGND VPWR VPWR sky130_fd_sc_hd__decap_3
XTAP_TAPCELL_ROW_80_671 VGND VPWR sky130_fd_sc_hd__tapvpwrvgnd_1
XFILLER_24_96 VGND VGND VPWR VPWR sky130_fd_sc_hd__fill_1
XFILLER_6_224 VGND VGND VPWR VPWR sky130_fd_sc_hd__decap_3
XFILLER_40_62 VGND VGND VPWR VPWR sky130_fd_sc_hd__fill_1
XFILLER_49_82 VGND VGND VPWR VPWR sky130_fd_sc_hd__decap_3
XFILLER_1_34 VGND VGND VPWR VPWR sky130_fd_sc_hd__decap_3
XFILLER_37_128 VGND VGND VPWR VPWR sky130_fd_sc_hd__fill_2
XFILLER_18_331 VGND VGND VPWR VPWR sky130_fd_sc_hd__decap_3
X_1070_ _0014_ _0055_ _0161_ _0057_ VGND VGND VPWR VPWR _0163_ sky130_fd_sc_hd__o211ai_4
XANTENNA_160 WW4END[3] VGND VGND VPWR VPWR sky130_fd_sc_hd__diode_2
XFILLER_33_345 VGND VGND VPWR VPWR sky130_fd_sc_hd__fill_2
XANTENNA_182 E1END[2] VGND VGND VPWR VPWR sky130_fd_sc_hd__diode_2
XANTENNA_193 net56 VGND VGND VPWR VPWR sky130_fd_sc_hd__diode_2
XANTENNA_171 net759 VGND VGND VPWR VPWR sky130_fd_sc_hd__diode_2
XFILLER_60_197 VGND VGND VPWR VPWR sky130_fd_sc_hd__decap_3
X_1972_ net786 net674 VGND VGND VPWR VPWR Inst_SimpleCLB_ConfigMem.Inst_frame5_bit15.Q
+ sky130_fd_sc_hd__dlxtp_1
X_0923_ Inst_SimpleCLB_ConfigMem.Inst_frame2_bit12.Q _0025_ VGND VGND VPWR VPWR _0026_
+ sky130_fd_sc_hd__and2b_1
X_0854_ net621 net612 net631 net608 Inst_SimpleCLB_ConfigMem.Inst_frame1_bit7.Q Inst_SimpleCLB_ConfigMem.Inst_frame1_bit6.Q
+ VGND VGND VPWR VPWR _0683_ sky130_fd_sc_hd__mux4_1
X_0785_ _0608_ _0609_ _0618_ _0617_ Inst_SimpleCLB_ConfigMem.Inst_frame10_bit12.Q
+ Inst_SimpleCLB_ConfigMem.Inst_frame10_bit13.Q VGND VGND VPWR VPWR _0619_ sky130_fd_sc_hd__mux4_2
XPHY_EDGE_ROW_49_Right_49 VGND VGND VPWR VPWR sky130_fd_sc_hd__decap_3
X_2386_ W6END[6] VGND VGND VPWR VPWR net233 sky130_fd_sc_hd__clkbuf_2
X_1406_ _0140_ net645 Inst_SimpleCLB_ConfigMem.Inst_frame12_bit10.Q VGND VGND VPWR
+ VPWR _0470_ sky130_fd_sc_hd__mux2_1
XTAP_TAPCELL_ROW_86_708 VGND VPWR sky130_fd_sc_hd__tapvpwrvgnd_1
X_1337_ _0409_ _0408_ Inst_SimpleCLB_ConfigMem.Inst_frame10_bit1.Q VGND VGND VPWR
+ VPWR Inst_SimpleCLB_switch_matrix.WW4BEG3 sky130_fd_sc_hd__mux2_4
XFILLER_68_253 VGND VGND VPWR VPWR sky130_fd_sc_hd__decap_3
XFILLER_83_234 VGND VGND VPWR VPWR sky130_fd_sc_hd__decap_3
X_1268_ Inst_SimpleCLB_ConfigMem.Inst_frame2_bit24.Q _0346_ Inst_SimpleCLB_ConfigMem.Inst_frame2_bit25.Q
+ VGND VGND VPWR VPWR _0349_ sky130_fd_sc_hd__o21a_1
XFILLER_45_18 VGND VGND VPWR VPWR sky130_fd_sc_hd__fill_1
XPHY_EDGE_ROW_58_Right_58 VGND VGND VPWR VPWR sky130_fd_sc_hd__decap_3
XFILLER_83_278 VGND VGND VPWR VPWR sky130_fd_sc_hd__fill_2
X_1199_ _0284_ _0281_ _0276_ VGND VGND VPWR VPWR _0285_ sky130_fd_sc_hd__mux2_4
XFILLER_24_334 VGND VGND VPWR VPWR sky130_fd_sc_hd__decap_3
XFILLER_51_175 VGND VGND VPWR VPWR sky130_fd_sc_hd__decap_3
XTAP_TAPCELL_ROW_34_395 VGND VPWR sky130_fd_sc_hd__tapvpwrvgnd_1
XPHY_EDGE_ROW_67_Right_67 VGND VGND VPWR VPWR sky130_fd_sc_hd__decap_3
XFILLER_3_216 VGND VGND VPWR VPWR sky130_fd_sc_hd__decap_3
XFILLER_10_54 VGND VGND VPWR VPWR sky130_fd_sc_hd__decap_3
XFILLER_86_58 VGND VGND VPWR VPWR sky130_fd_sc_hd__fill_2
XFILLER_74_223 VGND VGND VPWR VPWR sky130_fd_sc_hd__decap_3
XPHY_EDGE_ROW_76_Right_76 VGND VGND VPWR VPWR sky130_fd_sc_hd__decap_3
XFILLER_19_96 VGND VGND VPWR VPWR sky130_fd_sc_hd__decap_3
XFILLER_35_40 VGND VGND VPWR VPWR sky130_fd_sc_hd__decap_3
XTAP_TAPCELL_ROW_25_340 VGND VPWR sky130_fd_sc_hd__tapvpwrvgnd_1
XFILLER_30_304 VGND VGND VPWR VPWR sky130_fd_sc_hd__decap_3
XFILLER_30_337 VGND VGND VPWR VPWR sky130_fd_sc_hd__decap_3
XPHY_EDGE_ROW_85_Right_85 VGND VGND VPWR VPWR sky130_fd_sc_hd__decap_3
X_2240_ net681 VGND VGND VPWR VPWR net95 sky130_fd_sc_hd__clkbuf_1
X_2171_ E2MID[2] VGND VGND VPWR VPWR net16 sky130_fd_sc_hd__clkbuf_1
XFILLER_65_223 VGND VGND VPWR VPWR sky130_fd_sc_hd__fill_1
X_1122_ Inst_LE_LUT4c_frame_config_dffesr.inst_cus_mux161_buf.A1 _0155_ _0156_ Inst_LE_LUT4c_frame_config_dffesr.inst_cus_mux161_buf.A7
+ _0212_ VGND VGND VPWR VPWR _0213_ sky130_fd_sc_hd__o221a_1
XFILLER_65_256 VGND VGND VPWR VPWR sky130_fd_sc_hd__decap_3
XFILLER_76_91 VGND VGND VPWR VPWR sky130_fd_sc_hd__decap_3
XFILLER_18_150 VGND VGND VPWR VPWR sky130_fd_sc_hd__decap_3
XTAP_TAPCELL_ROW_48_476 VGND VPWR sky130_fd_sc_hd__tapvpwrvgnd_1
X_1053_ Inst_SimpleCLB_ConfigMem.Inst_frame2_bit16.Q _0146_ Inst_SimpleCLB_ConfigMem.Inst_frame2_bit17.Q
+ VGND VGND VPWR VPWR _0147_ sky130_fd_sc_hd__a21bo_1
XFILLER_65_278 VGND VGND VPWR VPWR sky130_fd_sc_hd__fill_2
XFILLER_80_237 VGND VGND VPWR VPWR sky130_fd_sc_hd__decap_3
XFILLER_33_131 VGND VGND VPWR VPWR sky130_fd_sc_hd__decap_3
XFILLER_33_164 VGND VGND VPWR VPWR sky130_fd_sc_hd__decap_3
X_1955_ net749 net667 VGND VGND VPWR VPWR Inst_SimpleCLB_ConfigMem.Inst_frame6_bit30.Q
+ sky130_fd_sc_hd__dlxtp_1
X_0906_ _0727_ _0728_ VGND VGND VPWR VPWR _0010_ sky130_fd_sc_hd__nand2_1
XTAP_TAPCELL_ROW_31_376 VGND VPWR sky130_fd_sc_hd__tapvpwrvgnd_1
X_1886_ net763 net660 VGND VGND VPWR VPWR Inst_SimpleCLB_ConfigMem.Inst_frame8_bit25.Q
+ sky130_fd_sc_hd__dlxtp_1
X_0837_ N2MID[4] E2MID[4] W2MID[4] Inst_SimpleCLB_switch_matrix.JS2BEG3 Inst_SimpleCLB_ConfigMem.Inst_frame8_bit30.Q
+ Inst_SimpleCLB_ConfigMem.Inst_frame8_bit31.Q VGND VGND VPWR VPWR _0667_ sky130_fd_sc_hd__mux4_2
X_0768_ _0603_ _0567_ Inst_SimpleCLB_ConfigMem.Inst_frame3_bit9.Q VGND VGND VPWR VPWR
+ _0604_ sky130_fd_sc_hd__o21a_1
X_2369_ Inst_SimpleCLB_switch_matrix.JW2BEG3 VGND VGND VPWR VPWR net214 sky130_fd_sc_hd__clkbuf_1
XFILLER_56_256 VGND VGND VPWR VPWR sky130_fd_sc_hd__decap_3
XFILLER_71_237 VGND VGND VPWR VPWR sky130_fd_sc_hd__decap_3
XFILLER_72_27 VGND VGND VPWR VPWR sky130_fd_sc_hd__fill_1
XFILLER_72_38 VGND VGND VPWR VPWR sky130_fd_sc_hd__decap_3
XFILLER_12_337 VGND VGND VPWR VPWR sky130_fd_sc_hd__fill_1
XTAP_TAPCELL_ROW_22_321 VGND VPWR sky130_fd_sc_hd__tapvpwrvgnd_1
XFILLER_24_197 VGND VGND VPWR VPWR sky130_fd_sc_hd__fill_2
XANTENNA_60 net110 VGND VGND VPWR VPWR sky130_fd_sc_hd__diode_2
XANTENNA_71 N4END[15] VGND VGND VPWR VPWR sky130_fd_sc_hd__diode_2
XANTENNA_82 NN4END[13] VGND VGND VPWR VPWR sky130_fd_sc_hd__diode_2
XANTENNA_93 S1END[0] VGND VGND VPWR VPWR sky130_fd_sc_hd__diode_2
XFILLER_21_86 VGND VGND VPWR VPWR sky130_fd_sc_hd__fill_1
XFILLER_46_50 VGND VGND VPWR VPWR sky130_fd_sc_hd__decap_3
XFILLER_46_94 VGND VGND VPWR VPWR sky130_fd_sc_hd__fill_2
XFILLER_15_186 VGND VGND VPWR VPWR sky130_fd_sc_hd__fill_1
XFILLER_30_123 VGND VGND VPWR VPWR sky130_fd_sc_hd__fill_1
XFILLER_62_82 VGND VGND VPWR VPWR sky130_fd_sc_hd__fill_2
XFILLER_30_156 VGND VGND VPWR VPWR sky130_fd_sc_hd__decap_3
XFILLER_7_33 VGND VGND VPWR VPWR sky130_fd_sc_hd__decap_3
XFILLER_30_189 VGND VGND VPWR VPWR sky130_fd_sc_hd__decap_3
X_1740_ net738 net718 VGND VGND VPWR VPWR Inst_SimpleCLB_ConfigMem.Inst_frame12_bit7.Q
+ sky130_fd_sc_hd__dlxtp_1
X_1671_ FrameData[2] net709 VGND VGND VPWR VPWR Inst_LG_LUT4c_frame_config_dffesr.inst_cus_mux161_buf.A14
+ sky130_fd_sc_hd__dlxtp_1
XFILLER_30_3 VGND VGND VPWR VPWR sky130_fd_sc_hd__fill_2
X_2223_ net780 VGND VGND VPWR VPWR net59 sky130_fd_sc_hd__clkbuf_1
XFILLER_38_212 VGND VGND VPWR VPWR sky130_fd_sc_hd__decap_3
XFILLER_38_245 VGND VGND VPWR VPWR sky130_fd_sc_hd__decap_3
X_2154_ clknet_1_1__leaf_UserCLK_regs _0005_ VGND VGND VPWR VPWR Inst_LE_LUT4c_frame_config_dffesr.LUT_flop
+ sky130_fd_sc_hd__dfxtp_1
XFILLER_38_267 VGND VGND VPWR VPWR sky130_fd_sc_hd__decap_3
X_1105_ _0196_ _0195_ _0165_ VGND VGND VPWR VPWR _0197_ sky130_fd_sc_hd__mux2_1
X_2085_ net798 net687 VGND VGND VPWR VPWR Inst_SimpleCLB_ConfigMem.Inst_frame1_bit0.Q
+ sky130_fd_sc_hd__dlxtp_1
XFILLER_53_215 VGND VGND VPWR VPWR sky130_fd_sc_hd__decap_3
X_1036_ N2END[3] S2END[3] E2END[3] WW4END[1] Inst_SimpleCLB_ConfigMem.Inst_frame5_bit13.Q
+ Inst_SimpleCLB_ConfigMem.Inst_frame5_bit12.Q VGND VGND VPWR VPWR _0131_ sky130_fd_sc_hd__mux4_2
XFILLER_21_189 VGND VGND VPWR VPWR sky130_fd_sc_hd__decap_3
X_1938_ net790 net670 VGND VGND VPWR VPWR Inst_SimpleCLB_ConfigMem.Inst_frame6_bit13.Q
+ sky130_fd_sc_hd__dlxtp_1
X_1869_ net736 net660 VGND VGND VPWR VPWR Inst_SimpleCLB_ConfigMem.Inst_frame8_bit8.Q
+ sky130_fd_sc_hd__dlxtp_1
XFILLER_88_156 VGND VGND VPWR VPWR sky130_fd_sc_hd__decap_3
XFILLER_88_134 VGND VGND VPWR VPWR sky130_fd_sc_hd__fill_2
XFILLER_67_27 VGND VGND VPWR VPWR sky130_fd_sc_hd__fill_1
XFILLER_88_178 VGND VGND VPWR VPWR sky130_fd_sc_hd__decap_3
XFILLER_29_245 VGND VGND VPWR VPWR sky130_fd_sc_hd__decap_3
XFILLER_44_215 VGND VGND VPWR VPWR sky130_fd_sc_hd__decap_3
XFILLER_44_237 VGND VGND VPWR VPWR sky130_fd_sc_hd__decap_3
XTAP_TAPCELL_ROW_67_593 VGND VPWR sky130_fd_sc_hd__tapvpwrvgnd_1
XPHY_EDGE_ROW_17_Left_108 VGND VGND VPWR VPWR sky130_fd_sc_hd__decap_3
XFILLER_12_178 VGND VGND VPWR VPWR sky130_fd_sc_hd__decap_3
XFILLER_8_138 VGND VGND VPWR VPWR sky130_fd_sc_hd__fill_2
XFILLER_32_74 VGND VGND VPWR VPWR sky130_fd_sc_hd__decap_3
XTAP_TAPCELL_ROW_50_493 VGND VPWR sky130_fd_sc_hd__tapvpwrvgnd_1
XFILLER_32_85 VGND VGND VPWR VPWR sky130_fd_sc_hd__decap_3
XPHY_EDGE_ROW_26_Left_117 VGND VGND VPWR VPWR sky130_fd_sc_hd__decap_3
XFILLER_35_237 VGND VGND VPWR VPWR sky130_fd_sc_hd__decap_3
XPHY_EDGE_ROW_35_Left_126 VGND VGND VPWR VPWR sky130_fd_sc_hd__decap_3
XFILLER_43_281 VGND VGND VPWR VPWR sky130_fd_sc_hd__decap_3
XFILLER_78_3 VGND VGND VPWR VPWR sky130_fd_sc_hd__fill_1
X_1723_ net769 net715 VGND VGND VPWR VPWR Inst_SimpleCLB_ConfigMem.Inst_frame13_bit22.Q
+ sky130_fd_sc_hd__dlxtp_1
XPHY_EDGE_ROW_44_Left_135 VGND VGND VPWR VPWR sky130_fd_sc_hd__decap_3
X_1654_ net782 net703 VGND VGND VPWR VPWR Inst_LF_LUT4c_frame_config_dffesr.c_out_mux
+ sky130_fd_sc_hd__dlxtp_1
Xhold138 Inst_LG_LUT4c_frame_config_dffesr.LUT_flop VGND VGND VPWR VPWR net392 sky130_fd_sc_hd__dlygate4sd3_1
X_1585_ net793 net694 VGND VGND VPWR VPWR Inst_LC_LUT4c_frame_config_dffesr.inst_cus_mux161_buf.A4
+ sky130_fd_sc_hd__dlxtp_1
Xfanout618 net620 VGND VGND VPWR VPWR net618 sky130_fd_sc_hd__buf_2
Xfanout629 net630 VGND VGND VPWR VPWR net629 sky130_fd_sc_hd__buf_8
XFILLER_85_137 VGND VGND VPWR VPWR sky130_fd_sc_hd__decap_3
X_2206_ net777 VGND VGND VPWR VPWR net61 sky130_fd_sc_hd__clkbuf_1
XPHY_EDGE_ROW_53_Left_144 VGND VGND VPWR VPWR sky130_fd_sc_hd__decap_3
X_2137_ net774 net731 VGND VGND VPWR VPWR Inst_SimpleCLB_ConfigMem.Inst_frame0_bit20.Q
+ sky130_fd_sc_hd__dlxtp_1
XFILLER_26_259 VGND VGND VPWR VPWR sky130_fd_sc_hd__fill_2
X_2068_ net786 net685 VGND VGND VPWR VPWR Inst_SimpleCLB_ConfigMem.Inst_frame2_bit15.Q
+ sky130_fd_sc_hd__dlxtp_1
X_1019_ _0112_ _0115_ _0105_ VGND VGND VPWR VPWR _0116_ sky130_fd_sc_hd__or3b_1
XFILLER_41_229 VGND VGND VPWR VPWR sky130_fd_sc_hd__decap_3
XTAP_TAPCELL_ROW_64_574 VGND VPWR sky130_fd_sc_hd__tapvpwrvgnd_1
XPHY_EDGE_ROW_62_Left_153 VGND VGND VPWR VPWR sky130_fd_sc_hd__decap_3
XPHY_EDGE_ROW_71_Left_162 VGND VGND VPWR VPWR sky130_fd_sc_hd__decap_3
XFILLER_17_237 VGND VGND VPWR VPWR sky130_fd_sc_hd__decap_3
XFILLER_17_204 VGND VGND VPWR VPWR sky130_fd_sc_hd__decap_3
XFILLER_27_63 VGND VGND VPWR VPWR sky130_fd_sc_hd__decap_3
XFILLER_72_321 VGND VGND VPWR VPWR sky130_fd_sc_hd__fill_1
XFILLER_84_192 VGND VGND VPWR VPWR sky130_fd_sc_hd__decap_3
XFILLER_32_229 VGND VGND VPWR VPWR sky130_fd_sc_hd__fill_1
XPHY_EDGE_ROW_80_Left_171 VGND VGND VPWR VPWR sky130_fd_sc_hd__decap_3
Xclone50 net635 VGND VGND VPWR VPWR net304 sky130_fd_sc_hd__clkbuf_1
Xclone94 net615 VGND VGND VPWR VPWR net348 sky130_fd_sc_hd__clkbuf_1
XFILLER_4_141 VGND VGND VPWR VPWR sky130_fd_sc_hd__decap_3
X_1370_ net653 E1END[0] W1END[0] net268 Inst_SimpleCLB_ConfigMem.Inst_frame11_bit8.Q
+ Inst_SimpleCLB_ConfigMem.Inst_frame11_bit9.Q VGND VGND VPWR VPWR _0438_ sky130_fd_sc_hd__mux4_1
XFILLER_68_81 VGND VGND VPWR VPWR sky130_fd_sc_hd__decap_3
XFILLER_84_91 VGND VGND VPWR VPWR sky130_fd_sc_hd__decap_3
XFILLER_90_184 VGND VGND VPWR VPWR sky130_fd_sc_hd__decap_3
XTAP_TAPCELL_ROW_18_298 VGND VPWR sky130_fd_sc_hd__tapvpwrvgnd_1
XTAP_TAPCELL_ROW_61_555 VGND VPWR sky130_fd_sc_hd__tapvpwrvgnd_1
XFILLER_31_284 VGND VGND VPWR VPWR sky130_fd_sc_hd__decap_3
X_1706_ net742 net713 VGND VGND VPWR VPWR Inst_SimpleCLB_ConfigMem.Inst_frame13_bit5.Q
+ sky130_fd_sc_hd__dlxtp_1
X_1637_ net799 net706 VGND VGND VPWR VPWR Inst_LE_LUT4c_frame_config_dffesr.c_reset_value
+ sky130_fd_sc_hd__dlxtp_1
X_1568_ net758 net692 VGND VGND VPWR VPWR Inst_LB_LUT4c_frame_config_dffesr.inst_cus_mux161_buf.A6
+ sky130_fd_sc_hd__dlxtp_1
XFILLER_48_18 VGND VGND VPWR VPWR sky130_fd_sc_hd__decap_3
X_1499_ _0528_ VGND VGND VPWR VPWR _0529_ sky130_fd_sc_hd__inv_1
XFILLER_58_137 VGND VGND VPWR VPWR sky130_fd_sc_hd__decap_3
XFILLER_73_107 VGND VGND VPWR VPWR sky130_fd_sc_hd__decap_3
XFILLER_66_170 VGND VGND VPWR VPWR sky130_fd_sc_hd__decap_3
XFILLER_81_173 VGND VGND VPWR VPWR sky130_fd_sc_hd__fill_1
XFILLER_81_162 VGND VGND VPWR VPWR sky130_fd_sc_hd__decap_3
XTAP_TAPCELL_ROW_1_199 VGND VPWR sky130_fd_sc_hd__tapvpwrvgnd_1
XTAP_TAPCELL_ROW_52_500 VGND VPWR sky130_fd_sc_hd__tapvpwrvgnd_1
XFILLER_22_251 VGND VGND VPWR VPWR sky130_fd_sc_hd__fill_1
XFILLER_80_38 VGND VGND VPWR VPWR sky130_fd_sc_hd__decap_3
XFILLER_13_43 VGND VGND VPWR VPWR sky130_fd_sc_hd__fill_2
XTAP_TAPCELL_ROW_9_244 VGND VPWR sky130_fd_sc_hd__tapvpwrvgnd_1
XFILLER_8_3 VGND VGND VPWR VPWR sky130_fd_sc_hd__fill_2
XFILLER_89_262 VGND VGND VPWR VPWR sky130_fd_sc_hd__decap_3
XFILLER_49_148 VGND VGND VPWR VPWR sky130_fd_sc_hd__decap_3
XFILLER_38_51 VGND VGND VPWR VPWR sky130_fd_sc_hd__decap_3
XFILLER_64_129 VGND VGND VPWR VPWR sky130_fd_sc_hd__decap_3
XFILLER_54_50 VGND VGND VPWR VPWR sky130_fd_sc_hd__decap_3
XTAP_TAPCELL_ROW_83_691 VGND VPWR sky130_fd_sc_hd__tapvpwrvgnd_1
XFILLER_54_83 VGND VGND VPWR VPWR sky130_fd_sc_hd__fill_1
XTAP_TAPCELL_ROW_15_279 VGND VPWR sky130_fd_sc_hd__tapvpwrvgnd_1
XFILLER_9_222 VGND VGND VPWR VPWR sky130_fd_sc_hd__fill_2
X_0870_ Inst_LA_LUT4c_frame_config_dffesr.inst_cus_mux161_buf.A14 Inst_LA_LUT4c_frame_config_dffesr.inst_cus_mux161_buf.A15
+ _0648_ VGND VGND VPWR VPWR _0698_ sky130_fd_sc_hd__mux2_1
X_1422_ net298 _0128_ Inst_SimpleCLB_ConfigMem.Inst_frame12_bit1.Q VGND VGND VPWR
+ VPWR _0483_ sky130_fd_sc_hd__mux2_4
X_1353_ net651 S1END[2] Inst_SimpleCLB_ConfigMem.Inst_frame11_bit22.Q VGND VGND VPWR
+ VPWR _0423_ sky130_fd_sc_hd__mux2_1
X_1284_ _0590_ _0362_ Inst_SimpleCLB_ConfigMem.Inst_frame3_bit25.Q VGND VGND VPWR
+ VPWR _0363_ sky130_fd_sc_hd__o21a_1
XFILLER_55_118 VGND VGND VPWR VPWR sky130_fd_sc_hd__decap_3
XFILLER_63_151 VGND VGND VPWR VPWR sky130_fd_sc_hd__decap_3
XFILLER_51_335 VGND VGND VPWR VPWR sky130_fd_sc_hd__fill_1
X_0999_ _0728_ _0727_ VGND VGND VPWR VPWR _0096_ sky130_fd_sc_hd__nand2b_1
XTAP_TAPCELL_ROW_6_225 VGND VPWR sky130_fd_sc_hd__tapvpwrvgnd_1
XFILLER_75_16 VGND VGND VPWR VPWR sky130_fd_sc_hd__fill_1
XFILLER_27_343 VGND VGND VPWR VPWR sky130_fd_sc_hd__decap_3
XFILLER_54_162 VGND VGND VPWR VPWR sky130_fd_sc_hd__decap_3
XFILLER_24_42 VGND VGND VPWR VPWR sky130_fd_sc_hd__decap_3
XFILLER_24_75 VGND VGND VPWR VPWR sky130_fd_sc_hd__decap_3
XTAP_TAPCELL_ROW_80_672 VGND VPWR sky130_fd_sc_hd__tapvpwrvgnd_1
XFILLER_6_203 VGND VGND VPWR VPWR sky130_fd_sc_hd__decap_3
XFILLER_6_236 VGND VGND VPWR VPWR sky130_fd_sc_hd__decap_3
XFILLER_40_41 VGND VGND VPWR VPWR sky130_fd_sc_hd__decap_3
XFILLER_49_61 VGND VGND VPWR VPWR sky130_fd_sc_hd__decap_3
Xfanout790 FrameData[13] VGND VGND VPWR VPWR net790 sky130_fd_sc_hd__clkbuf_4
XFILLER_77_287 VGND VGND VPWR VPWR sky130_fd_sc_hd__decap_3
XFILLER_18_343 VGND VGND VPWR VPWR sky130_fd_sc_hd__decap_3
XFILLER_1_57 VGND VGND VPWR VPWR sky130_fd_sc_hd__decap_3
XFILLER_65_60 VGND VGND VPWR VPWR sky130_fd_sc_hd__fill_1
XTAP_TAPCELL_ROW_28_360 VGND VPWR sky130_fd_sc_hd__tapvpwrvgnd_1
XFILLER_33_335 VGND VGND VPWR VPWR sky130_fd_sc_hd__fill_1
XANTENNA_150 WW4END[0] VGND VGND VPWR VPWR sky130_fd_sc_hd__diode_2
XANTENNA_161 WW4END[3] VGND VGND VPWR VPWR sky130_fd_sc_hd__diode_2
XANTENNA_194 net63 VGND VGND VPWR VPWR sky130_fd_sc_hd__diode_2
XANTENNA_172 net763 VGND VGND VPWR VPWR sky130_fd_sc_hd__diode_2
XFILLER_60_165 VGND VGND VPWR VPWR sky130_fd_sc_hd__decap_3
XANTENNA_183 net29 VGND VGND VPWR VPWR sky130_fd_sc_hd__diode_2
X_1971_ net788 net674 VGND VGND VPWR VPWR Inst_SimpleCLB_ConfigMem.Inst_frame5_bit14.Q
+ sky130_fd_sc_hd__dlxtp_1
X_0922_ W2END[5] net638 net642 net629 Inst_SimpleCLB_ConfigMem.Inst_frame2_bit11.Q
+ Inst_SimpleCLB_ConfigMem.Inst_frame2_bit10.Q VGND VGND VPWR VPWR _0025_ sky130_fd_sc_hd__mux4_1
X_0853_ Inst_SimpleCLB_ConfigMem.Inst_frame1_bit8.Q _0681_ VGND VGND VPWR VPWR _0682_
+ sky130_fd_sc_hd__and2b_1
XFILLER_60_3 VGND VGND VPWR VPWR sky130_fd_sc_hd__decap_3
X_0784_ NN4END[0] S2END[2] E2END[2] W2END[2] Inst_SimpleCLB_ConfigMem.Inst_frame6_bit29.Q
+ Inst_SimpleCLB_ConfigMem.Inst_frame6_bit28.Q VGND VGND VPWR VPWR _0618_ sky130_fd_sc_hd__mux4_2
X_1405_ _0468_ VGND VGND VPWR VPWR _0469_ sky130_fd_sc_hd__inv_1
X_2385_ W6END[5] VGND VGND VPWR VPWR net232 sky130_fd_sc_hd__clkbuf_2
XTAP_TAPCELL_ROW_86_709 VGND VPWR sky130_fd_sc_hd__tapvpwrvgnd_1
XTAP_TAPCELL_ROW_3_206 VGND VPWR sky130_fd_sc_hd__tapvpwrvgnd_1
X_1336_ net652 S1END[1] W1END[1] net618 Inst_SimpleCLB_ConfigMem.Inst_frame11_bit31.Q
+ Inst_SimpleCLB_ConfigMem.Inst_frame10_bit0.Q VGND VGND VPWR VPWR _0409_ sky130_fd_sc_hd__mux4_1
XFILLER_68_232 VGND VGND VPWR VPWR sky130_fd_sc_hd__fill_2
XFILLER_28_118 VGND VGND VPWR VPWR sky130_fd_sc_hd__decap_3
X_1267_ _0586_ _0347_ VGND VGND VPWR VPWR _0348_ sky130_fd_sc_hd__or2_1
X_1198_ _0283_ _0282_ _0234_ VGND VGND VPWR VPWR _0284_ sky130_fd_sc_hd__mux2_1
XFILLER_36_173 VGND VGND VPWR VPWR sky130_fd_sc_hd__decap_3
XFILLER_51_132 VGND VGND VPWR VPWR sky130_fd_sc_hd__decap_3
XFILLER_61_18 VGND VGND VPWR VPWR sky130_fd_sc_hd__decap_3
XTAP_TAPCELL_ROW_34_396 VGND VPWR sky130_fd_sc_hd__tapvpwrvgnd_1
XFILLER_3_228 VGND VGND VPWR VPWR sky130_fd_sc_hd__decap_3
XFILLER_86_15 VGND VGND VPWR VPWR sky130_fd_sc_hd__decap_3
XFILLER_19_75 VGND VGND VPWR VPWR sky130_fd_sc_hd__decap_3
XFILLER_27_162 VGND VGND VPWR VPWR sky130_fd_sc_hd__decap_3
XFILLER_27_195 VGND VGND VPWR VPWR sky130_fd_sc_hd__fill_1
XFILLER_42_121 VGND VGND VPWR VPWR sky130_fd_sc_hd__fill_1
XFILLER_15_346 VGND VGND VPWR VPWR sky130_fd_sc_hd__fill_1
XTAP_TAPCELL_ROW_25_341 VGND VPWR sky130_fd_sc_hd__tapvpwrvgnd_1
XFILLER_35_63 VGND VGND VPWR VPWR sky130_fd_sc_hd__decap_3
X_2170_ E2MID[1] VGND VGND VPWR VPWR net15 sky130_fd_sc_hd__buf_1
XFILLER_65_202 VGND VGND VPWR VPWR sky130_fd_sc_hd__decap_3
XFILLER_65_235 VGND VGND VPWR VPWR sky130_fd_sc_hd__decap_3
X_1121_ Inst_LE_LUT4c_frame_config_dffesr.inst_cus_mux161_buf.A3 _0202_ _0203_ Inst_LE_LUT4c_frame_config_dffesr.inst_cus_mux161_buf.A5
+ VGND VGND VPWR VPWR _0212_ sky130_fd_sc_hd__o22a_1
XTAP_TAPCELL_ROW_48_477 VGND VPWR sky130_fd_sc_hd__tapvpwrvgnd_1
X_1052_ net619 net615 net625 net611 Inst_SimpleCLB_ConfigMem.Inst_frame2_bit15.Q Inst_SimpleCLB_ConfigMem.Inst_frame2_bit14.Q
+ VGND VGND VPWR VPWR _0146_ sky130_fd_sc_hd__mux4_2
XFILLER_80_205 VGND VGND VPWR VPWR sky130_fd_sc_hd__decap_3
XFILLER_80_249 VGND VGND VPWR VPWR sky130_fd_sc_hd__decap_3
XFILLER_33_143 VGND VGND VPWR VPWR sky130_fd_sc_hd__decap_3
XFILLER_33_187 VGND VGND VPWR VPWR sky130_fd_sc_hd__decap_3
X_1954_ net753 net667 VGND VGND VPWR VPWR Inst_SimpleCLB_ConfigMem.Inst_frame6_bit29.Q
+ sky130_fd_sc_hd__dlxtp_1
X_0905_ _0727_ _0728_ VGND VGND VPWR VPWR _0009_ sky130_fd_sc_hd__or2_1
XTAP_TAPCELL_ROW_31_377 VGND VPWR sky130_fd_sc_hd__tapvpwrvgnd_1
X_1885_ net765 net660 VGND VGND VPWR VPWR Inst_SimpleCLB_ConfigMem.Inst_frame8_bit24.Q
+ sky130_fd_sc_hd__dlxtp_1
X_0836_ Inst_SimpleCLB_switch_matrix.JS2BEG3 VGND VGND VPWR VPWR _0666_ sky130_fd_sc_hd__inv_1
X_0767_ net621 net612 net631 net608 Inst_SimpleCLB_ConfigMem.Inst_frame3_bit7.Q Inst_SimpleCLB_ConfigMem.Inst_frame3_bit6.Q
+ VGND VGND VPWR VPWR _0603_ sky130_fd_sc_hd__mux4_2
XFILLER_88_305 VGND VGND VPWR VPWR sky130_fd_sc_hd__decap_3
X_2368_ Inst_SimpleCLB_switch_matrix.JW2BEG2 VGND VGND VPWR VPWR net213 sky130_fd_sc_hd__clkbuf_2
XFILLER_56_29 VGND VGND VPWR VPWR sky130_fd_sc_hd__decap_3
X_2299_ NN4END[10] VGND VGND VPWR VPWR net150 sky130_fd_sc_hd__buf_1
XTAP_TAPCELL_ROW_39_422 VGND VPWR sky130_fd_sc_hd__tapvpwrvgnd_1
X_1319_ _0393_ _0390_ Inst_SimpleCLB_ConfigMem.Inst_frame10_bit9.Q VGND VGND VPWR
+ VPWR Inst_SimpleCLB_switch_matrix.W6BEG1 sky130_fd_sc_hd__mux2_4
XFILLER_56_246 VGND VGND VPWR VPWR sky130_fd_sc_hd__decap_3
XFILLER_56_279 VGND VGND VPWR VPWR sky130_fd_sc_hd__decap_3
XFILLER_71_249 VGND VGND VPWR VPWR sky130_fd_sc_hd__fill_1
XFILLER_12_305 VGND VGND VPWR VPWR sky130_fd_sc_hd__decap_3
XFILLER_24_176 VGND VGND VPWR VPWR sky130_fd_sc_hd__decap_3
XTAP_TAPCELL_ROW_22_322 VGND VPWR sky130_fd_sc_hd__tapvpwrvgnd_1
XANTENNA_50 FrameStrobe[16] VGND VGND VPWR VPWR sky130_fd_sc_hd__diode_2
XANTENNA_83 NN4END[14] VGND VGND VPWR VPWR sky130_fd_sc_hd__diode_2
XANTENNA_61 N2END[0] VGND VGND VPWR VPWR sky130_fd_sc_hd__diode_2
XANTENNA_72 N4END[3] VGND VGND VPWR VPWR sky130_fd_sc_hd__diode_2
XANTENNA_94 S1END[0] VGND VGND VPWR VPWR sky130_fd_sc_hd__diode_2
Xoutput190 net190 VGND VGND VPWR VPWR SS4BEG[0] sky130_fd_sc_hd__buf_2
XFILLER_47_213 VGND VGND VPWR VPWR sky130_fd_sc_hd__decap_3
XFILLER_47_246 VGND VGND VPWR VPWR sky130_fd_sc_hd__decap_3
XFILLER_62_238 VGND VGND VPWR VPWR sky130_fd_sc_hd__decap_3
Xclkbuf_1_0__f_UserCLK clknet_0_UserCLK VGND VGND VPWR VPWR clknet_1_0__leaf_UserCLK
+ sky130_fd_sc_hd__clkbuf_16
XTAP_TAPCELL_ROW_45_458 VGND VPWR sky130_fd_sc_hd__tapvpwrvgnd_1
XFILLER_15_154 VGND VGND VPWR VPWR sky130_fd_sc_hd__decap_3
XFILLER_62_50 VGND VGND VPWR VPWR sky130_fd_sc_hd__decap_3
XFILLER_70_282 VGND VGND VPWR VPWR sky130_fd_sc_hd__decap_3
XFILLER_7_12 VGND VGND VPWR VPWR sky130_fd_sc_hd__decap_3
XFILLER_30_168 VGND VGND VPWR VPWR sky130_fd_sc_hd__decap_3
XFILLER_7_331 VGND VGND VPWR VPWR sky130_fd_sc_hd__decap_3
XFILLER_7_45 VGND VGND VPWR VPWR sky130_fd_sc_hd__decap_3
X_1670_ net777 net709 VGND VGND VPWR VPWR Inst_LG_LUT4c_frame_config_dffesr.inst_cus_mux161_buf.A13
+ sky130_fd_sc_hd__dlxtp_1
XFILLER_23_3 VGND VGND VPWR VPWR sky130_fd_sc_hd__decap_3
X_2222_ net782 VGND VGND VPWR VPWR net58 sky130_fd_sc_hd__clkbuf_1
X_2153_ clknet_1_0__leaf_UserCLK_regs _0004_ VGND VGND VPWR VPWR Inst_LD_LUT4c_frame_config_dffesr.LUT_flop
+ sky130_fd_sc_hd__dfxtp_1
X_1104_ Inst_LF_LUT4c_frame_config_dffesr.inst_cus_mux161_buf.A0 Inst_LF_LUT4c_frame_config_dffesr.inst_cus_mux161_buf.A2
+ Inst_LF_LUT4c_frame_config_dffesr.inst_cus_mux161_buf.A4 Inst_LF_LUT4c_frame_config_dffesr.inst_cus_mux161_buf.A6
+ _0167_ _0166_ VGND VGND VPWR VPWR _0196_ sky130_fd_sc_hd__mux4_1
X_2084_ net747 net683 VGND VGND VPWR VPWR Inst_SimpleCLB_ConfigMem.Inst_frame2_bit31.Q
+ sky130_fd_sc_hd__dlxtp_1
X_1035_ NN4END[2] S4END[2] E2END[2] Inst_SimpleCLB_switch_matrix.E2BEG3 Inst_SimpleCLB_ConfigMem.Inst_frame0_bit13.Q
+ Inst_SimpleCLB_ConfigMem.Inst_frame0_bit12.Q VGND VGND VPWR VPWR _0130_ sky130_fd_sc_hd__mux4_2
XFILLER_21_113 VGND VGND VPWR VPWR sky130_fd_sc_hd__fill_1
X_1937_ net793 net670 VGND VGND VPWR VPWR Inst_SimpleCLB_ConfigMem.Inst_frame6_bit12.Q
+ sky130_fd_sc_hd__dlxtp_1
X_1868_ net738 net661 VGND VGND VPWR VPWR Inst_SimpleCLB_ConfigMem.Inst_frame8_bit7.Q
+ sky130_fd_sc_hd__dlxtp_1
X_0819_ net621 net612 net631 net608 Inst_SimpleCLB_ConfigMem.Inst_frame3_bit31.Q Inst_SimpleCLB_ConfigMem.Inst_frame3_bit30.Q
+ VGND VGND VPWR VPWR _0651_ sky130_fd_sc_hd__mux4_1
X_1799_ net751 net728 VGND VGND VPWR VPWR Inst_SimpleCLB_ConfigMem.Inst_frame10_bit2.Q
+ sky130_fd_sc_hd__dlxtp_1
XFILLER_88_113 VGND VGND VPWR VPWR sky130_fd_sc_hd__decap_3
XFILLER_29_257 VGND VGND VPWR VPWR sky130_fd_sc_hd__decap_3
XFILLER_83_27 VGND VGND VPWR VPWR sky130_fd_sc_hd__fill_1
XTAP_TAPCELL_ROW_67_594 VGND VPWR sky130_fd_sc_hd__tapvpwrvgnd_1
XFILLER_44_249 VGND VGND VPWR VPWR sky130_fd_sc_hd__decap_3
XFILLER_8_106 VGND VGND VPWR VPWR sky130_fd_sc_hd__decap_3
XFILLER_4_345 VGND VGND VPWR VPWR sky130_fd_sc_hd__fill_2
XFILLER_79_113 VGND VGND VPWR VPWR sky130_fd_sc_hd__fill_1
XFILLER_79_135 VGND VGND VPWR VPWR sky130_fd_sc_hd__decap_3
XFILLER_35_205 VGND VGND VPWR VPWR sky130_fd_sc_hd__fill_2
XFILLER_28_290 VGND VGND VPWR VPWR sky130_fd_sc_hd__decap_3
XFILLER_43_260 VGND VGND VPWR VPWR sky130_fd_sc_hd__decap_3
XFILLER_73_60 VGND VGND VPWR VPWR sky130_fd_sc_hd__decap_3
X_1722_ net770 net712 VGND VGND VPWR VPWR Inst_SimpleCLB_ConfigMem.Inst_frame13_bit21.Q
+ sky130_fd_sc_hd__dlxtp_1
XFILLER_11_190 VGND VGND VPWR VPWR sky130_fd_sc_hd__decap_3
XFILLER_7_172 VGND VGND VPWR VPWR sky130_fd_sc_hd__decap_3
X_1653_ net784 net704 VGND VGND VPWR VPWR Inst_LF_LUT4c_frame_config_dffesr.inst_cus_mux161_buf.A15
+ sky130_fd_sc_hd__dlxtp_1
XPHY_EDGE_ROW_9_Right_9 VGND VGND VPWR VPWR sky130_fd_sc_hd__decap_3
Xhold139 Inst_LE_LUT4c_frame_config_dffesr.LUT_flop VGND VGND VPWR VPWR net393 sky130_fd_sc_hd__dlygate4sd3_1
X_1584_ net795 net695 VGND VGND VPWR VPWR Inst_LC_LUT4c_frame_config_dffesr.inst_cus_mux161_buf.A3
+ sky130_fd_sc_hd__dlxtp_1
Xfanout619 net620 VGND VGND VPWR VPWR net619 sky130_fd_sc_hd__clkbuf_2
Xfanout608 net609 VGND VGND VPWR VPWR net608 sky130_fd_sc_hd__buf_2
XFILLER_58_319 VGND VGND VPWR VPWR sky130_fd_sc_hd__fill_2
X_2205_ net799 VGND VGND VPWR VPWR net50 sky130_fd_sc_hd__clkbuf_2
XFILLER_26_216 VGND VGND VPWR VPWR sky130_fd_sc_hd__decap_3
X_2136_ net778 net731 VGND VGND VPWR VPWR Inst_SimpleCLB_ConfigMem.Inst_frame0_bit19.Q
+ sky130_fd_sc_hd__dlxtp_1
X_2067_ net788 net685 VGND VGND VPWR VPWR Inst_SimpleCLB_ConfigMem.Inst_frame2_bit14.Q
+ sky130_fd_sc_hd__dlxtp_1
X_1018_ Inst_LB_LUT4c_frame_config_dffesr.inst_cus_mux161_buf.A13 _0097_ _0114_ _0095_
+ VGND VGND VPWR VPWR _0115_ sky130_fd_sc_hd__o211a_1
XFILLER_41_208 VGND VGND VPWR VPWR sky130_fd_sc_hd__decap_3
XTAP_TAPCELL_ROW_64_575 VGND VPWR sky130_fd_sc_hd__tapvpwrvgnd_1
XFILLER_1_315 VGND VGND VPWR VPWR sky130_fd_sc_hd__decap_3
XFILLER_78_49 VGND VGND VPWR VPWR sky130_fd_sc_hd__decap_3
XFILLER_76_127 VGND VGND VPWR VPWR sky130_fd_sc_hd__decap_3
XFILLER_69_190 VGND VGND VPWR VPWR sky130_fd_sc_hd__decap_3
XFILLER_84_171 VGND VGND VPWR VPWR sky130_fd_sc_hd__decap_3
XFILLER_27_75 VGND VGND VPWR VPWR sky130_fd_sc_hd__decap_3
XTAP_TAPCELL_ROW_55_520 VGND VPWR sky130_fd_sc_hd__tapvpwrvgnd_1
XFILLER_32_208 VGND VGND VPWR VPWR sky130_fd_sc_hd__decap_3
XFILLER_43_85 VGND VGND VPWR VPWR sky130_fd_sc_hd__decap_3
Xclone51 net641 VGND VGND VPWR VPWR net305 sky130_fd_sc_hd__buf_8
XFILLER_57_9 VGND VGND VPWR VPWR sky130_fd_sc_hd__decap_3
XFILLER_4_186 VGND VGND VPWR VPWR sky130_fd_sc_hd__decap_3
XFILLER_4_197 VGND VGND VPWR VPWR sky130_fd_sc_hd__decap_3
XFILLER_67_105 VGND VGND VPWR VPWR sky130_fd_sc_hd__decap_3
XFILLER_68_60 VGND VGND VPWR VPWR sky130_fd_sc_hd__decap_3
XTAP_TAPCELL_ROW_78_656 VGND VPWR sky130_fd_sc_hd__tapvpwrvgnd_1
XFILLER_90_141 VGND VGND VPWR VPWR sky130_fd_sc_hd__decap_3
XFILLER_23_219 VGND VGND VPWR VPWR sky130_fd_sc_hd__decap_3
XTAP_TAPCELL_ROW_18_299 VGND VPWR sky130_fd_sc_hd__tapvpwrvgnd_1
XFILLER_90_3 VGND VGND VPWR VPWR sky130_fd_sc_hd__fill_1
XTAP_TAPCELL_ROW_61_556 VGND VPWR sky130_fd_sc_hd__tapvpwrvgnd_1
XFILLER_31_274 VGND VGND VPWR VPWR sky130_fd_sc_hd__decap_3
X_1705_ net744 net713 VGND VGND VPWR VPWR Inst_SimpleCLB_ConfigMem.Inst_frame13_bit4.Q
+ sky130_fd_sc_hd__dlxtp_1
X_1636_ net748 net701 VGND VGND VPWR VPWR Inst_LE_LUT4c_frame_config_dffesr.c_I0mux
+ sky130_fd_sc_hd__dlxtp_1
X_1567_ net760 net691 VGND VGND VPWR VPWR Inst_LB_LUT4c_frame_config_dffesr.inst_cus_mux161_buf.A5
+ sky130_fd_sc_hd__dlxtp_1
X_1498_ Inst_SimpleCLB_switch_matrix.JN2BEG2 Inst_SimpleCLB_switch_matrix.E2BEG2 Inst_SimpleCLB_ConfigMem.Inst_frame0_bit29.Q
+ VGND VGND VPWR VPWR _0528_ sky130_fd_sc_hd__mux2_1
XFILLER_58_116 VGND VGND VPWR VPWR sky130_fd_sc_hd__decap_3
XFILLER_73_119 VGND VGND VPWR VPWR sky130_fd_sc_hd__decap_3
X_2119_ net751 net732 VGND VGND VPWR VPWR Inst_SimpleCLB_ConfigMem.Inst_frame0_bit2.Q
+ sky130_fd_sc_hd__dlxtp_1
XTAP_TAPCELL_ROW_52_501 VGND VPWR sky130_fd_sc_hd__tapvpwrvgnd_1
XFILLER_22_230 VGND VGND VPWR VPWR sky130_fd_sc_hd__decap_3
XFILLER_13_55 VGND VGND VPWR VPWR sky130_fd_sc_hd__fill_1
XFILLER_13_88 VGND VGND VPWR VPWR sky130_fd_sc_hd__decap_3
XTAP_TAPCELL_ROW_9_245 VGND VPWR sky130_fd_sc_hd__tapvpwrvgnd_1
XFILLER_1_167 VGND VGND VPWR VPWR sky130_fd_sc_hd__fill_1
XFILLER_49_116 VGND VGND VPWR VPWR sky130_fd_sc_hd__decap_3
XFILLER_38_63 VGND VGND VPWR VPWR sky130_fd_sc_hd__decap_3
XFILLER_38_85 VGND VGND VPWR VPWR sky130_fd_sc_hd__decap_3
XFILLER_64_108 VGND VGND VPWR VPWR sky130_fd_sc_hd__decap_3
XFILLER_72_141 VGND VGND VPWR VPWR sky130_fd_sc_hd__decap_3
XFILLER_54_62 VGND VGND VPWR VPWR sky130_fd_sc_hd__decap_3
XFILLER_13_296 VGND VGND VPWR VPWR sky130_fd_sc_hd__fill_2
XFILLER_62_7 VGND VGND VPWR VPWR sky130_fd_sc_hd__decap_3
X_1421_ net648 net802 S1END[3] net644 Inst_SimpleCLB_ConfigMem.Inst_frame12_bit1.Q
+ Inst_SimpleCLB_ConfigMem.Inst_frame12_bit2.Q VGND VGND VPWR VPWR _0482_ sky130_fd_sc_hd__mux4_1
X_1352_ Inst_SimpleCLB_ConfigMem.Inst_frame11_bit23.Q _0421_ _0419_ Inst_SimpleCLB_ConfigMem.Inst_frame11_bit24.Q
+ VGND VGND VPWR VPWR _0422_ sky130_fd_sc_hd__o211a_1
X_1283_ net616 net623 net304 net613 Inst_SimpleCLB_ConfigMem.Inst_frame3_bit22.Q Inst_SimpleCLB_ConfigMem.Inst_frame3_bit23.Q
+ VGND VGND VPWR VPWR _0362_ sky130_fd_sc_hd__mux4_1
XFILLER_48_171 VGND VGND VPWR VPWR sky130_fd_sc_hd__fill_1
XFILLER_55_108 VGND VGND VPWR VPWR sky130_fd_sc_hd__decap_3
XFILLER_48_193 VGND VGND VPWR VPWR sky130_fd_sc_hd__decap_3
XFILLER_63_163 VGND VGND VPWR VPWR sky130_fd_sc_hd__fill_1
X_0998_ _0092_ _0093_ _0091_ VGND VGND VPWR VPWR _0095_ sky130_fd_sc_hd__o21ai_1
X_1619_ net789 net699 VGND VGND VPWR VPWR Inst_LE_LUT4c_frame_config_dffesr.inst_cus_mux161_buf.A0
+ sky130_fd_sc_hd__dlxtp_1
XTAP_TAPCELL_ROW_6_226 VGND VPWR sky130_fd_sc_hd__tapvpwrvgnd_1
XFILLER_86_288 VGND VGND VPWR VPWR sky130_fd_sc_hd__fill_1
XFILLER_39_160 VGND VGND VPWR VPWR sky130_fd_sc_hd__decap_3
XFILLER_10_200 VGND VGND VPWR VPWR sky130_fd_sc_hd__decap_3
XFILLER_24_54 VGND VGND VPWR VPWR sky130_fd_sc_hd__decap_3
XTAP_TAPCELL_ROW_80_673 VGND VPWR sky130_fd_sc_hd__tapvpwrvgnd_1
XFILLER_10_266 VGND VGND VPWR VPWR sky130_fd_sc_hd__fill_1
XFILLER_6_215 VGND VGND VPWR VPWR sky130_fd_sc_hd__decap_3
XFILLER_6_248 VGND VGND VPWR VPWR sky130_fd_sc_hd__decap_3
XFILLER_40_53 VGND VGND VPWR VPWR sky130_fd_sc_hd__decap_3
XFILLER_40_97 VGND VGND VPWR VPWR sky130_fd_sc_hd__decap_3
XFILLER_49_73 VGND VGND VPWR VPWR sky130_fd_sc_hd__decap_3
XFILLER_77_222 VGND VGND VPWR VPWR sky130_fd_sc_hd__fill_2
XFILLER_77_255 VGND VGND VPWR VPWR sky130_fd_sc_hd__decap_3
Xfanout780 net781 VGND VGND VPWR VPWR net780 sky130_fd_sc_hd__clkbuf_4
Xfanout791 FrameData[13] VGND VGND VPWR VPWR net791 sky130_fd_sc_hd__clkbuf_4
XFILLER_18_322 VGND VGND VPWR VPWR sky130_fd_sc_hd__decap_3
XFILLER_45_152 VGND VGND VPWR VPWR sky130_fd_sc_hd__decap_3
XFILLER_65_94 VGND VGND VPWR VPWR sky130_fd_sc_hd__decap_3
XANTENNA_151 WW4END[0] VGND VGND VPWR VPWR sky130_fd_sc_hd__diode_2
XANTENNA_140 W2END[7] VGND VGND VPWR VPWR sky130_fd_sc_hd__diode_2
XTAP_TAPCELL_ROW_28_361 VGND VPWR sky130_fd_sc_hd__tapvpwrvgnd_1
XANTENNA_184 E6END[0] VGND VGND VPWR VPWR sky130_fd_sc_hd__diode_2
XANTENNA_173 net763 VGND VGND VPWR VPWR sky130_fd_sc_hd__diode_2
XANTENNA_162 _0680_ VGND VGND VPWR VPWR sky130_fd_sc_hd__diode_2
X_1970_ net791 net673 VGND VGND VPWR VPWR Inst_SimpleCLB_ConfigMem.Inst_frame5_bit13.Q
+ sky130_fd_sc_hd__dlxtp_1
XANTENNA_195 net86 VGND VGND VPWR VPWR sky130_fd_sc_hd__diode_2
X_0921_ net618 net614 net633 net610 Inst_SimpleCLB_ConfigMem.Inst_frame2_bit11.Q Inst_SimpleCLB_ConfigMem.Inst_frame2_bit10.Q
+ VGND VGND VPWR VPWR _0024_ sky130_fd_sc_hd__mux4_2
XFILLER_81_82 VGND VGND VPWR VPWR sky130_fd_sc_hd__decap_3
X_0852_ WW4END[2] net636 net640 net626 Inst_SimpleCLB_ConfigMem.Inst_frame1_bit7.Q
+ Inst_SimpleCLB_ConfigMem.Inst_frame1_bit6.Q VGND VGND VPWR VPWR _0681_ sky130_fd_sc_hd__mux4_1
X_0783_ EE4END[2] S4END[2] W2END[7] Inst_SimpleCLB_switch_matrix.E2BEG1 Inst_SimpleCLB_ConfigMem.Inst_frame1_bit28.Q
+ Inst_SimpleCLB_ConfigMem.Inst_frame1_bit29.Q VGND VGND VPWR VPWR _0617_ sky130_fd_sc_hd__mux4_1
XFILLER_53_3 VGND VGND VPWR VPWR sky130_fd_sc_hd__fill_1
XFILLER_5_281 VGND VGND VPWR VPWR sky130_fd_sc_hd__fill_1
X_2384_ W6END[4] VGND VGND VPWR VPWR net231 sky130_fd_sc_hd__clkbuf_2
XFILLER_68_200 VGND VGND VPWR VPWR sky130_fd_sc_hd__decap_3
X_1404_ _0609_ _0050_ Inst_SimpleCLB_ConfigMem.Inst_frame12_bit10.Q VGND VGND VPWR
+ VPWR _0468_ sky130_fd_sc_hd__mux2_1
XTAP_TAPCELL_ROW_3_207 VGND VPWR sky130_fd_sc_hd__tapvpwrvgnd_1
X_1335_ net624 _0151_ _0241_ _0658_ Inst_SimpleCLB_ConfigMem.Inst_frame11_bit31.Q
+ Inst_SimpleCLB_ConfigMem.Inst_frame10_bit0.Q VGND VGND VPWR VPWR _0408_ sky130_fd_sc_hd__mux4_2
XFILLER_68_244 VGND VGND VPWR VPWR sky130_fd_sc_hd__fill_1
XFILLER_28_108 VGND VGND VPWR VPWR sky130_fd_sc_hd__decap_3
XFILLER_83_225 VGND VGND VPWR VPWR sky130_fd_sc_hd__decap_3
X_1266_ net616 net621 net631 net612 Inst_SimpleCLB_ConfigMem.Inst_frame2_bit22.Q Inst_SimpleCLB_ConfigMem.Inst_frame2_bit23.Q
+ VGND VGND VPWR VPWR _0347_ sky130_fd_sc_hd__mux4_1
XFILLER_36_141 VGND VGND VPWR VPWR sky130_fd_sc_hd__fill_2
X_1197_ Inst_LG_LUT4c_frame_config_dffesr.inst_cus_mux161_buf.A1 Inst_LG_LUT4c_frame_config_dffesr.inst_cus_mux161_buf.A3
+ Inst_LG_LUT4c_frame_config_dffesr.inst_cus_mux161_buf.A5 Inst_LG_LUT4c_frame_config_dffesr.inst_cus_mux161_buf.A7
+ _0257_ net263 VGND VGND VPWR VPWR _0283_ sky130_fd_sc_hd__mux4_1
XFILLER_24_303 VGND VGND VPWR VPWR sky130_fd_sc_hd__decap_3
XFILLER_51_111 VGND VGND VPWR VPWR sky130_fd_sc_hd__fill_1
XTAP_TAPCELL_ROW_34_397 VGND VPWR sky130_fd_sc_hd__tapvpwrvgnd_1
XFILLER_10_23 VGND VGND VPWR VPWR sky130_fd_sc_hd__fill_2
XFILLER_10_78 VGND VGND VPWR VPWR sky130_fd_sc_hd__decap_3
XFILLER_86_27 VGND VGND VPWR VPWR sky130_fd_sc_hd__fill_1
XFILLER_59_211 VGND VGND VPWR VPWR sky130_fd_sc_hd__decap_3
XFILLER_59_222 VGND VGND VPWR VPWR sky130_fd_sc_hd__fill_2
XFILLER_19_119 VGND VGND VPWR VPWR sky130_fd_sc_hd__decap_3
XFILLER_19_108 VGND VGND VPWR VPWR sky130_fd_sc_hd__decap_3
XFILLER_74_214 VGND VGND VPWR VPWR sky130_fd_sc_hd__decap_3
XFILLER_19_87 VGND VGND VPWR VPWR sky130_fd_sc_hd__decap_3
XFILLER_59_299 VGND VGND VPWR VPWR sky130_fd_sc_hd__fill_1
XFILLER_42_100 VGND VGND VPWR VPWR sky130_fd_sc_hd__decap_3
XTAP_TAPCELL_ROW_25_342 VGND VPWR sky130_fd_sc_hd__tapvpwrvgnd_1
XFILLER_35_75 VGND VGND VPWR VPWR sky130_fd_sc_hd__decap_3
XFILLER_42_188 VGND VGND VPWR VPWR sky130_fd_sc_hd__decap_3
XFILLER_51_96 VGND VGND VPWR VPWR sky130_fd_sc_hd__decap_3
X_1120_ _0205_ _0210_ _0201_ VGND VGND VPWR VPWR _0211_ sky130_fd_sc_hd__mux2_4
XFILLER_65_214 VGND VGND VPWR VPWR sky130_fd_sc_hd__decap_3
XFILLER_65_247 VGND VGND VPWR VPWR sky130_fd_sc_hd__decap_3
XFILLER_76_82 VGND VGND VPWR VPWR sky130_fd_sc_hd__fill_2
XFILLER_18_141 VGND VGND VPWR VPWR sky130_fd_sc_hd__decap_3
X_1051_ Inst_SimpleCLB_ConfigMem.Inst_frame2_bit16.Q _0144_ VGND VGND VPWR VPWR _0145_
+ sky130_fd_sc_hd__and2b_1
XFILLER_33_100 VGND VGND VPWR VPWR sky130_fd_sc_hd__decap_3
XTAP_TAPCELL_ROW_48_478 VGND VPWR sky130_fd_sc_hd__tapvpwrvgnd_1
XFILLER_33_122 VGND VGND VPWR VPWR sky130_fd_sc_hd__decap_3
XFILLER_33_155 VGND VGND VPWR VPWR sky130_fd_sc_hd__decap_3
X_1953_ net756 net667 VGND VGND VPWR VPWR Inst_SimpleCLB_ConfigMem.Inst_frame6_bit28.Q
+ sky130_fd_sc_hd__dlxtp_1
X_0904_ _0728_ _0727_ VGND VGND VPWR VPWR _0008_ sky130_fd_sc_hd__nor2_4
X_1884_ net767 net659 VGND VGND VPWR VPWR Inst_SimpleCLB_ConfigMem.Inst_frame8_bit23.Q
+ sky130_fd_sc_hd__dlxtp_1
X_0835_ _0662_ _0661_ _0665_ _0574_ VGND VGND VPWR VPWR Inst_SimpleCLB_switch_matrix.JS2BEG3
+ sky130_fd_sc_hd__a22o_4
XTAP_TAPCELL_ROW_31_378 VGND VPWR sky130_fd_sc_hd__tapvpwrvgnd_1
X_0766_ Inst_SimpleCLB_ConfigMem.Inst_frame3_bit8.Q _0601_ VGND VGND VPWR VPWR _0602_
+ sky130_fd_sc_hd__or2_4
X_2367_ Inst_SimpleCLB_switch_matrix.JW2BEG1 VGND VGND VPWR VPWR net212 sky130_fd_sc_hd__clkbuf_1
X_2298_ NN4END[9] VGND VGND VPWR VPWR net149 sky130_fd_sc_hd__buf_1
XTAP_TAPCELL_ROW_39_423 VGND VPWR sky130_fd_sc_hd__tapvpwrvgnd_1
X_1318_ _0392_ _0391_ Inst_SimpleCLB_ConfigMem.Inst_frame10_bit8.Q VGND VGND VPWR
+ VPWR _0393_ sky130_fd_sc_hd__mux2_1
X_1249_ net616 net621 net304 net612 Inst_SimpleCLB_ConfigMem.Inst_frame1_bit22.Q Inst_SimpleCLB_ConfigMem.Inst_frame1_bit23.Q
+ VGND VGND VPWR VPWR _0332_ sky130_fd_sc_hd__mux4_1
XFILLER_24_133 VGND VGND VPWR VPWR sky130_fd_sc_hd__decap_3
XFILLER_72_18 VGND VGND VPWR VPWR sky130_fd_sc_hd__fill_2
XFILLER_72_29 VGND VGND VPWR VPWR sky130_fd_sc_hd__decap_3
XTAP_TAPCELL_ROW_22_323 VGND VPWR sky130_fd_sc_hd__tapvpwrvgnd_1
XANTENNA_40 FrameData[9] VGND VGND VPWR VPWR sky130_fd_sc_hd__diode_2
XANTENNA_51 FrameStrobe[19] VGND VGND VPWR VPWR sky130_fd_sc_hd__diode_2
XANTENNA_62 N2MID[2] VGND VGND VPWR VPWR sky130_fd_sc_hd__diode_2
XANTENNA_84 NN4END[15] VGND VGND VPWR VPWR sky130_fd_sc_hd__diode_2
XANTENNA_73 N4END[4] VGND VGND VPWR VPWR sky130_fd_sc_hd__diode_2
XFILLER_21_55 VGND VGND VPWR VPWR sky130_fd_sc_hd__fill_1
XANTENNA_95 S1END[0] VGND VGND VPWR VPWR sky130_fd_sc_hd__diode_2
XFILLER_21_77 VGND VGND VPWR VPWR sky130_fd_sc_hd__decap_3
Xoutput180 net180 VGND VGND VPWR VPWR S4BEG[15] sky130_fd_sc_hd__buf_4
Xoutput191 net191 VGND VGND VPWR VPWR SS4BEG[10] sky130_fd_sc_hd__buf_2
XFILLER_46_41 VGND VGND VPWR VPWR sky130_fd_sc_hd__decap_3
XPHY_EDGE_ROW_6_Left_97 VGND VGND VPWR VPWR sky130_fd_sc_hd__decap_3
XTAP_TAPCELL_ROW_45_459 VGND VPWR sky130_fd_sc_hd__tapvpwrvgnd_1
XFILLER_15_166 VGND VGND VPWR VPWR sky130_fd_sc_hd__fill_2
XFILLER_62_73 VGND VGND VPWR VPWR sky130_fd_sc_hd__decap_3
XFILLER_7_310 VGND VGND VPWR VPWR sky130_fd_sc_hd__decap_3
XFILLER_7_24 VGND VGND VPWR VPWR sky130_fd_sc_hd__decap_3
XFILLER_7_343 VGND VGND VPWR VPWR sky130_fd_sc_hd__decap_3
XFILLER_7_57 VGND VGND VPWR VPWR sky130_fd_sc_hd__decap_3
X_2221_ net784 VGND VGND VPWR VPWR net57 sky130_fd_sc_hd__clkbuf_1
XFILLER_38_203 VGND VGND VPWR VPWR sky130_fd_sc_hd__decap_3
X_2152_ clknet_1_0__leaf_UserCLK_regs _0003_ VGND VGND VPWR VPWR Inst_LC_LUT4c_frame_config_dffesr.LUT_flop
+ sky130_fd_sc_hd__dfxtp_1
X_2083_ net749 net683 VGND VGND VPWR VPWR Inst_SimpleCLB_ConfigMem.Inst_frame2_bit30.Q
+ sky130_fd_sc_hd__dlxtp_1
X_1103_ Inst_LF_LUT4c_frame_config_dffesr.inst_cus_mux161_buf.A3 _0169_ _0194_ VGND
+ VGND VPWR VPWR _0195_ sky130_fd_sc_hd__o21a_1
XTAP_TAPCELL_ROW_36_404 VGND VPWR sky130_fd_sc_hd__tapvpwrvgnd_1
XFILLER_53_206 VGND VGND VPWR VPWR sky130_fd_sc_hd__decap_3
XFILLER_53_239 VGND VGND VPWR VPWR sky130_fd_sc_hd__decap_3
X_1034_ _0125_ _0126_ _0128_ _0127_ Inst_SimpleCLB_ConfigMem.Inst_frame9_bit28.Q Inst_SimpleCLB_ConfigMem.Inst_frame9_bit29.Q
+ VGND VGND VPWR VPWR _0129_ sky130_fd_sc_hd__mux4_1
XFILLER_21_158 VGND VGND VPWR VPWR sky130_fd_sc_hd__fill_1
X_1936_ net795 net668 VGND VGND VPWR VPWR Inst_SimpleCLB_ConfigMem.Inst_frame6_bit11.Q
+ sky130_fd_sc_hd__dlxtp_1
X_1867_ net740 net661 VGND VGND VPWR VPWR Inst_SimpleCLB_ConfigMem.Inst_frame8_bit6.Q
+ sky130_fd_sc_hd__dlxtp_1
X_0818_ W6END[0] net626 net640 net616 Inst_SimpleCLB_ConfigMem.Inst_frame3_bit31.Q
+ Inst_SimpleCLB_ConfigMem.Inst_frame3_bit30.Q VGND VGND VPWR VPWR _0650_ sky130_fd_sc_hd__mux4_2
X_1798_ net777 net727 VGND VGND VPWR VPWR Inst_SimpleCLB_ConfigMem.Inst_frame10_bit1.Q
+ sky130_fd_sc_hd__dlxtp_1
X_0749_ Inst_SimpleCLB_ConfigMem.Inst_frame2_bit29.Q VGND VGND VPWR VPWR _0585_ sky130_fd_sc_hd__inv_1
XFILLER_67_18 VGND VGND VPWR VPWR sky130_fd_sc_hd__decap_3
XFILLER_29_236 VGND VGND VPWR VPWR sky130_fd_sc_hd__decap_3
XFILLER_44_206 VGND VGND VPWR VPWR sky130_fd_sc_hd__decap_3
XFILLER_44_228 VGND VGND VPWR VPWR sky130_fd_sc_hd__decap_3
XTAP_TAPCELL_ROW_67_595 VGND VPWR sky130_fd_sc_hd__tapvpwrvgnd_1
XFILLER_16_55 VGND VGND VPWR VPWR sky130_fd_sc_hd__decap_3
XFILLER_12_136 VGND VGND VPWR VPWR sky130_fd_sc_hd__decap_3
XFILLER_12_103 VGND VGND VPWR VPWR sky130_fd_sc_hd__decap_3
XFILLER_32_65 VGND VGND VPWR VPWR sky130_fd_sc_hd__decap_3
XFILLER_20_191 VGND VGND VPWR VPWR sky130_fd_sc_hd__decap_3
XFILLER_57_95 VGND VGND VPWR VPWR sky130_fd_sc_hd__decap_3
XTAP_TAPCELL_ROW_58_540 VGND VPWR sky130_fd_sc_hd__tapvpwrvgnd_1
XFILLER_73_72 VGND VGND VPWR VPWR sky130_fd_sc_hd__fill_2
X_1721_ net773 net712 VGND VGND VPWR VPWR Inst_SimpleCLB_ConfigMem.Inst_frame13_bit20.Q
+ sky130_fd_sc_hd__dlxtp_1
XFILLER_7_162 VGND VGND VPWR VPWR sky130_fd_sc_hd__decap_3
X_1652_ FrameData[15] net703 VGND VGND VPWR VPWR Inst_LF_LUT4c_frame_config_dffesr.inst_cus_mux161_buf.A14
+ sky130_fd_sc_hd__dlxtp_1
X_1583_ net797 net694 VGND VGND VPWR VPWR Inst_LC_LUT4c_frame_config_dffesr.inst_cus_mux161_buf.A2
+ sky130_fd_sc_hd__dlxtp_1
Xfanout609 net310 VGND VGND VPWR VPWR net609 sky130_fd_sc_hd__buf_6
XFILLER_85_106 VGND VGND VPWR VPWR sky130_fd_sc_hd__decap_3
XFILLER_85_128 VGND VGND VPWR VPWR sky130_fd_sc_hd__decap_3
X_2204_ Inst_SimpleCLB_switch_matrix.EE4BEG3 VGND VGND VPWR VPWR net40 sky130_fd_sc_hd__buf_1
X_2135_ net780 net731 VGND VGND VPWR VPWR Inst_SimpleCLB_ConfigMem.Inst_frame0_bit18.Q
+ sky130_fd_sc_hd__dlxtp_1
X_2066_ net791 net685 VGND VGND VPWR VPWR Inst_SimpleCLB_ConfigMem.Inst_frame2_bit13.Q
+ sky130_fd_sc_hd__dlxtp_1
X_1017_ Inst_LB_LUT4c_frame_config_dffesr.inst_cus_mux161_buf.A9 _0009_ _0010_ Inst_LB_LUT4c_frame_config_dffesr.inst_cus_mux161_buf.A15
+ _0113_ VGND VGND VPWR VPWR _0114_ sky130_fd_sc_hd__o221a_1
XTAP_TAPCELL_ROW_64_576 VGND VPWR sky130_fd_sc_hd__tapvpwrvgnd_1
X_1919_ net761 net664 VGND VGND VPWR VPWR Inst_SimpleCLB_ConfigMem.Inst_frame7_bit26.Q
+ sky130_fd_sc_hd__dlxtp_1
XFILLER_1_327 VGND VGND VPWR VPWR sky130_fd_sc_hd__decap_3
XFILLER_76_106 VGND VGND VPWR VPWR sky130_fd_sc_hd__fill_2
XFILLER_76_139 VGND VGND VPWR VPWR sky130_fd_sc_hd__fill_1
XFILLER_84_150 VGND VGND VPWR VPWR sky130_fd_sc_hd__decap_3
XFILLER_17_228 VGND VGND VPWR VPWR sky130_fd_sc_hd__decap_3
XFILLER_27_43 VGND VGND VPWR VPWR sky130_fd_sc_hd__fill_1
XTAP_TAPCELL_ROW_55_521 VGND VPWR sky130_fd_sc_hd__tapvpwrvgnd_1
XFILLER_40_253 VGND VGND VPWR VPWR sky130_fd_sc_hd__decap_3
Xclone63 Inst_LG_LUT4c_frame_config_dffesr.O VGND VGND VPWR VPWR net317 sky130_fd_sc_hd__buf_6
XFILLER_4_25 VGND VGND VPWR VPWR sky130_fd_sc_hd__decap_3
XFILLER_4_154 VGND VGND VPWR VPWR sky130_fd_sc_hd__fill_1
XFILLER_68_72 VGND VGND VPWR VPWR sky130_fd_sc_hd__decap_3
XFILLER_67_139 VGND VGND VPWR VPWR sky130_fd_sc_hd__decap_3
XTAP_TAPCELL_ROW_78_657 VGND VPWR sky130_fd_sc_hd__tapvpwrvgnd_1
XFILLER_75_150 VGND VGND VPWR VPWR sky130_fd_sc_hd__decap_3
XFILLER_90_197 VGND VGND VPWR VPWR sky130_fd_sc_hd__decap_3
XTAP_TAPCELL_ROW_61_557 VGND VPWR sky130_fd_sc_hd__tapvpwrvgnd_1
X_1704_ net746 net711 VGND VGND VPWR VPWR Inst_SimpleCLB_ConfigMem.Inst_frame13_bit3.Q
+ sky130_fd_sc_hd__dlxtp_1
X_1635_ net750 net701 VGND VGND VPWR VPWR Inst_LE_LUT4c_frame_config_dffesr.c_out_mux
+ sky130_fd_sc_hd__dlxtp_1
X_1566_ net763 net691 VGND VGND VPWR VPWR Inst_LB_LUT4c_frame_config_dffesr.inst_cus_mux161_buf.A4
+ sky130_fd_sc_hd__dlxtp_1
XTAP_TAPCELL_ROW_69_602 VGND VPWR sky130_fd_sc_hd__tapvpwrvgnd_1
X_1497_ _0526_ VGND VGND VPWR VPWR _0527_ sky130_fd_sc_hd__inv_1
XFILLER_58_128 VGND VGND VPWR VPWR sky130_fd_sc_hd__decap_3
XFILLER_66_161 VGND VGND VPWR VPWR sky130_fd_sc_hd__fill_1
X_2118_ net776 net730 VGND VGND VPWR VPWR Inst_SimpleCLB_ConfigMem.Inst_frame0_bit1.Q
+ sky130_fd_sc_hd__dlxtp_1
XFILLER_54_334 VGND VGND VPWR VPWR sky130_fd_sc_hd__fill_1
XFILLER_66_194 VGND VGND VPWR VPWR sky130_fd_sc_hd__fill_2
X_2049_ net756 net679 VGND VGND VPWR VPWR Inst_SimpleCLB_ConfigMem.Inst_frame3_bit28.Q
+ sky130_fd_sc_hd__dlxtp_1
XTAP_TAPCELL_ROW_52_502 VGND VPWR sky130_fd_sc_hd__tapvpwrvgnd_1
XFILLER_22_242 VGND VGND VPWR VPWR sky130_fd_sc_hd__decap_3
XFILLER_80_29 VGND VGND VPWR VPWR sky130_fd_sc_hd__decap_3
XFILLER_22_253 VGND VGND VPWR VPWR sky130_fd_sc_hd__decap_3
XFILLER_89_231 VGND VGND VPWR VPWR sky130_fd_sc_hd__fill_1
XTAP_TAPCELL_ROW_9_246 VGND VPWR sky130_fd_sc_hd__tapvpwrvgnd_1
XFILLER_89_253 VGND VGND VPWR VPWR sky130_fd_sc_hd__decap_3
XFILLER_49_106 VGND VGND VPWR VPWR sky130_fd_sc_hd__decap_3
XFILLER_49_128 VGND VGND VPWR VPWR sky130_fd_sc_hd__decap_3
XFILLER_38_75 VGND VGND VPWR VPWR sky130_fd_sc_hd__decap_3
XTAP_TAPCELL_ROW_75_638 VGND VPWR sky130_fd_sc_hd__tapvpwrvgnd_1
XFILLER_54_41 VGND VGND VPWR VPWR sky130_fd_sc_hd__decap_3
XTAP_TAPCELL_ROW_0_190 VGND VPWR sky130_fd_sc_hd__tapvpwrvgnd_1
XFILLER_13_231 VGND VGND VPWR VPWR sky130_fd_sc_hd__decap_3
XFILLER_54_85 VGND VGND VPWR VPWR sky130_fd_sc_hd__fill_2
XFILLER_13_264 VGND VGND VPWR VPWR sky130_fd_sc_hd__fill_2
XFILLER_9_213 VGND VGND VPWR VPWR sky130_fd_sc_hd__decap_3
XFILLER_70_62 VGND VGND VPWR VPWR sky130_fd_sc_hd__fill_1
X_1420_ Inst_SimpleCLB_ConfigMem.Inst_frame12_bit6.Q _0481_ _0480_ VGND VGND VPWR
+ VPWR Inst_SimpleCLB_switch_matrix.EE4BEG2 sky130_fd_sc_hd__o21ba_1
XFILLER_48_6 VGND VGND VPWR VPWR sky130_fd_sc_hd__decap_3
XFILLER_79_60 VGND VGND VPWR VPWR sky130_fd_sc_hd__decap_3
X_1351_ _0420_ VGND VGND VPWR VPWR _0421_ sky130_fd_sc_hd__inv_1
X_1282_ Inst_SimpleCLB_ConfigMem.Inst_frame3_bit24.Q _0360_ VGND VGND VPWR VPWR _0361_
+ sky130_fd_sc_hd__or2_1
XFILLER_48_150 VGND VGND VPWR VPWR sky130_fd_sc_hd__decap_3
XFILLER_36_312 VGND VGND VPWR VPWR sky130_fd_sc_hd__fill_2
X_0997_ _0092_ _0093_ _0091_ VGND VGND VPWR VPWR _0094_ sky130_fd_sc_hd__o21a_1
X_1618_ net790 net698 VGND VGND VPWR VPWR Inst_LD_LUT4c_frame_config_dffesr.c_reset_value
+ sky130_fd_sc_hd__dlxtp_1
XFILLER_86_223 VGND VGND VPWR VPWR sky130_fd_sc_hd__fill_2
X_1549_ net736 net692 VGND VGND VPWR VPWR Inst_LA_LUT4c_frame_config_dffesr.inst_cus_mux161_buf.A6
+ sky130_fd_sc_hd__dlxtp_1
XTAP_TAPCELL_ROW_6_227 VGND VPWR sky130_fd_sc_hd__tapvpwrvgnd_1
XFILLER_54_153 VGND VGND VPWR VPWR sky130_fd_sc_hd__decap_3
XFILLER_54_197 VGND VGND VPWR VPWR sky130_fd_sc_hd__decap_3
XFILLER_24_33 VGND VGND VPWR VPWR sky130_fd_sc_hd__decap_3
XPHY_EDGE_ROW_59_Left_150 VGND VGND VPWR VPWR sky130_fd_sc_hd__decap_3
XFILLER_10_212 VGND VGND VPWR VPWR sky130_fd_sc_hd__fill_1
XFILLER_24_88 VGND VGND VPWR VPWR sky130_fd_sc_hd__fill_2
XFILLER_6_227 VGND VGND VPWR VPWR sky130_fd_sc_hd__decap_3
XFILLER_40_21 VGND VGND VPWR VPWR sky130_fd_sc_hd__decap_3
XFILLER_40_32 VGND VGND VPWR VPWR sky130_fd_sc_hd__decap_3
XFILLER_49_30 VGND VGND VPWR VPWR sky130_fd_sc_hd__decap_3
XFILLER_49_41 VGND VGND VPWR VPWR sky130_fd_sc_hd__fill_1
Xclkbuf_regs_0_UserCLK UserCLK VGND VGND VPWR VPWR UserCLK_regs sky130_fd_sc_hd__clkbuf_16
XFILLER_77_234 VGND VGND VPWR VPWR sky130_fd_sc_hd__decap_3
XFILLER_1_37 VGND VGND VPWR VPWR sky130_fd_sc_hd__decap_3
Xfanout770 net772 VGND VGND VPWR VPWR net770 sky130_fd_sc_hd__buf_4
Xfanout781 FrameData[18] VGND VGND VPWR VPWR net781 sky130_fd_sc_hd__buf_4
Xfanout792 net793 VGND VGND VPWR VPWR net792 sky130_fd_sc_hd__clkbuf_4
XFILLER_77_278 VGND VGND VPWR VPWR sky130_fd_sc_hd__fill_2
XFILLER_18_334 VGND VGND VPWR VPWR sky130_fd_sc_hd__decap_3
XFILLER_45_142 VGND VGND VPWR VPWR sky130_fd_sc_hd__decap_3
XANTENNA_141 W2END[7] VGND VGND VPWR VPWR sky130_fd_sc_hd__diode_2
XANTENNA_130 W2END[0] VGND VGND VPWR VPWR sky130_fd_sc_hd__diode_2
XANTENNA_152 WW4END[0] VGND VGND VPWR VPWR sky130_fd_sc_hd__diode_2
XFILLER_33_337 VGND VGND VPWR VPWR sky130_fd_sc_hd__fill_2
XANTENNA_185 E6END[4] VGND VGND VPWR VPWR sky130_fd_sc_hd__diode_2
XANTENNA_163 net647 VGND VGND VPWR VPWR sky130_fd_sc_hd__diode_2
XANTENNA_174 net765 VGND VGND VPWR VPWR sky130_fd_sc_hd__diode_2
XANTENNA_196 net95 VGND VGND VPWR VPWR sky130_fd_sc_hd__diode_2
X_0920_ N2END[4] E2END[4] SS4END[2] W2END[4] Inst_SimpleCLB_ConfigMem.Inst_frame5_bit6.Q
+ Inst_SimpleCLB_ConfigMem.Inst_frame5_bit7.Q VGND VGND VPWR VPWR _0023_ sky130_fd_sc_hd__mux4_2
X_0851_ N2END[0] E2END[0] S2END[0] WW4END[3] Inst_SimpleCLB_ConfigMem.Inst_frame5_bit0.Q
+ Inst_SimpleCLB_ConfigMem.Inst_frame5_bit1.Q VGND VGND VPWR VPWR _0680_ sky130_fd_sc_hd__mux4_2
X_0782_ _0612_ _0613_ _0616_ _0570_ VGND VGND VPWR VPWR Inst_SimpleCLB_switch_matrix.E2BEG1
+ sky130_fd_sc_hd__a22o_1
XFILLER_46_3 VGND VGND VPWR VPWR sky130_fd_sc_hd__decap_3
XPHY_EDGE_ROW_18_Right_18 VGND VGND VPWR VPWR sky130_fd_sc_hd__decap_3
X_2383_ W6END[3] VGND VGND VPWR VPWR net230 sky130_fd_sc_hd__clkbuf_2
XFILLER_68_212 VGND VGND VPWR VPWR sky130_fd_sc_hd__decap_3
X_1403_ Inst_SimpleCLB_ConfigMem.Inst_frame12_bit12.Q _0466_ Inst_SimpleCLB_ConfigMem.Inst_frame12_bit13.Q
+ VGND VGND VPWR VPWR _0467_ sky130_fd_sc_hd__o21ai_1
XTAP_TAPCELL_ROW_3_208 VGND VPWR sky130_fd_sc_hd__tapvpwrvgnd_1
XFILLER_68_256 VGND VGND VPWR VPWR sky130_fd_sc_hd__fill_2
X_1334_ _0401_ _0406_ _0407_ VGND VGND VPWR VPWR Inst_SimpleCLB_switch_matrix.W6BEG0
+ sky130_fd_sc_hd__o21ai_1
X_1265_ W2END[0] net268 net305 net626 Inst_SimpleCLB_ConfigMem.Inst_frame2_bit23.Q
+ Inst_SimpleCLB_ConfigMem.Inst_frame2_bit22.Q VGND VGND VPWR VPWR _0346_ sky130_fd_sc_hd__mux4_1
XFILLER_83_237 VGND VGND VPWR VPWR sky130_fd_sc_hd__decap_3
X_1196_ Inst_LG_LUT4c_frame_config_dffesr.inst_cus_mux161_buf.A0 Inst_LG_LUT4c_frame_config_dffesr.inst_cus_mux161_buf.A2
+ Inst_LG_LUT4c_frame_config_dffesr.inst_cus_mux161_buf.A4 Inst_LG_LUT4c_frame_config_dffesr.inst_cus_mux161_buf.A6
+ _0257_ net263 VGND VGND VPWR VPWR _0282_ sky130_fd_sc_hd__mux4_1
XFILLER_24_337 VGND VGND VPWR VPWR sky130_fd_sc_hd__decap_3
XPHY_EDGE_ROW_27_Right_27 VGND VGND VPWR VPWR sky130_fd_sc_hd__decap_3
XFILLER_36_197 VGND VGND VPWR VPWR sky130_fd_sc_hd__decap_3
XFILLER_3_219 VGND VGND VPWR VPWR sky130_fd_sc_hd__decap_3
XPHY_EDGE_ROW_36_Right_36 VGND VGND VPWR VPWR sky130_fd_sc_hd__decap_3
XTAP_TAPCELL_ROW_85_700 VGND VPWR sky130_fd_sc_hd__tapvpwrvgnd_1
XFILLER_59_278 VGND VGND VPWR VPWR sky130_fd_sc_hd__fill_2
XFILLER_74_226 VGND VGND VPWR VPWR sky130_fd_sc_hd__decap_3
XFILLER_19_99 VGND VGND VPWR VPWR sky130_fd_sc_hd__decap_3
XFILLER_27_131 VGND VGND VPWR VPWR sky130_fd_sc_hd__fill_1
XFILLER_35_43 VGND VGND VPWR VPWR sky130_fd_sc_hd__fill_1
XFILLER_42_112 VGND VGND VPWR VPWR sky130_fd_sc_hd__decap_3
XPHY_EDGE_ROW_45_Right_45 VGND VGND VPWR VPWR sky130_fd_sc_hd__decap_3
XFILLER_15_337 VGND VGND VPWR VPWR sky130_fd_sc_hd__decap_3
XTAP_TAPCELL_ROW_25_343 VGND VPWR sky130_fd_sc_hd__tapvpwrvgnd_1
XFILLER_30_307 VGND VGND VPWR VPWR sky130_fd_sc_hd__fill_1
XFILLER_51_31 VGND VGND VPWR VPWR sky130_fd_sc_hd__fill_2
XFILLER_51_42 VGND VGND VPWR VPWR sky130_fd_sc_hd__fill_1
XPHY_EDGE_ROW_54_Right_54 VGND VGND VPWR VPWR sky130_fd_sc_hd__decap_3
XFILLER_76_94 VGND VGND VPWR VPWR sky130_fd_sc_hd__decap_3
XFILLER_18_120 VGND VGND VPWR VPWR sky130_fd_sc_hd__decap_3
X_1050_ W2END[6] net638 net642 net629 Inst_SimpleCLB_ConfigMem.Inst_frame2_bit15.Q
+ Inst_SimpleCLB_ConfigMem.Inst_frame2_bit14.Q VGND VGND VPWR VPWR _0144_ sky130_fd_sc_hd__mux4_1
XPHY_EDGE_ROW_63_Right_63 VGND VGND VPWR VPWR sky130_fd_sc_hd__decap_3
XFILLER_65_259 VGND VGND VPWR VPWR sky130_fd_sc_hd__decap_3
XFILLER_18_153 VGND VGND VPWR VPWR sky130_fd_sc_hd__fill_1
XTAP_TAPCELL_ROW_48_479 VGND VPWR sky130_fd_sc_hd__tapvpwrvgnd_1
XFILLER_33_134 VGND VGND VPWR VPWR sky130_fd_sc_hd__decap_3
XFILLER_33_167 VGND VGND VPWR VPWR sky130_fd_sc_hd__fill_1
X_1952_ net759 net669 VGND VGND VPWR VPWR Inst_SimpleCLB_ConfigMem.Inst_frame6_bit27.Q
+ sky130_fd_sc_hd__dlxtp_1
X_0903_ _0667_ _0669_ _0658_ _0657_ Inst_SimpleCLB_ConfigMem.Inst_frame10_bit24.Q
+ Inst_SimpleCLB_ConfigMem.Inst_frame10_bit25.Q VGND VGND VPWR VPWR _0728_ sky130_fd_sc_hd__mux4_2
X_1883_ net769 net659 VGND VGND VPWR VPWR Inst_SimpleCLB_ConfigMem.Inst_frame8_bit22.Q
+ sky130_fd_sc_hd__dlxtp_1
X_0834_ _0663_ _0664_ _0573_ VGND VGND VPWR VPWR _0665_ sky130_fd_sc_hd__mux2_1
XTAP_TAPCELL_ROW_31_379 VGND VPWR sky130_fd_sc_hd__tapvpwrvgnd_1
XPHY_EDGE_ROW_72_Right_72 VGND VGND VPWR VPWR sky130_fd_sc_hd__decap_3
X_0765_ W6END[0] net636 net305 net626 Inst_SimpleCLB_ConfigMem.Inst_frame3_bit7.Q
+ Inst_SimpleCLB_ConfigMem.Inst_frame3_bit6.Q VGND VGND VPWR VPWR _0601_ sky130_fd_sc_hd__mux4_2
X_2366_ Inst_SimpleCLB_switch_matrix.JW2BEG0 VGND VGND VPWR VPWR net211 sky130_fd_sc_hd__buf_1
X_2297_ NN4END[8] VGND VGND VPWR VPWR net148 sky130_fd_sc_hd__buf_1
XPHY_EDGE_ROW_81_Right_81 VGND VGND VPWR VPWR sky130_fd_sc_hd__decap_3
XFILLER_2_80 VGND VGND VPWR VPWR sky130_fd_sc_hd__fill_1
XTAP_TAPCELL_ROW_39_424 VGND VPWR sky130_fd_sc_hd__tapvpwrvgnd_1
X_1317_ net650 S1END[2] E1END[2] net647 Inst_SimpleCLB_ConfigMem.Inst_frame10_bit7.Q
+ Inst_SimpleCLB_ConfigMem.Inst_frame10_bit6.Q VGND VGND VPWR VPWR _0392_ sky130_fd_sc_hd__mux4_1
X_1248_ _0331_ Inst_LD_LUT4c_frame_config_dffesr.LUT_flop Inst_LD_LUT4c_frame_config_dffesr.c_out_mux
+ VGND VGND VPWR VPWR Inst_LD_LUT4c_frame_config_dffesr.O sky130_fd_sc_hd__mux2_4
XFILLER_56_259 VGND VGND VPWR VPWR sky130_fd_sc_hd__fill_2
X_1179_ W2END[7] net638 net642 net302 Inst_SimpleCLB_ConfigMem.Inst_frame1_bit19.Q
+ Inst_SimpleCLB_ConfigMem.Inst_frame1_bit18.Q VGND VGND VPWR VPWR _0266_ sky130_fd_sc_hd__mux4_2
XFILLER_24_112 VGND VGND VPWR VPWR sky130_fd_sc_hd__decap_3
XTAP_TAPCELL_ROW_22_324 VGND VPWR sky130_fd_sc_hd__tapvpwrvgnd_1
XANTENNA_41 FrameData[9] VGND VGND VPWR VPWR sky130_fd_sc_hd__diode_2
XANTENNA_30 FrameData[16] VGND VGND VPWR VPWR sky130_fd_sc_hd__diode_2
XPHY_EDGE_ROW_90_Right_90 VGND VGND VPWR VPWR sky130_fd_sc_hd__decap_3
XANTENNA_52 FrameStrobe[19] VGND VGND VPWR VPWR sky130_fd_sc_hd__diode_2
XANTENNA_74 N4END[5] VGND VGND VPWR VPWR sky130_fd_sc_hd__diode_2
XANTENNA_63 N2MID[2] VGND VGND VPWR VPWR sky130_fd_sc_hd__diode_2
XANTENNA_96 S1END[0] VGND VGND VPWR VPWR sky130_fd_sc_hd__diode_2
XANTENNA_85 NN4END[1] VGND VGND VPWR VPWR sky130_fd_sc_hd__diode_2
Xoutput170 net170 VGND VGND VPWR VPWR S2BEGb[4] sky130_fd_sc_hd__buf_2
Xoutput181 net181 VGND VGND VPWR VPWR S4BEG[1] sky130_fd_sc_hd__buf_2
Xoutput192 net192 VGND VGND VPWR VPWR SS4BEG[11] sky130_fd_sc_hd__buf_2
XFILLER_46_53 VGND VGND VPWR VPWR sky130_fd_sc_hd__decap_3
XFILLER_70_251 VGND VGND VPWR VPWR sky130_fd_sc_hd__fill_1
XFILLER_70_262 VGND VGND VPWR VPWR sky130_fd_sc_hd__decap_3
XFILLER_62_41 VGND VGND VPWR VPWR sky130_fd_sc_hd__decap_3
XFILLER_70_295 VGND VGND VPWR VPWR sky130_fd_sc_hd__decap_3
XFILLER_30_159 VGND VGND VPWR VPWR sky130_fd_sc_hd__decap_3
XFILLER_62_85 VGND VGND VPWR VPWR sky130_fd_sc_hd__decap_3
XFILLER_7_322 VGND VGND VPWR VPWR sky130_fd_sc_hd__decap_3
XFILLER_7_36 VGND VGND VPWR VPWR sky130_fd_sc_hd__decap_3
X_2220_ net786 VGND VGND VPWR VPWR net56 sky130_fd_sc_hd__clkbuf_2
X_2151_ clknet_1_0__leaf_UserCLK_regs _0002_ VGND VGND VPWR VPWR Inst_LB_LUT4c_frame_config_dffesr.LUT_flop
+ sky130_fd_sc_hd__dfxtp_1
XFILLER_38_215 VGND VGND VPWR VPWR sky130_fd_sc_hd__decap_3
XFILLER_38_248 VGND VGND VPWR VPWR sky130_fd_sc_hd__decap_3
X_2082_ net753 net684 VGND VGND VPWR VPWR Inst_SimpleCLB_ConfigMem.Inst_frame2_bit29.Q
+ sky130_fd_sc_hd__dlxtp_1
X_1102_ Inst_LF_LUT4c_frame_config_dffesr.inst_cus_mux161_buf.A7 _0171_ _0173_ Inst_LF_LUT4c_frame_config_dffesr.inst_cus_mux161_buf.A5
+ _0193_ VGND VGND VPWR VPWR _0194_ sky130_fd_sc_hd__o221a_1
X_1033_ N2END[7] S2END[7] EE4END[2] W2END[7] Inst_SimpleCLB_ConfigMem.Inst_frame5_bit11.Q
+ Inst_SimpleCLB_ConfigMem.Inst_frame5_bit10.Q VGND VGND VPWR VPWR _0128_ sky130_fd_sc_hd__mux4_2
XTAP_TAPCELL_ROW_36_405 VGND VPWR sky130_fd_sc_hd__tapvpwrvgnd_1
XFILLER_53_218 VGND VGND VPWR VPWR sky130_fd_sc_hd__decap_3
XFILLER_61_240 VGND VGND VPWR VPWR sky130_fd_sc_hd__fill_1
XFILLER_61_262 VGND VGND VPWR VPWR sky130_fd_sc_hd__decap_3
X_1935_ net797 net668 VGND VGND VPWR VPWR Inst_SimpleCLB_ConfigMem.Inst_frame6_bit10.Q
+ sky130_fd_sc_hd__dlxtp_1
X_1866_ net742 net662 VGND VGND VPWR VPWR Inst_SimpleCLB_ConfigMem.Inst_frame8_bit5.Q
+ sky130_fd_sc_hd__dlxtp_1
X_0817_ Inst_LA_LUT4c_frame_config_dffesr.inst_cus_mux161_buf.A4 Inst_LA_LUT4c_frame_config_dffesr.inst_cus_mux161_buf.A5
+ _0648_ VGND VGND VPWR VPWR _0649_ sky130_fd_sc_hd__mux2_1
X_1797_ net798 net728 VGND VGND VPWR VPWR Inst_SimpleCLB_ConfigMem.Inst_frame10_bit0.Q
+ sky130_fd_sc_hd__dlxtp_1
X_0748_ Inst_SimpleCLB_ConfigMem.Inst_frame2_bit28.Q VGND VGND VPWR VPWR _0584_ sky130_fd_sc_hd__inv_1
X_2349_ SS4END[8] VGND VGND VPWR VPWR net200 sky130_fd_sc_hd__buf_2
XFILLER_29_248 VGND VGND VPWR VPWR sky130_fd_sc_hd__decap_3
XFILLER_83_18 VGND VGND VPWR VPWR sky130_fd_sc_hd__decap_3
XFILLER_44_218 VGND VGND VPWR VPWR sky130_fd_sc_hd__decap_3
XFILLER_37_281 VGND VGND VPWR VPWR sky130_fd_sc_hd__decap_3
XPHY_EDGE_ROW_0_Right_0 VGND VGND VPWR VPWR sky130_fd_sc_hd__decap_3
XFILLER_52_295 VGND VGND VPWR VPWR sky130_fd_sc_hd__decap_3
XFILLER_32_33 VGND VGND VPWR VPWR sky130_fd_sc_hd__fill_2
XFILLER_32_77 VGND VGND VPWR VPWR sky130_fd_sc_hd__decap_3
XFILLER_32_88 VGND VGND VPWR VPWR sky130_fd_sc_hd__fill_2
XFILLER_79_126 VGND VGND VPWR VPWR sky130_fd_sc_hd__decap_3
XTAP_TAPCELL_ROW_58_541 VGND VPWR sky130_fd_sc_hd__tapvpwrvgnd_1
XFILLER_43_251 VGND VGND VPWR VPWR sky130_fd_sc_hd__decap_3
XFILLER_43_284 VGND VGND VPWR VPWR sky130_fd_sc_hd__decap_3
XFILLER_11_181 VGND VGND VPWR VPWR sky130_fd_sc_hd__decap_3
X_1720_ net778 net712 VGND VGND VPWR VPWR Inst_SimpleCLB_ConfigMem.Inst_frame13_bit19.Q
+ sky130_fd_sc_hd__dlxtp_1
X_1651_ FrameData[14] net704 VGND VGND VPWR VPWR Inst_LF_LUT4c_frame_config_dffesr.inst_cus_mux161_buf.A13
+ sky130_fd_sc_hd__dlxtp_1
X_1582_ net734 net695 VGND VGND VPWR VPWR Inst_LC_LUT4c_frame_config_dffesr.inst_cus_mux161_buf.A1
+ sky130_fd_sc_hd__dlxtp_1
XPHY_EDGE_ROW_13_Left_104 VGND VGND VPWR VPWR sky130_fd_sc_hd__decap_3
X_2203_ Inst_SimpleCLB_switch_matrix.EE4BEG2 VGND VGND VPWR VPWR net39 sky130_fd_sc_hd__clkbuf_2
XFILLER_66_321 VGND VGND VPWR VPWR sky130_fd_sc_hd__fill_1
X_2134_ net783 net729 VGND VGND VPWR VPWR Inst_SimpleCLB_ConfigMem.Inst_frame0_bit17.Q
+ sky130_fd_sc_hd__dlxtp_1
XFILLER_78_192 VGND VGND VPWR VPWR sky130_fd_sc_hd__decap_3
XFILLER_26_207 VGND VGND VPWR VPWR sky130_fd_sc_hd__decap_3
X_2065_ net792 net685 VGND VGND VPWR VPWR Inst_SimpleCLB_ConfigMem.Inst_frame2_bit12.Q
+ sky130_fd_sc_hd__dlxtp_1
XFILLER_19_270 VGND VGND VPWR VPWR sky130_fd_sc_hd__decap_3
X_1016_ Inst_LB_LUT4c_frame_config_dffesr.inst_cus_mux161_buf.A11 _0096_ VGND VGND
+ VPWR VPWR _0113_ sky130_fd_sc_hd__or2_1
XFILLER_34_251 VGND VGND VPWR VPWR sky130_fd_sc_hd__fill_1
XTAP_TAPCELL_ROW_64_577 VGND VPWR sky130_fd_sc_hd__tapvpwrvgnd_1
XPHY_EDGE_ROW_22_Left_113 VGND VGND VPWR VPWR sky130_fd_sc_hd__decap_3
X_1918_ net762 net663 VGND VGND VPWR VPWR Inst_SimpleCLB_ConfigMem.Inst_frame7_bit25.Q
+ sky130_fd_sc_hd__dlxtp_1
X_1849_ net774 net657 VGND VGND VPWR VPWR Inst_SimpleCLB_ConfigMem.Inst_frame9_bit20.Q
+ sky130_fd_sc_hd__dlxtp_1
XPHY_EDGE_ROW_31_Left_122 VGND VGND VPWR VPWR sky130_fd_sc_hd__decap_3
XFILLER_84_162 VGND VGND VPWR VPWR sky130_fd_sc_hd__decap_3
XFILLER_17_207 VGND VGND VPWR VPWR sky130_fd_sc_hd__decap_3
XFILLER_84_195 VGND VGND VPWR VPWR sky130_fd_sc_hd__fill_1
XFILLER_27_66 VGND VGND VPWR VPWR sky130_fd_sc_hd__decap_3
XTAP_TAPCELL_ROW_55_522 VGND VPWR sky130_fd_sc_hd__tapvpwrvgnd_1
XFILLER_25_240 VGND VGND VPWR VPWR sky130_fd_sc_hd__decap_3
XPHY_EDGE_ROW_40_Left_131 VGND VGND VPWR VPWR sky130_fd_sc_hd__decap_3
XFILLER_25_284 VGND VGND VPWR VPWR sky130_fd_sc_hd__fill_1
XFILLER_4_111 VGND VGND VPWR VPWR sky130_fd_sc_hd__decap_3
XFILLER_4_144 VGND VGND VPWR VPWR sky130_fd_sc_hd__decap_3
XFILLER_4_177 VGND VGND VPWR VPWR sky130_fd_sc_hd__decap_3
XTAP_TAPCELL_ROW_78_658 VGND VPWR sky130_fd_sc_hd__tapvpwrvgnd_1
XFILLER_75_162 VGND VGND VPWR VPWR sky130_fd_sc_hd__decap_3
XFILLER_84_83 VGND VGND VPWR VPWR sky130_fd_sc_hd__fill_1
XFILLER_16_251 VGND VGND VPWR VPWR sky130_fd_sc_hd__fill_1
XFILLER_90_187 VGND VGND VPWR VPWR sky130_fd_sc_hd__decap_3
XFILLER_16_262 VGND VGND VPWR VPWR sky130_fd_sc_hd__decap_3
XFILLER_31_232 VGND VGND VPWR VPWR sky130_fd_sc_hd__decap_3
XTAP_TAPCELL_ROW_61_558 VGND VPWR sky130_fd_sc_hd__tapvpwrvgnd_1
XFILLER_31_265 VGND VGND VPWR VPWR sky130_fd_sc_hd__fill_2
XFILLER_31_287 VGND VGND VPWR VPWR sky130_fd_sc_hd__fill_2
XFILLER_76_3 VGND VGND VPWR VPWR sky130_fd_sc_hd__decap_3
X_1703_ net752 net711 VGND VGND VPWR VPWR Inst_SimpleCLB_ConfigMem.Inst_frame13_bit2.Q
+ sky130_fd_sc_hd__dlxtp_1
X_1634_ net755 net699 VGND VGND VPWR VPWR Inst_LE_LUT4c_frame_config_dffesr.inst_cus_mux161_buf.A15
+ sky130_fd_sc_hd__dlxtp_1
X_1565_ net765 net691 VGND VGND VPWR VPWR Inst_LB_LUT4c_frame_config_dffesr.inst_cus_mux161_buf.A3
+ sky130_fd_sc_hd__dlxtp_1
X_1496_ net265 Inst_SimpleCLB_switch_matrix.JW2BEG2 Inst_SimpleCLB_ConfigMem.Inst_frame0_bit29.Q
+ VGND VGND VPWR VPWR _0526_ sky130_fd_sc_hd__mux2_1
XFILLER_58_107 VGND VGND VPWR VPWR sky130_fd_sc_hd__decap_3
XTAP_TAPCELL_ROW_69_603 VGND VPWR sky130_fd_sc_hd__tapvpwrvgnd_1
XFILLER_54_302 VGND VGND VPWR VPWR sky130_fd_sc_hd__decap_3
X_2117_ net798 net730 VGND VGND VPWR VPWR Inst_SimpleCLB_ConfigMem.Inst_frame0_bit0.Q
+ sky130_fd_sc_hd__dlxtp_1
XFILLER_66_173 VGND VGND VPWR VPWR sky130_fd_sc_hd__decap_3
XFILLER_81_165 VGND VGND VPWR VPWR sky130_fd_sc_hd__decap_3
X_2048_ net758 net679 VGND VGND VPWR VPWR Inst_SimpleCLB_ConfigMem.Inst_frame3_bit27.Q
+ sky130_fd_sc_hd__dlxtp_1
XTAP_TAPCELL_ROW_52_503 VGND VPWR sky130_fd_sc_hd__tapvpwrvgnd_1
XTAP_TAPCELL_ROW_17_290 VGND VPWR sky130_fd_sc_hd__tapvpwrvgnd_1
XFILLER_13_57 VGND VGND VPWR VPWR sky130_fd_sc_hd__decap_3
XFILLER_89_221 VGND VGND VPWR VPWR sky130_fd_sc_hd__decap_3
XFILLER_89_210 VGND VGND VPWR VPWR sky130_fd_sc_hd__fill_1
XTAP_TAPCELL_ROW_9_247 VGND VPWR sky130_fd_sc_hd__tapvpwrvgnd_1
XFILLER_89_265 VGND VGND VPWR VPWR sky130_fd_sc_hd__decap_3
XFILLER_1_169 VGND VGND VPWR VPWR sky130_fd_sc_hd__fill_1
XFILLER_38_54 VGND VGND VPWR VPWR sky130_fd_sc_hd__decap_3
XFILLER_72_121 VGND VGND VPWR VPWR sky130_fd_sc_hd__fill_2
XTAP_TAPCELL_ROW_75_639 VGND VPWR sky130_fd_sc_hd__tapvpwrvgnd_1
XFILLER_54_20 VGND VGND VPWR VPWR sky130_fd_sc_hd__fill_2
XFILLER_54_53 VGND VGND VPWR VPWR sky130_fd_sc_hd__decap_3
XTAP_TAPCELL_ROW_0_191 VGND VPWR sky130_fd_sc_hd__tapvpwrvgnd_1
XFILLER_70_96 VGND VGND VPWR VPWR sky130_fd_sc_hd__decap_3
X_1350_ net348 _0609_ Inst_SimpleCLB_ConfigMem.Inst_frame11_bit22.Q VGND VGND VPWR
+ VPWR _0420_ sky130_fd_sc_hd__mux2_1
X_1281_ WW4END[0] net637 net641 net628 Inst_SimpleCLB_ConfigMem.Inst_frame3_bit23.Q
+ Inst_SimpleCLB_ConfigMem.Inst_frame3_bit22.Q VGND VGND VPWR VPWR _0360_ sky130_fd_sc_hd__mux4_1
XFILLER_48_162 VGND VGND VPWR VPWR sky130_fd_sc_hd__decap_3
XFILLER_48_184 VGND VGND VPWR VPWR sky130_fd_sc_hd__decap_3
XFILLER_63_154 VGND VGND VPWR VPWR sky130_fd_sc_hd__decap_3
X_0996_ Inst_SimpleCLB_ConfigMem.Inst_frame10_bit26.Q _0680_ Inst_SimpleCLB_ConfigMem.Inst_frame10_bit27.Q
+ VGND VGND VPWR VPWR _0093_ sky130_fd_sc_hd__o21ai_1
X_1617_ net793 net702 VGND VGND VPWR VPWR Inst_LD_LUT4c_frame_config_dffesr.c_I0mux
+ sky130_fd_sc_hd__dlxtp_1
XFILLER_5_80 VGND VGND VPWR VPWR sky130_fd_sc_hd__decap_3
X_1548_ net738 net692 VGND VGND VPWR VPWR Inst_LA_LUT4c_frame_config_dffesr.inst_cus_mux161_buf.A5
+ sky130_fd_sc_hd__dlxtp_1
XTAP_TAPCELL_ROW_6_228 VGND VPWR sky130_fd_sc_hd__tapvpwrvgnd_1
XFILLER_86_257 VGND VGND VPWR VPWR sky130_fd_sc_hd__decap_3
X_1479_ net304 Inst_SimpleCLB_switch_matrix.JN2BEG1 net645 _0262_ Inst_SimpleCLB_ConfigMem.Inst_frame13_bit27.Q
+ Inst_SimpleCLB_ConfigMem.Inst_frame13_bit26.Q VGND VGND VPWR VPWR Inst_SimpleCLB_switch_matrix.E1BEG2
+ sky130_fd_sc_hd__mux4_2
XFILLER_54_110 VGND VGND VPWR VPWR sky130_fd_sc_hd__decap_3
XFILLER_27_346 VGND VGND VPWR VPWR sky130_fd_sc_hd__fill_1
XFILLER_54_132 VGND VGND VPWR VPWR sky130_fd_sc_hd__decap_3
XFILLER_54_165 VGND VGND VPWR VPWR sky130_fd_sc_hd__fill_2
XFILLER_24_45 VGND VGND VPWR VPWR sky130_fd_sc_hd__decap_3
XFILLER_24_78 VGND VGND VPWR VPWR sky130_fd_sc_hd__decap_3
Xclkbuf_0_UserCLK_regs UserCLK_regs VGND VGND VPWR VPWR clknet_0_UserCLK_regs sky130_fd_sc_hd__clkbuf_16
XFILLER_6_206 VGND VGND VPWR VPWR sky130_fd_sc_hd__decap_3
XFILLER_6_239 VGND VGND VPWR VPWR sky130_fd_sc_hd__decap_3
XFILLER_40_44 VGND VGND VPWR VPWR sky130_fd_sc_hd__decap_3
XFILLER_6_3 VGND VGND VPWR VPWR sky130_fd_sc_hd__decap_3
XFILLER_49_64 VGND VGND VPWR VPWR sky130_fd_sc_hd__decap_3
XTAP_TAPCELL_ROW_88_720 VGND VPWR sky130_fd_sc_hd__tapvpwrvgnd_1
Xfanout760 net761 VGND VGND VPWR VPWR net760 sky130_fd_sc_hd__clkbuf_4
Xfanout771 net772 VGND VGND VPWR VPWR net771 sky130_fd_sc_hd__clkbuf_2
Xfanout782 net783 VGND VGND VPWR VPWR net782 sky130_fd_sc_hd__clkbuf_4
Xfanout793 FrameData[12] VGND VGND VPWR VPWR net793 sky130_fd_sc_hd__buf_4
XFILLER_18_302 VGND VGND VPWR VPWR sky130_fd_sc_hd__decap_3
XFILLER_18_346 VGND VGND VPWR VPWR sky130_fd_sc_hd__fill_1
XANTENNA_131 W2END[2] VGND VGND VPWR VPWR sky130_fd_sc_hd__diode_2
XANTENNA_142 W6END[1] VGND VGND VPWR VPWR sky130_fd_sc_hd__diode_2
XANTENNA_120 SS4END[1] VGND VGND VPWR VPWR sky130_fd_sc_hd__diode_2
XANTENNA_175 net767 VGND VGND VPWR VPWR sky130_fd_sc_hd__diode_2
XANTENNA_153 WW4END[0] VGND VGND VPWR VPWR sky130_fd_sc_hd__diode_2
XANTENNA_164 net647 VGND VGND VPWR VPWR sky130_fd_sc_hd__diode_2
XANTENNA_186 E6END[8] VGND VGND VPWR VPWR sky130_fd_sc_hd__diode_2
XANTENNA_197 Inst_SimpleCLB_switch_matrix.JN2BEG3 VGND VGND VPWR VPWR sky130_fd_sc_hd__diode_2
XFILLER_60_168 VGND VGND VPWR VPWR sky130_fd_sc_hd__decap_3
X_0850_ N4END[0] net801 S4END[0] Inst_SimpleCLB_switch_matrix.JW2BEG1 Inst_SimpleCLB_ConfigMem.Inst_frame0_bit0.Q
+ Inst_SimpleCLB_ConfigMem.Inst_frame0_bit1.Q VGND VGND VPWR VPWR _0679_ sky130_fd_sc_hd__mux4_1
X_0781_ _0614_ _0615_ Inst_SimpleCLB_ConfigMem.Inst_frame3_bit0.Q VGND VGND VPWR VPWR
+ _0616_ sky130_fd_sc_hd__mux2_1
X_1402_ net267 net317 net634 net264 Inst_SimpleCLB_ConfigMem.Inst_frame12_bit11.Q
+ Inst_SimpleCLB_ConfigMem.Inst_frame12_bit10.Q VGND VGND VPWR VPWR _0466_ sky130_fd_sc_hd__mux4_1
X_2382_ W6END[2] VGND VGND VPWR VPWR net227 sky130_fd_sc_hd__clkbuf_2
X_1333_ Inst_SimpleCLB_ConfigMem.Inst_frame10_bit4.Q _0397_ _0399_ Inst_SimpleCLB_ConfigMem.Inst_frame10_bit5.Q
+ _0395_ VGND VGND VPWR VPWR _0407_ sky130_fd_sc_hd__a311o_1
XTAP_TAPCELL_ROW_3_209 VGND VPWR sky130_fd_sc_hd__tapvpwrvgnd_1
X_1264_ _0340_ _0342_ _0345_ _0585_ VGND VGND VPWR VPWR Inst_SimpleCLB_switch_matrix.JW2BEG0
+ sky130_fd_sc_hd__a22o_1
X_1195_ _0261_ _0280_ _0234_ VGND VGND VPWR VPWR _0281_ sky130_fd_sc_hd__mux2_4
XFILLER_24_316 VGND VGND VPWR VPWR sky130_fd_sc_hd__decap_3
XFILLER_36_176 VGND VGND VPWR VPWR sky130_fd_sc_hd__decap_3
XFILLER_51_102 VGND VGND VPWR VPWR sky130_fd_sc_hd__decap_3
X_0979_ _0075_ _0076_ _0068_ _0067_ Inst_SimpleCLB_ConfigMem.Inst_frame9_bit4.Q Inst_SimpleCLB_ConfigMem.Inst_frame9_bit5.Q
+ VGND VGND VPWR VPWR _0077_ sky130_fd_sc_hd__mux4_2
XFILLER_86_29 VGND VGND VPWR VPWR sky130_fd_sc_hd__decap_3
XFILLER_86_18 VGND VGND VPWR VPWR sky130_fd_sc_hd__decap_3
XFILLER_59_202 VGND VGND VPWR VPWR sky130_fd_sc_hd__decap_3
XTAP_TAPCELL_ROW_85_701 VGND VPWR sky130_fd_sc_hd__tapvpwrvgnd_1
XFILLER_19_78 VGND VGND VPWR VPWR sky130_fd_sc_hd__decap_3
XFILLER_35_66 VGND VGND VPWR VPWR sky130_fd_sc_hd__decap_3
XFILLER_42_168 VGND VGND VPWR VPWR sky130_fd_sc_hd__decap_3
XFILLER_42_179 VGND VGND VPWR VPWR sky130_fd_sc_hd__decap_3
XFILLER_2_220 VGND VGND VPWR VPWR sky130_fd_sc_hd__decap_3
XFILLER_65_205 VGND VGND VPWR VPWR sky130_fd_sc_hd__decap_3
XFILLER_65_238 VGND VGND VPWR VPWR sky130_fd_sc_hd__decap_3
XFILLER_80_208 VGND VGND VPWR VPWR sky130_fd_sc_hd__fill_2
XFILLER_33_113 VGND VGND VPWR VPWR sky130_fd_sc_hd__decap_3
XFILLER_33_146 VGND VGND VPWR VPWR sky130_fd_sc_hd__decap_3
X_1951_ net761 net669 VGND VGND VPWR VPWR Inst_SimpleCLB_ConfigMem.Inst_frame6_bit26.Q
+ sky130_fd_sc_hd__dlxtp_1
X_0902_ _0608_ _0609_ _0618_ _0617_ Inst_SimpleCLB_ConfigMem.Inst_frame10_bit22.Q
+ Inst_SimpleCLB_ConfigMem.Inst_frame10_bit23.Q VGND VGND VPWR VPWR _0727_ sky130_fd_sc_hd__mux4_2
XFILLER_41_190 VGND VGND VPWR VPWR sky130_fd_sc_hd__decap_3
X_1882_ net770 net660 VGND VGND VPWR VPWR Inst_SimpleCLB_ConfigMem.Inst_frame8_bit21.Q
+ sky130_fd_sc_hd__dlxtp_1
X_0833_ net653 N2END[4] E1END[2] E2END[4] Inst_SimpleCLB_ConfigMem.Inst_frame2_bit6.Q
+ Inst_SimpleCLB_ConfigMem.Inst_frame2_bit7.Q VGND VGND VPWR VPWR _0664_ sky130_fd_sc_hd__mux4_1
XPHY_EDGE_ROW_78_Left_169 VGND VGND VPWR VPWR sky130_fd_sc_hd__decap_3
X_0764_ net639 VGND VGND VPWR VPWR _0600_ sky130_fd_sc_hd__inv_2
X_2365_ Inst_SimpleCLB_switch_matrix.W1BEG3 VGND VGND VPWR VPWR net210 sky130_fd_sc_hd__buf_1
X_1316_ net644 net639 net302 net618 Inst_SimpleCLB_ConfigMem.Inst_frame10_bit6.Q Inst_SimpleCLB_ConfigMem.Inst_frame10_bit7.Q
+ VGND VGND VPWR VPWR _0391_ sky130_fd_sc_hd__mux4_1
XPHY_EDGE_ROW_87_Left_178 VGND VGND VPWR VPWR sky130_fd_sc_hd__decap_3
X_2296_ NN4END[7] VGND VGND VPWR VPWR net147 sky130_fd_sc_hd__buf_1
XTAP_TAPCELL_ROW_39_425 VGND VPWR sky130_fd_sc_hd__tapvpwrvgnd_1
X_1247_ _0330_ _0327_ _0325_ VGND VGND VPWR VPWR _0331_ sky130_fd_sc_hd__mux2_4
XFILLER_49_290 VGND VGND VPWR VPWR sky130_fd_sc_hd__decap_3
XFILLER_56_249 VGND VGND VPWR VPWR sky130_fd_sc_hd__decap_3
X_1178_ _0264_ VGND VGND VPWR VPWR _0265_ sky130_fd_sc_hd__inv_2
XTAP_TAPCELL_ROW_22_325 VGND VPWR sky130_fd_sc_hd__tapvpwrvgnd_1
XFILLER_24_179 VGND VGND VPWR VPWR sky130_fd_sc_hd__decap_3
XANTENNA_20 EE4END[3] VGND VGND VPWR VPWR sky130_fd_sc_hd__diode_2
XANTENNA_31 FrameData[16] VGND VGND VPWR VPWR sky130_fd_sc_hd__diode_2
XANTENNA_64 N2MID[2] VGND VGND VPWR VPWR sky130_fd_sc_hd__diode_2
XANTENNA_75 N4END[6] VGND VGND VPWR VPWR sky130_fd_sc_hd__diode_2
XANTENNA_53 FrameStrobe[2] VGND VGND VPWR VPWR sky130_fd_sc_hd__diode_2
XANTENNA_42 net53 VGND VGND VPWR VPWR sky130_fd_sc_hd__diode_2
XANTENNA_97 S1END[0] VGND VGND VPWR VPWR sky130_fd_sc_hd__diode_2
XANTENNA_86 NN4END[1] VGND VGND VPWR VPWR sky130_fd_sc_hd__diode_2
Xoutput160 net160 VGND VGND VPWR VPWR S2BEG[2] sky130_fd_sc_hd__buf_4
Xoutput171 net171 VGND VGND VPWR VPWR S2BEGb[5] sky130_fd_sc_hd__buf_2
Xoutput182 net182 VGND VGND VPWR VPWR S4BEG[2] sky130_fd_sc_hd__buf_2
Xoutput193 net193 VGND VGND VPWR VPWR SS4BEG[12] sky130_fd_sc_hd__buf_4
XFILLER_47_216 VGND VGND VPWR VPWR sky130_fd_sc_hd__decap_3
XFILLER_46_21 VGND VGND VPWR VPWR sky130_fd_sc_hd__decap_3
XFILLER_46_32 VGND VGND VPWR VPWR sky130_fd_sc_hd__decap_3
XFILLER_62_219 VGND VGND VPWR VPWR sky130_fd_sc_hd__fill_1
XFILLER_15_157 VGND VGND VPWR VPWR sky130_fd_sc_hd__decap_3
XFILLER_62_53 VGND VGND VPWR VPWR sky130_fd_sc_hd__decap_3
XFILLER_70_285 VGND VGND VPWR VPWR sky130_fd_sc_hd__fill_1
XFILLER_30_138 VGND VGND VPWR VPWR sky130_fd_sc_hd__fill_2
XFILLER_7_15 VGND VGND VPWR VPWR sky130_fd_sc_hd__decap_3
XFILLER_7_334 VGND VGND VPWR VPWR sky130_fd_sc_hd__fill_2
XFILLER_7_48 VGND VGND VPWR VPWR sky130_fd_sc_hd__decap_3
XFILLER_87_72 VGND VGND VPWR VPWR sky130_fd_sc_hd__fill_1
X_2150_ clknet_1_0__leaf_UserCLK_regs _0001_ VGND VGND VPWR VPWR Inst_LA_LUT4c_frame_config_dffesr.LUT_flop
+ sky130_fd_sc_hd__dfxtp_1
X_2081_ net756 net684 VGND VGND VPWR VPWR Inst_SimpleCLB_ConfigMem.Inst_frame2_bit28.Q
+ sky130_fd_sc_hd__dlxtp_1
X_1101_ Inst_LF_LUT4c_frame_config_dffesr.inst_cus_mux161_buf.A1 _0166_ _0167_ VGND
+ VGND VPWR VPWR _0193_ sky130_fd_sc_hd__or3_1
XTAP_TAPCELL_ROW_36_406 VGND VPWR sky130_fd_sc_hd__tapvpwrvgnd_1
X_1032_ N4END[3] W2END[3] E2END[3] Inst_SimpleCLB_switch_matrix.JN2BEG3 Inst_SimpleCLB_ConfigMem.Inst_frame0_bit11.Q
+ Inst_SimpleCLB_ConfigMem.Inst_frame0_bit10.Q VGND VGND VPWR VPWR _0127_ sky130_fd_sc_hd__mux4_1
XFILLER_46_271 VGND VGND VPWR VPWR sky130_fd_sc_hd__decap_3
XFILLER_21_116 VGND VGND VPWR VPWR sky130_fd_sc_hd__fill_2
XFILLER_14_190 VGND VGND VPWR VPWR sky130_fd_sc_hd__decap_3
X_1934_ net734 net667 VGND VGND VPWR VPWR Inst_SimpleCLB_ConfigMem.Inst_frame6_bit9.Q
+ sky130_fd_sc_hd__dlxtp_1
X_1865_ net744 net662 VGND VGND VPWR VPWR Inst_SimpleCLB_ConfigMem.Inst_frame8_bit4.Q
+ sky130_fd_sc_hd__dlxtp_1
X_0816_ _0647_ Ci Inst_LA_LUT4c_frame_config_dffesr.c_I0mux VGND VGND VPWR VPWR _0648_
+ sky130_fd_sc_hd__mux2_4
X_1796_ net748 net722 VGND VGND VPWR VPWR Inst_SimpleCLB_ConfigMem.Inst_frame11_bit31.Q
+ sky130_fd_sc_hd__dlxtp_1
X_0747_ Inst_SimpleCLB_ConfigMem.Inst_frame1_bit25.Q VGND VGND VPWR VPWR _0583_ sky130_fd_sc_hd__inv_1
X_2348_ SS4END[7] VGND VGND VPWR VPWR net199 sky130_fd_sc_hd__buf_4
X_2279_ N4END[6] VGND VGND VPWR VPWR net130 sky130_fd_sc_hd__clkbuf_1
XFILLER_37_260 VGND VGND VPWR VPWR sky130_fd_sc_hd__decap_3
XFILLER_12_127 VGND VGND VPWR VPWR sky130_fd_sc_hd__decap_3
XFILLER_20_182 VGND VGND VPWR VPWR sky130_fd_sc_hd__decap_3
XFILLER_79_138 VGND VGND VPWR VPWR sky130_fd_sc_hd__decap_3
XFILLER_35_219 VGND VGND VPWR VPWR sky130_fd_sc_hd__decap_3
XFILLER_90_325 VGND VGND VPWR VPWR sky130_fd_sc_hd__decap_3
XFILLER_28_293 VGND VGND VPWR VPWR sky130_fd_sc_hd__decap_3
XFILLER_73_63 VGND VGND VPWR VPWR sky130_fd_sc_hd__decap_3
XFILLER_43_263 VGND VGND VPWR VPWR sky130_fd_sc_hd__decap_3
XFILLER_85_8 VGND VGND VPWR VPWR sky130_fd_sc_hd__decap_3
XFILLER_11_193 VGND VGND VPWR VPWR sky130_fd_sc_hd__decap_3
XFILLER_7_175 VGND VGND VPWR VPWR sky130_fd_sc_hd__decap_3
X_1650_ net791 net703 VGND VGND VPWR VPWR Inst_LF_LUT4c_frame_config_dffesr.inst_cus_mux161_buf.A12
+ sky130_fd_sc_hd__dlxtp_1
X_1581_ net736 net695 VGND VGND VPWR VPWR Inst_LC_LUT4c_frame_config_dffesr.inst_cus_mux161_buf.A0
+ sky130_fd_sc_hd__dlxtp_1
XFILLER_21_3 VGND VGND VPWR VPWR sky130_fd_sc_hd__fill_1
X_2202_ Inst_SimpleCLB_switch_matrix.EE4BEG1 VGND VGND VPWR VPWR net38 sky130_fd_sc_hd__buf_6
X_2133_ net785 net729 VGND VGND VPWR VPWR Inst_SimpleCLB_ConfigMem.Inst_frame0_bit16.Q
+ sky130_fd_sc_hd__dlxtp_1
XFILLER_26_219 VGND VGND VPWR VPWR sky130_fd_sc_hd__fill_2
X_2064_ net794 net685 VGND VGND VPWR VPWR Inst_SimpleCLB_ConfigMem.Inst_frame2_bit11.Q
+ sky130_fd_sc_hd__dlxtp_1
X_1015_ Inst_LB_LUT4c_frame_config_dffesr.inst_cus_mux161_buf.A3 _0096_ _0111_ _0094_
+ VGND VGND VPWR VPWR _0112_ sky130_fd_sc_hd__o211a_1
X_1917_ net764 net663 VGND VGND VPWR VPWR Inst_SimpleCLB_ConfigMem.Inst_frame7_bit24.Q
+ sky130_fd_sc_hd__dlxtp_1
XFILLER_8_91 VGND VGND VPWR VPWR sky130_fd_sc_hd__decap_3
X_1848_ FrameData[19] net657 VGND VGND VPWR VPWR Inst_SimpleCLB_ConfigMem.Inst_frame9_bit19.Q
+ sky130_fd_sc_hd__dlxtp_1
X_1779_ net789 net722 VGND VGND VPWR VPWR Inst_SimpleCLB_ConfigMem.Inst_frame11_bit14.Q
+ sky130_fd_sc_hd__dlxtp_1
XFILLER_1_318 VGND VGND VPWR VPWR sky130_fd_sc_hd__decap_3
XFILLER_84_141 VGND VGND VPWR VPWR sky130_fd_sc_hd__decap_3
XTAP_TAPCELL_ROW_55_523 VGND VPWR sky130_fd_sc_hd__tapvpwrvgnd_1
XFILLER_40_233 VGND VGND VPWR VPWR sky130_fd_sc_hd__fill_1
XFILLER_43_88 VGND VGND VPWR VPWR sky130_fd_sc_hd__decap_3
Xclone10 net309 VGND VGND VPWR VPWR net264 sky130_fd_sc_hd__clkbuf_1
XFILLER_4_189 VGND VGND VPWR VPWR sky130_fd_sc_hd__decap_3
XFILLER_68_41 VGND VGND VPWR VPWR sky130_fd_sc_hd__decap_3
XFILLER_68_63 VGND VGND VPWR VPWR sky130_fd_sc_hd__decap_3
XFILLER_67_108 VGND VGND VPWR VPWR sky130_fd_sc_hd__decap_3
XFILLER_67_119 VGND VGND VPWR VPWR sky130_fd_sc_hd__fill_2
XFILLER_68_85 VGND VGND VPWR VPWR sky130_fd_sc_hd__fill_2
XTAP_TAPCELL_ROW_78_659 VGND VPWR sky130_fd_sc_hd__tapvpwrvgnd_1
XFILLER_31_211 VGND VGND VPWR VPWR sky130_fd_sc_hd__decap_3
XTAP_TAPCELL_ROW_61_559 VGND VPWR sky130_fd_sc_hd__tapvpwrvgnd_1
XFILLER_31_277 VGND VGND VPWR VPWR sky130_fd_sc_hd__decap_3
X_1702_ net777 net711 VGND VGND VPWR VPWR Inst_SimpleCLB_ConfigMem.Inst_frame13_bit1.Q
+ sky130_fd_sc_hd__dlxtp_1
X_1633_ net757 net699 VGND VGND VPWR VPWR Inst_LE_LUT4c_frame_config_dffesr.inst_cus_mux161_buf.A14
+ sky130_fd_sc_hd__dlxtp_1
XFILLER_69_3 VGND VGND VPWR VPWR sky130_fd_sc_hd__decap_3
X_1564_ net767 net691 VGND VGND VPWR VPWR Inst_LB_LUT4c_frame_config_dffesr.inst_cus_mux161_buf.A2
+ sky130_fd_sc_hd__dlxtp_1
X_1495_ _0524_ VGND VGND VPWR VPWR _0525_ sky130_fd_sc_hd__inv_1
XFILLER_58_119 VGND VGND VPWR VPWR sky130_fd_sc_hd__decap_3
XTAP_TAPCELL_ROW_69_604 VGND VPWR sky130_fd_sc_hd__tapvpwrvgnd_1
XFILLER_66_141 VGND VGND VPWR VPWR sky130_fd_sc_hd__decap_3
X_2116_ net747 net687 VGND VGND VPWR VPWR Inst_SimpleCLB_ConfigMem.Inst_frame1_bit31.Q
+ sky130_fd_sc_hd__dlxtp_1
XFILLER_66_185 VGND VGND VPWR VPWR sky130_fd_sc_hd__decap_3
XFILLER_81_111 VGND VGND VPWR VPWR sky130_fd_sc_hd__fill_1
X_2047_ net760 net679 VGND VGND VPWR VPWR Inst_SimpleCLB_ConfigMem.Inst_frame3_bit26.Q
+ sky130_fd_sc_hd__dlxtp_1
XFILLER_22_200 VGND VGND VPWR VPWR sky130_fd_sc_hd__decap_3
XTAP_TAPCELL_ROW_52_504 VGND VPWR sky130_fd_sc_hd__tapvpwrvgnd_1
XFILLER_81_199 VGND VGND VPWR VPWR sky130_fd_sc_hd__decap_3
XFILLER_22_233 VGND VGND VPWR VPWR sky130_fd_sc_hd__decap_3
XTAP_TAPCELL_ROW_17_291 VGND VPWR sky130_fd_sc_hd__tapvpwrvgnd_1
XFILLER_49_119 VGND VGND VPWR VPWR sky130_fd_sc_hd__decap_3
XFILLER_38_66 VGND VGND VPWR VPWR sky130_fd_sc_hd__decap_3
XFILLER_38_88 VGND VGND VPWR VPWR sky130_fd_sc_hd__fill_2
XFILLER_57_196 VGND VGND VPWR VPWR sky130_fd_sc_hd__decap_3
XFILLER_54_32 VGND VGND VPWR VPWR sky130_fd_sc_hd__decap_3
XFILLER_72_144 VGND VGND VPWR VPWR sky130_fd_sc_hd__fill_1
XFILLER_54_65 VGND VGND VPWR VPWR sky130_fd_sc_hd__decap_3
XTAP_TAPCELL_ROW_0_192 VGND VPWR sky130_fd_sc_hd__tapvpwrvgnd_1
XFILLER_9_237 VGND VGND VPWR VPWR sky130_fd_sc_hd__fill_2
XFILLER_79_51 VGND VGND VPWR VPWR sky130_fd_sc_hd__decap_3
X_1280_ _0355_ _0356_ _0359_ _0589_ VGND VGND VPWR VPWR Inst_SimpleCLB_switch_matrix.JS2BEG0
+ sky130_fd_sc_hd__a22o_1
XFILLER_63_111 VGND VGND VPWR VPWR sky130_fd_sc_hd__fill_1
XFILLER_63_122 VGND VGND VPWR VPWR sky130_fd_sc_hd__fill_2
XTAP_TAPCELL_ROW_14_272 VGND VPWR sky130_fd_sc_hd__tapvpwrvgnd_1
X_0995_ _0578_ _0679_ VGND VGND VPWR VPWR _0092_ sky130_fd_sc_hd__nor2_1
X_1616_ net795 net698 VGND VGND VPWR VPWR Inst_LD_LUT4c_frame_config_dffesr.c_out_mux
+ sky130_fd_sc_hd__dlxtp_1
XFILLER_86_214 VGND VGND VPWR VPWR sky130_fd_sc_hd__decap_3
X_1547_ net739 net692 VGND VGND VPWR VPWR Inst_LA_LUT4c_frame_config_dffesr.inst_cus_mux161_buf.A4
+ sky130_fd_sc_hd__dlxtp_1
XTAP_TAPCELL_ROW_6_229 VGND VPWR sky130_fd_sc_hd__tapvpwrvgnd_1
X_1478_ net613 _0669_ Inst_SimpleCLB_switch_matrix.JN2BEG2 _0644_ Inst_SimpleCLB_ConfigMem.Inst_frame13_bit28.Q
+ Inst_SimpleCLB_ConfigMem.Inst_frame13_bit29.Q VGND VGND VPWR VPWR Inst_SimpleCLB_switch_matrix.E1BEG3
+ sky130_fd_sc_hd__mux4_2
XFILLER_39_163 VGND VGND VPWR VPWR sky130_fd_sc_hd__decap_3
XFILLER_54_188 VGND VGND VPWR VPWR sky130_fd_sc_hd__decap_3
XFILLER_24_57 VGND VGND VPWR VPWR sky130_fd_sc_hd__decap_3
XFILLER_10_203 VGND VGND VPWR VPWR sky130_fd_sc_hd__decap_3
XFILLER_6_218 VGND VGND VPWR VPWR sky130_fd_sc_hd__decap_3
XFILLER_40_56 VGND VGND VPWR VPWR sky130_fd_sc_hd__decap_3
XFILLER_49_21 VGND VGND VPWR VPWR sky130_fd_sc_hd__decap_3
XTAP_TAPCELL_ROW_88_721 VGND VPWR sky130_fd_sc_hd__tapvpwrvgnd_1
Xfanout750 FrameData[30] VGND VGND VPWR VPWR net750 sky130_fd_sc_hd__buf_4
XFILLER_49_76 VGND VGND VPWR VPWR sky130_fd_sc_hd__decap_3
Xfanout794 net795 VGND VGND VPWR VPWR net794 sky130_fd_sc_hd__clkbuf_4
Xfanout783 FrameData[17] VGND VGND VPWR VPWR net783 sky130_fd_sc_hd__buf_4
Xfanout772 FrameData[21] VGND VGND VPWR VPWR net772 sky130_fd_sc_hd__buf_2
Xfanout761 FrameData[26] VGND VGND VPWR VPWR net761 sky130_fd_sc_hd__clkbuf_4
XFILLER_18_325 VGND VGND VPWR VPWR sky130_fd_sc_hd__decap_3
XFILLER_45_100 VGND VGND VPWR VPWR sky130_fd_sc_hd__decap_3
XFILLER_65_53 VGND VGND VPWR VPWR sky130_fd_sc_hd__decap_3
XANTENNA_132 W2END[2] VGND VGND VPWR VPWR sky130_fd_sc_hd__diode_2
XANTENNA_110 S4END[0] VGND VGND VPWR VPWR sky130_fd_sc_hd__diode_2
XANTENNA_121 SS4END[1] VGND VGND VPWR VPWR sky130_fd_sc_hd__diode_2
XANTENNA_143 W6END[1] VGND VGND VPWR VPWR sky130_fd_sc_hd__diode_2
XFILLER_45_155 VGND VGND VPWR VPWR sky130_fd_sc_hd__fill_1
XFILLER_60_103 VGND VGND VPWR VPWR sky130_fd_sc_hd__decap_3
XANTENNA_176 net767 VGND VGND VPWR VPWR sky130_fd_sc_hd__diode_2
XANTENNA_165 net647 VGND VGND VPWR VPWR sky130_fd_sc_hd__diode_2
XANTENNA_154 WW4END[1] VGND VGND VPWR VPWR sky130_fd_sc_hd__diode_2
XANTENNA_198 NN4END[8] VGND VGND VPWR VPWR sky130_fd_sc_hd__diode_2
XANTENNA_187 EE4END[0] VGND VGND VPWR VPWR sky130_fd_sc_hd__diode_2
XFILLER_81_85 VGND VGND VPWR VPWR sky130_fd_sc_hd__decap_3
X_0780_ E2END[2] S2END[2] net801 W2END[2] Inst_SimpleCLB_ConfigMem.Inst_frame4_bit31.Q
+ Inst_SimpleCLB_ConfigMem.Inst_frame4_bit30.Q VGND VGND VPWR VPWR _0615_ sky130_fd_sc_hd__mux4_1
XFILLER_5_240 VGND VGND VPWR VPWR sky130_fd_sc_hd__decap_3
X_1401_ Inst_SimpleCLB_ConfigMem.Inst_frame12_bit10.Q _0600_ _0464_ Inst_SimpleCLB_ConfigMem.Inst_frame12_bit11.Q
+ VGND VGND VPWR VPWR _0465_ sky130_fd_sc_hd__a211o_1
X_2381_ W2MID[7] VGND VGND VPWR VPWR net226 sky130_fd_sc_hd__clkbuf_2
XFILLER_68_203 VGND VGND VPWR VPWR sky130_fd_sc_hd__decap_3
X_1332_ Inst_SimpleCLB_ConfigMem.Inst_frame10_bit3.Q _0403_ _0405_ Inst_SimpleCLB_ConfigMem.Inst_frame10_bit4.Q
+ VGND VGND VPWR VPWR _0406_ sky130_fd_sc_hd__o211a_1
X_1263_ _0343_ _0344_ Inst_SimpleCLB_ConfigMem.Inst_frame2_bit28.Q VGND VGND VPWR
+ VPWR _0345_ sky130_fd_sc_hd__mux2_1
XFILLER_83_228 VGND VGND VPWR VPWR sky130_fd_sc_hd__decap_3
X_1194_ _0277_ _0278_ _0279_ VGND VGND VPWR VPWR _0280_ sky130_fd_sc_hd__and3_1
XFILLER_76_280 VGND VGND VPWR VPWR sky130_fd_sc_hd__fill_1
XFILLER_24_306 VGND VGND VPWR VPWR sky130_fd_sc_hd__fill_2
XFILLER_51_169 VGND VGND VPWR VPWR sky130_fd_sc_hd__decap_3
X_0978_ N2MID[1] E2MID[1] S2MID[1] W2MID[1] Inst_SimpleCLB_ConfigMem.Inst_frame6_bit8.Q
+ Inst_SimpleCLB_ConfigMem.Inst_frame6_bit9.Q VGND VGND VPWR VPWR _0076_ sky130_fd_sc_hd__mux4_2
XFILLER_10_48 VGND VGND VPWR VPWR sky130_fd_sc_hd__decap_3
XFILLER_59_214 VGND VGND VPWR VPWR sky130_fd_sc_hd__fill_1
XFILLER_59_225 VGND VGND VPWR VPWR sky130_fd_sc_hd__fill_1
XTAP_TAPCELL_ROW_85_702 VGND VPWR sky130_fd_sc_hd__tapvpwrvgnd_1
XFILLER_59_247 VGND VGND VPWR VPWR sky130_fd_sc_hd__fill_1
XFILLER_74_217 VGND VGND VPWR VPWR sky130_fd_sc_hd__decap_3
XFILLER_27_111 VGND VGND VPWR VPWR sky130_fd_sc_hd__fill_1
XFILLER_27_122 VGND VGND VPWR VPWR sky130_fd_sc_hd__decap_3
XFILLER_82_261 VGND VGND VPWR VPWR sky130_fd_sc_hd__decap_3
XFILLER_42_103 VGND VGND VPWR VPWR sky130_fd_sc_hd__decap_3
XFILLER_35_78 VGND VGND VPWR VPWR sky130_fd_sc_hd__fill_1
XFILLER_50_180 VGND VGND VPWR VPWR sky130_fd_sc_hd__fill_2
XFILLER_51_55 VGND VGND VPWR VPWR sky130_fd_sc_hd__fill_1
XFILLER_51_99 VGND VGND VPWR VPWR sky130_fd_sc_hd__decap_3
XFILLER_65_217 VGND VGND VPWR VPWR sky130_fd_sc_hd__decap_3
XFILLER_76_85 VGND VGND VPWR VPWR sky130_fd_sc_hd__decap_3
XFILLER_18_144 VGND VGND VPWR VPWR sky130_fd_sc_hd__decap_3
XFILLER_33_103 VGND VGND VPWR VPWR sky130_fd_sc_hd__decap_3
XFILLER_33_125 VGND VGND VPWR VPWR sky130_fd_sc_hd__decap_3
XFILLER_33_158 VGND VGND VPWR VPWR sky130_fd_sc_hd__decap_3
X_1950_ net762 net667 VGND VGND VPWR VPWR Inst_SimpleCLB_ConfigMem.Inst_frame6_bit25.Q
+ sky130_fd_sc_hd__dlxtp_1
X_0901_ Inst_SimpleCLB_ConfigMem.Inst_frame10_bit31.Q _0725_ _0579_ VGND VGND VPWR
+ VPWR _0726_ sky130_fd_sc_hd__o21ai_1
X_1881_ net773 net660 VGND VGND VPWR VPWR Inst_SimpleCLB_ConfigMem.Inst_frame8_bit20.Q
+ sky130_fd_sc_hd__dlxtp_1
X_0832_ net801 S2END[4] S4END[0] W2END[4] Inst_SimpleCLB_ConfigMem.Inst_frame2_bit6.Q
+ Inst_SimpleCLB_ConfigMem.Inst_frame2_bit7.Q VGND VGND VPWR VPWR _0663_ sky130_fd_sc_hd__mux4_1
X_0763_ Inst_SimpleCLB_ConfigMem.Inst_frame12_bit16.Q VGND VGND VPWR VPWR _0599_ sky130_fd_sc_hd__inv_1
XFILLER_51_3 VGND VGND VPWR VPWR sky130_fd_sc_hd__fill_1
X_1315_ _0389_ _0388_ Inst_SimpleCLB_ConfigMem.Inst_frame10_bit8.Q VGND VGND VPWR
+ VPWR _0390_ sky130_fd_sc_hd__mux2_1
X_2295_ NN4END[6] VGND VGND VPWR VPWR net146 sky130_fd_sc_hd__clkbuf_1
XFILLER_2_60 VGND VGND VPWR VPWR sky130_fd_sc_hd__decap_3
XFILLER_2_71 VGND VGND VPWR VPWR sky130_fd_sc_hd__decap_3
X_1246_ _0328_ _0329_ _0320_ VGND VGND VPWR VPWR _0330_ sky130_fd_sc_hd__mux2_1
XTAP_TAPCELL_ROW_39_426 VGND VPWR sky130_fd_sc_hd__tapvpwrvgnd_1
X_1177_ N2END[1] S2END[1] EE4END[3] W2END[1] Inst_SimpleCLB_ConfigMem.Inst_frame5_bit25.Q
+ Inst_SimpleCLB_ConfigMem.Inst_frame5_bit24.Q VGND VGND VPWR VPWR _0264_ sky130_fd_sc_hd__mux4_2
XFILLER_64_250 VGND VGND VPWR VPWR sky130_fd_sc_hd__fill_2
XTAP_TAPCELL_ROW_47_470 VGND VPWR sky130_fd_sc_hd__tapvpwrvgnd_1
XFILLER_12_309 VGND VGND VPWR VPWR sky130_fd_sc_hd__fill_1
XFILLER_24_136 VGND VGND VPWR VPWR sky130_fd_sc_hd__decap_3
XANTENNA_10 E6END[7] VGND VGND VPWR VPWR sky130_fd_sc_hd__diode_2
XANTENNA_32 FrameData[17] VGND VGND VPWR VPWR sky130_fd_sc_hd__diode_2
XANTENNA_21 EE4END[4] VGND VGND VPWR VPWR sky130_fd_sc_hd__diode_2
XANTENNA_65 N2MID[2] VGND VGND VPWR VPWR sky130_fd_sc_hd__diode_2
XANTENNA_54 FrameStrobe[3] VGND VGND VPWR VPWR sky130_fd_sc_hd__diode_2
XANTENNA_43 net60 VGND VGND VPWR VPWR sky130_fd_sc_hd__diode_2
XANTENNA_76 N4END[7] VGND VGND VPWR VPWR sky130_fd_sc_hd__diode_2
XANTENNA_87 NN4END[1] VGND VGND VPWR VPWR sky130_fd_sc_hd__diode_2
XTAP_TAPCELL_ROW_30_370 VGND VPWR sky130_fd_sc_hd__tapvpwrvgnd_1
XANTENNA_98 S1END[2] VGND VGND VPWR VPWR sky130_fd_sc_hd__diode_2
Xoutput150 net150 VGND VGND VPWR VPWR NN4BEG[6] sky130_fd_sc_hd__buf_2
Xoutput161 net161 VGND VGND VPWR VPWR S2BEG[3] sky130_fd_sc_hd__buf_2
Xoutput183 net183 VGND VGND VPWR VPWR S4BEG[3] sky130_fd_sc_hd__buf_2
Xoutput172 net172 VGND VGND VPWR VPWR S2BEGb[6] sky130_fd_sc_hd__buf_2
Xoutput194 Inst_SimpleCLB_switch_matrix.SS4BEG1 VGND VGND VPWR VPWR SS4BEG[13] sky130_fd_sc_hd__buf_8
XFILLER_46_44 VGND VGND VPWR VPWR sky130_fd_sc_hd__decap_3
XFILLER_55_261 VGND VGND VPWR VPWR sky130_fd_sc_hd__decap_3
XFILLER_62_209 VGND VGND VPWR VPWR sky130_fd_sc_hd__fill_2
XFILLER_15_125 VGND VGND VPWR VPWR sky130_fd_sc_hd__decap_3
XFILLER_46_88 VGND VGND VPWR VPWR sky130_fd_sc_hd__decap_3
XFILLER_70_220 VGND VGND VPWR VPWR sky130_fd_sc_hd__fill_1
XFILLER_15_169 VGND VGND VPWR VPWR sky130_fd_sc_hd__fill_2
XFILLER_62_10 VGND VGND VPWR VPWR sky130_fd_sc_hd__fill_2
XFILLER_62_21 VGND VGND VPWR VPWR sky130_fd_sc_hd__decap_3
XFILLER_70_242 VGND VGND VPWR VPWR sky130_fd_sc_hd__decap_3
XFILLER_70_253 VGND VGND VPWR VPWR sky130_fd_sc_hd__fill_2
XFILLER_30_117 VGND VGND VPWR VPWR sky130_fd_sc_hd__decap_3
XFILLER_62_32 VGND VGND VPWR VPWR sky130_fd_sc_hd__decap_3
XFILLER_23_191 VGND VGND VPWR VPWR sky130_fd_sc_hd__decap_3
XFILLER_62_76 VGND VGND VPWR VPWR sky130_fd_sc_hd__decap_3
XFILLER_7_313 VGND VGND VPWR VPWR sky130_fd_sc_hd__decap_3
XFILLER_7_27 VGND VGND VPWR VPWR sky130_fd_sc_hd__decap_3
XFILLER_7_346 VGND VGND VPWR VPWR sky130_fd_sc_hd__fill_1
XFILLER_11_80 VGND VGND VPWR VPWR sky130_fd_sc_hd__fill_2
XFILLER_38_206 VGND VGND VPWR VPWR sky130_fd_sc_hd__decap_3
X_1100_ _0174_ _0191_ _0165_ VGND VGND VPWR VPWR _0192_ sky130_fd_sc_hd__mux2_1
XFILLER_38_239 VGND VGND VPWR VPWR sky130_fd_sc_hd__decap_3
X_2080_ net758 net684 VGND VGND VPWR VPWR Inst_SimpleCLB_ConfigMem.Inst_frame2_bit27.Q
+ sky130_fd_sc_hd__dlxtp_1
XTAP_TAPCELL_ROW_36_407 VGND VPWR sky130_fd_sc_hd__tapvpwrvgnd_1
XFILLER_46_250 VGND VGND VPWR VPWR sky130_fd_sc_hd__fill_2
X_1031_ N2MID[7] E2MID[7] S2MID[7] W2MID[7] Inst_SimpleCLB_ConfigMem.Inst_frame6_bit10.Q
+ Inst_SimpleCLB_ConfigMem.Inst_frame6_bit11.Q VGND VGND VPWR VPWR _0126_ sky130_fd_sc_hd__mux4_2
XFILLER_53_209 VGND VGND VPWR VPWR sky130_fd_sc_hd__decap_3
X_1933_ net736 net667 VGND VGND VPWR VPWR Inst_SimpleCLB_ConfigMem.Inst_frame6_bit8.Q
+ sky130_fd_sc_hd__dlxtp_1
X_1864_ net746 FrameStrobe[8] VGND VGND VPWR VPWR Inst_SimpleCLB_ConfigMem.Inst_frame8_bit3.Q
+ sky130_fd_sc_hd__dlxtp_1
X_0815_ _0634_ _0635_ _0646_ Inst_SimpleCLB_ConfigMem.Inst_frame10_bit11.Q VGND VGND
+ VPWR VPWR _0647_ sky130_fd_sc_hd__a22o_1
X_1795_ net749 net722 VGND VGND VPWR VPWR Inst_SimpleCLB_ConfigMem.Inst_frame11_bit30.Q
+ sky130_fd_sc_hd__dlxtp_1
X_0746_ Inst_SimpleCLB_ConfigMem.Inst_frame1_bit24.Q VGND VGND VPWR VPWR _0582_ sky130_fd_sc_hd__inv_1
X_2347_ SS4END[6] VGND VGND VPWR VPWR net198 sky130_fd_sc_hd__buf_4
X_2278_ N4END[5] VGND VGND VPWR VPWR net129 sky130_fd_sc_hd__clkbuf_1
XFILLER_29_239 VGND VGND VPWR VPWR sky130_fd_sc_hd__decap_3
XFILLER_44_209 VGND VGND VPWR VPWR sky130_fd_sc_hd__decap_3
X_1229_ _0313_ _0305_ VGND VGND VPWR VPWR _0314_ sky130_fd_sc_hd__nor2_1
XFILLER_37_272 VGND VGND VPWR VPWR sky130_fd_sc_hd__decap_3
XFILLER_12_106 VGND VGND VPWR VPWR sky130_fd_sc_hd__decap_3
XFILLER_12_139 VGND VGND VPWR VPWR sky130_fd_sc_hd__fill_1
XFILLER_32_68 VGND VGND VPWR VPWR sky130_fd_sc_hd__decap_3
XFILLER_20_194 VGND VGND VPWR VPWR sky130_fd_sc_hd__fill_2
XFILLER_4_305 VGND VGND VPWR VPWR sky130_fd_sc_hd__decap_3
XFILLER_75_345 VGND VGND VPWR VPWR sky130_fd_sc_hd__fill_2
XFILLER_57_98 VGND VGND VPWR VPWR sky130_fd_sc_hd__decap_3
XFILLER_90_337 VGND VGND VPWR VPWR sky130_fd_sc_hd__decap_3
XFILLER_43_220 VGND VGND VPWR VPWR sky130_fd_sc_hd__decap_3
XFILLER_43_242 VGND VGND VPWR VPWR sky130_fd_sc_hd__decap_3
XFILLER_11_172 VGND VGND VPWR VPWR sky130_fd_sc_hd__decap_3
XFILLER_7_165 VGND VGND VPWR VPWR sky130_fd_sc_hd__decap_3
X_1580_ net738 net697 VGND VGND VPWR VPWR Inst_LB_LUT4c_frame_config_dffesr.c_reset_value
+ sky130_fd_sc_hd__dlxtp_1
XFILLER_85_109 VGND VGND VPWR VPWR sky130_fd_sc_hd__decap_3
X_2201_ Inst_SimpleCLB_switch_matrix.EE4BEG0 VGND VGND VPWR VPWR net37 sky130_fd_sc_hd__buf_6
X_2132_ net787 net730 VGND VGND VPWR VPWR Inst_SimpleCLB_ConfigMem.Inst_frame0_bit15.Q
+ sky130_fd_sc_hd__dlxtp_1
X_2063_ net796 net685 VGND VGND VPWR VPWR Inst_SimpleCLB_ConfigMem.Inst_frame2_bit10.Q
+ sky130_fd_sc_hd__dlxtp_1
X_1014_ Inst_LB_LUT4c_frame_config_dffesr.inst_cus_mux161_buf.A1 _0009_ _0010_ Inst_LB_LUT4c_frame_config_dffesr.inst_cus_mux161_buf.A7
+ _0110_ VGND VGND VPWR VPWR _0111_ sky130_fd_sc_hd__o221a_1
X_1916_ net766 net665 VGND VGND VPWR VPWR Inst_SimpleCLB_ConfigMem.Inst_frame7_bit23.Q
+ sky130_fd_sc_hd__dlxtp_1
XFILLER_8_70 VGND VGND VPWR VPWR sky130_fd_sc_hd__decap_3
X_1847_ FrameData[18] net657 VGND VGND VPWR VPWR Inst_SimpleCLB_ConfigMem.Inst_frame9_bit18.Q
+ sky130_fd_sc_hd__dlxtp_1
X_1778_ net790 net721 VGND VGND VPWR VPWR Inst_SimpleCLB_ConfigMem.Inst_frame11_bit13.Q
+ sky130_fd_sc_hd__dlxtp_1
X_0729_ E1END[2] VGND VGND VPWR VPWR _0565_ sky130_fd_sc_hd__inv_2
XFILLER_84_153 VGND VGND VPWR VPWR sky130_fd_sc_hd__decap_3
XFILLER_72_326 VGND VGND VPWR VPWR sky130_fd_sc_hd__fill_1
XFILLER_25_220 VGND VGND VPWR VPWR sky130_fd_sc_hd__decap_3
XFILLER_25_231 VGND VGND VPWR VPWR sky130_fd_sc_hd__decap_3
XFILLER_43_12 VGND VGND VPWR VPWR sky130_fd_sc_hd__fill_2
XFILLER_40_256 VGND VGND VPWR VPWR sky130_fd_sc_hd__decap_3
XFILLER_0_330 VGND VGND VPWR VPWR sky130_fd_sc_hd__fill_2
XFILLER_48_301 VGND VGND VPWR VPWR sky130_fd_sc_hd__decap_3
XFILLER_68_75 VGND VGND VPWR VPWR sky130_fd_sc_hd__decap_3
XFILLER_84_41 VGND VGND VPWR VPWR sky130_fd_sc_hd__decap_3
XFILLER_75_153 VGND VGND VPWR VPWR sky130_fd_sc_hd__decap_3
XFILLER_63_326 VGND VGND VPWR VPWR sky130_fd_sc_hd__decap_3
XFILLER_63_337 VGND VGND VPWR VPWR sky130_fd_sc_hd__fill_1
XFILLER_84_85 VGND VGND VPWR VPWR sky130_fd_sc_hd__decap_3
XFILLER_16_242 VGND VGND VPWR VPWR sky130_fd_sc_hd__decap_3
XFILLER_90_178 VGND VGND VPWR VPWR sky130_fd_sc_hd__decap_3
XFILLER_16_253 VGND VGND VPWR VPWR sky130_fd_sc_hd__decap_3
X_1701_ net799 net711 VGND VGND VPWR VPWR Inst_SimpleCLB_ConfigMem.Inst_frame13_bit0.Q
+ sky130_fd_sc_hd__dlxtp_1
X_1632_ net759 net699 VGND VGND VPWR VPWR Inst_LE_LUT4c_frame_config_dffesr.inst_cus_mux161_buf.A13
+ sky130_fd_sc_hd__dlxtp_1
X_1563_ net769 net692 VGND VGND VPWR VPWR Inst_LB_LUT4c_frame_config_dffesr.inst_cus_mux161_buf.A1
+ sky130_fd_sc_hd__dlxtp_1
X_1494_ _0076_ _0185_ Inst_SimpleCLB_ConfigMem.Inst_frame0_bit29.Q VGND VGND VPWR
+ VPWR _0524_ sky130_fd_sc_hd__mux2_1
XTAP_TAPCELL_ROW_69_605 VGND VPWR sky130_fd_sc_hd__tapvpwrvgnd_1
XFILLER_39_323 VGND VGND VPWR VPWR sky130_fd_sc_hd__fill_1
X_2115_ net749 net687 VGND VGND VPWR VPWR Inst_SimpleCLB_ConfigMem.Inst_frame1_bit30.Q
+ sky130_fd_sc_hd__dlxtp_1
X_2046_ net762 net680 VGND VGND VPWR VPWR Inst_SimpleCLB_ConfigMem.Inst_frame3_bit25.Q
+ sky130_fd_sc_hd__dlxtp_1
XFILLER_66_197 VGND VGND VPWR VPWR sky130_fd_sc_hd__decap_3
XTAP_TAPCELL_ROW_52_505 VGND VPWR sky130_fd_sc_hd__tapvpwrvgnd_1
XTAP_TAPCELL_ROW_17_292 VGND VPWR sky130_fd_sc_hd__tapvpwrvgnd_1
XFILLER_22_245 VGND VGND VPWR VPWR sky130_fd_sc_hd__decap_3
XFILLER_22_256 VGND VGND VPWR VPWR sky130_fd_sc_hd__fill_1
XFILLER_89_201 VGND VGND VPWR VPWR sky130_fd_sc_hd__decap_3
XFILLER_89_256 VGND VGND VPWR VPWR sky130_fd_sc_hd__decap_3
XFILLER_89_278 VGND VGND VPWR VPWR sky130_fd_sc_hd__fill_2
XFILLER_49_109 VGND VGND VPWR VPWR sky130_fd_sc_hd__decap_3
XFILLER_38_45 VGND VGND VPWR VPWR sky130_fd_sc_hd__decap_3
XFILLER_38_78 VGND VGND VPWR VPWR sky130_fd_sc_hd__decap_3
XFILLER_54_44 VGND VGND VPWR VPWR sky130_fd_sc_hd__decap_3
XFILLER_13_234 VGND VGND VPWR VPWR sky130_fd_sc_hd__decap_3
XFILLER_13_212 VGND VGND VPWR VPWR sky130_fd_sc_hd__decap_3
XTAP_TAPCELL_ROW_0_182 VGND VPWR sky130_fd_sc_hd__tapvpwrvgnd_1
XTAP_TAPCELL_ROW_0_193 VGND VPWR sky130_fd_sc_hd__tapvpwrvgnd_1
XFILLER_9_216 VGND VGND VPWR VPWR sky130_fd_sc_hd__decap_3
XFILLER_13_278 VGND VGND VPWR VPWR sky130_fd_sc_hd__fill_2
XFILLER_70_32 VGND VGND VPWR VPWR sky130_fd_sc_hd__fill_1
XFILLER_79_63 VGND VGND VPWR VPWR sky130_fd_sc_hd__decap_3
XFILLER_48_9 VGND VGND VPWR VPWR sky130_fd_sc_hd__decap_3
XFILLER_48_153 VGND VGND VPWR VPWR sky130_fd_sc_hd__decap_3
XFILLER_48_197 VGND VGND VPWR VPWR sky130_fd_sc_hd__decap_3
XFILLER_63_145 VGND VGND VPWR VPWR sky130_fd_sc_hd__decap_3
XTAP_TAPCELL_ROW_14_273 VGND VPWR sky130_fd_sc_hd__tapvpwrvgnd_1
XFILLER_81_3 VGND VGND VPWR VPWR sky130_fd_sc_hd__decap_3
X_0994_ Inst_SimpleCLB_ConfigMem.Inst_frame10_bit27.Q _0089_ _0090_ VGND VGND VPWR
+ VPWR _0091_ sky130_fd_sc_hd__or3_1
X_1615_ net797 net698 VGND VGND VPWR VPWR Inst_LD_LUT4c_frame_config_dffesr.inst_cus_mux161_buf.A15
+ sky130_fd_sc_hd__dlxtp_1
X_1546_ net741 net693 VGND VGND VPWR VPWR Inst_LA_LUT4c_frame_config_dffesr.inst_cus_mux161_buf.A3
+ sky130_fd_sc_hd__dlxtp_1
X_1477_ net623 Inst_SimpleCLB_switch_matrix.E2BEG3 _0076_ net256 Inst_SimpleCLB_ConfigMem.Inst_frame12_bit19.Q
+ Inst_SimpleCLB_ConfigMem.Inst_frame12_bit18.Q VGND VGND VPWR VPWR Inst_SimpleCLB_switch_matrix.S1BEG0
+ sky130_fd_sc_hd__mux4_1
XPHY_EDGE_ROW_19_Left_110 VGND VGND VPWR VPWR sky130_fd_sc_hd__decap_3
XFILLER_54_156 VGND VGND VPWR VPWR sky130_fd_sc_hd__decap_3
X_2029_ net735 net680 VGND VGND VPWR VPWR Inst_SimpleCLB_ConfigMem.Inst_frame3_bit8.Q
+ sky130_fd_sc_hd__dlxtp_1
XFILLER_24_36 VGND VGND VPWR VPWR sky130_fd_sc_hd__decap_3
XFILLER_40_24 VGND VGND VPWR VPWR sky130_fd_sc_hd__decap_3
XFILLER_40_35 VGND VGND VPWR VPWR sky130_fd_sc_hd__decap_3
XFILLER_49_33 VGND VGND VPWR VPWR sky130_fd_sc_hd__decap_3
Xfanout751 net752 VGND VGND VPWR VPWR net751 sky130_fd_sc_hd__clkbuf_4
Xfanout740 FrameData[6] VGND VGND VPWR VPWR net740 sky130_fd_sc_hd__buf_4
Xfanout762 net763 VGND VGND VPWR VPWR net762 sky130_fd_sc_hd__clkbuf_4
Xfanout773 net775 VGND VGND VPWR VPWR net773 sky130_fd_sc_hd__buf_4
Xfanout784 net785 VGND VGND VPWR VPWR net784 sky130_fd_sc_hd__clkbuf_4
Xfanout795 FrameData[11] VGND VGND VPWR VPWR net795 sky130_fd_sc_hd__buf_4
XFILLER_85_281 VGND VGND VPWR VPWR sky130_fd_sc_hd__decap_3
XFILLER_18_337 VGND VGND VPWR VPWR sky130_fd_sc_hd__decap_3
XANTENNA_100 net169 VGND VGND VPWR VPWR sky130_fd_sc_hd__diode_2
XFILLER_45_145 VGND VGND VPWR VPWR sky130_fd_sc_hd__fill_2
XANTENNA_122 W1END[3] VGND VGND VPWR VPWR sky130_fd_sc_hd__diode_2
XANTENNA_111 S4END[12] VGND VGND VPWR VPWR sky130_fd_sc_hd__diode_2
XANTENNA_133 W2END[2] VGND VGND VPWR VPWR sky130_fd_sc_hd__diode_2
XFILLER_45_178 VGND VGND VPWR VPWR sky130_fd_sc_hd__decap_3
XANTENNA_155 WW4END[2] VGND VGND VPWR VPWR sky130_fd_sc_hd__diode_2
XANTENNA_144 W6END[1] VGND VGND VPWR VPWR sky130_fd_sc_hd__diode_2
XANTENNA_166 net745 VGND VGND VPWR VPWR sky130_fd_sc_hd__diode_2
XANTENNA_177 net767 VGND VGND VPWR VPWR sky130_fd_sc_hd__diode_2
XANTENNA_199 S1END[2] VGND VGND VPWR VPWR sky130_fd_sc_hd__diode_2
XANTENNA_188 FrameData[2] VGND VGND VPWR VPWR sky130_fd_sc_hd__diode_2
XFILLER_81_31 VGND VGND VPWR VPWR sky130_fd_sc_hd__fill_2
XTAP_TAPCELL_ROW_11_254 VGND VPWR sky130_fd_sc_hd__tapvpwrvgnd_1
XFILLER_5_252 VGND VGND VPWR VPWR sky130_fd_sc_hd__decap_3
X_1400_ Inst_SimpleCLB_ConfigMem.Inst_frame12_bit10.Q net643 VGND VGND VPWR VPWR _0464_
+ sky130_fd_sc_hd__nor2_1
X_2380_ W2MID[6] VGND VGND VPWR VPWR net225 sky130_fd_sc_hd__buf_1
XFILLER_68_215 VGND VGND VPWR VPWR sky130_fd_sc_hd__fill_1
X_1331_ Inst_SimpleCLB_ConfigMem.Inst_frame10_bit3.Q _0404_ VGND VGND VPWR VPWR _0405_
+ sky130_fd_sc_hd__nand2_1
X_1262_ net800 S4END[1] S2END[1] W2END[1] Inst_SimpleCLB_ConfigMem.Inst_frame2_bit27.Q
+ Inst_SimpleCLB_ConfigMem.Inst_frame2_bit26.Q VGND VGND VPWR VPWR _0344_ sky130_fd_sc_hd__mux4_1
XFILLER_68_248 VGND VGND VPWR VPWR sky130_fd_sc_hd__decap_3
X_1193_ Inst_LG_LUT4c_frame_config_dffesr.inst_cus_mux161_buf.A14 _0258_ _0260_ Inst_LG_LUT4c_frame_config_dffesr.inst_cus_mux161_buf.A8
+ VGND VGND VPWR VPWR _0279_ sky130_fd_sc_hd__o22a_1
X_0977_ N2MID[0] S2MID[0] W2MID[0] Inst_SimpleCLB_switch_matrix.JW2BEG4 Inst_SimpleCLB_ConfigMem.Inst_frame7_bit8.Q
+ Inst_SimpleCLB_ConfigMem.Inst_frame7_bit9.Q VGND VGND VPWR VPWR _0075_ sky130_fd_sc_hd__mux4_2
X_1529_ Inst_LD_LUT4c_frame_config_dffesr.c_reset_value _0331_ _0554_ VGND VGND VPWR
+ VPWR _0555_ sky130_fd_sc_hd__mux2_1
XTAP_TAPCELL_ROW_85_703 VGND VPWR sky130_fd_sc_hd__tapvpwrvgnd_1
XFILLER_19_69 VGND VGND VPWR VPWR sky130_fd_sc_hd__decap_3
XTAP_TAPCELL_ROW_2_200 VGND VPWR sky130_fd_sc_hd__tapvpwrvgnd_1
XFILLER_74_229 VGND VGND VPWR VPWR sky130_fd_sc_hd__fill_2
XFILLER_82_251 VGND VGND VPWR VPWR sky130_fd_sc_hd__fill_1
XFILLER_27_156 VGND VGND VPWR VPWR sky130_fd_sc_hd__decap_3
XFILLER_35_57 VGND VGND VPWR VPWR sky130_fd_sc_hd__decap_3
XFILLER_42_115 VGND VGND VPWR VPWR sky130_fd_sc_hd__decap_3
XFILLER_42_148 VGND VGND VPWR VPWR sky130_fd_sc_hd__fill_2
XPHY_EDGE_ROW_14_Right_14 VGND VGND VPWR VPWR sky130_fd_sc_hd__decap_3
XTAP_TAPCELL_ROW_33_390 VGND VPWR sky130_fd_sc_hd__tapvpwrvgnd_1
XFILLER_2_200 VGND VGND VPWR VPWR sky130_fd_sc_hd__decap_3
XPHY_EDGE_ROW_23_Right_23 VGND VGND VPWR VPWR sky130_fd_sc_hd__decap_3
XFILLER_18_123 VGND VGND VPWR VPWR sky130_fd_sc_hd__fill_2
XFILLER_76_97 VGND VGND VPWR VPWR sky130_fd_sc_hd__decap_3
XPHY_EDGE_ROW_32_Right_32 VGND VGND VPWR VPWR sky130_fd_sc_hd__decap_3
XFILLER_33_137 VGND VGND VPWR VPWR sky130_fd_sc_hd__decap_3
X_0900_ _0723_ _0724_ Inst_SimpleCLB_ConfigMem.Inst_frame10_bit30.Q VGND VGND VPWR
+ VPWR _0725_ sky130_fd_sc_hd__mux2_1
X_1880_ net778 net660 VGND VGND VPWR VPWR Inst_SimpleCLB_ConfigMem.Inst_frame8_bit19.Q
+ sky130_fd_sc_hd__dlxtp_1
XFILLER_41_181 VGND VGND VPWR VPWR sky130_fd_sc_hd__decap_3
X_0831_ _0573_ _0659_ Inst_SimpleCLB_ConfigMem.Inst_frame2_bit9.Q VGND VGND VPWR VPWR
+ _0662_ sky130_fd_sc_hd__o21a_1
X_0762_ Inst_SimpleCLB_ConfigMem.Inst_frame11_bit11.Q VGND VGND VPWR VPWR _0598_ sky130_fd_sc_hd__inv_2
XPHY_EDGE_ROW_41_Right_41 VGND VGND VPWR VPWR sky130_fd_sc_hd__decap_3
XFILLER_44_3 VGND VGND VPWR VPWR sky130_fd_sc_hd__decap_3
X_2363_ Inst_SimpleCLB_switch_matrix.W1BEG1 VGND VGND VPWR VPWR net208 sky130_fd_sc_hd__buf_1
X_1314_ net624 net614 net633 net363 Inst_SimpleCLB_ConfigMem.Inst_frame10_bit7.Q Inst_SimpleCLB_ConfigMem.Inst_frame10_bit6.Q
+ VGND VGND VPWR VPWR _0389_ sky130_fd_sc_hd__mux4_1
X_2294_ NN4END[5] VGND VGND VPWR VPWR net145 sky130_fd_sc_hd__clkbuf_1
XFILLER_56_229 VGND VGND VPWR VPWR sky130_fd_sc_hd__fill_2
X_1245_ Inst_LD_LUT4c_frame_config_dffesr.inst_cus_mux161_buf.A0 Inst_LD_LUT4c_frame_config_dffesr.inst_cus_mux161_buf.A2
+ Inst_LD_LUT4c_frame_config_dffesr.inst_cus_mux161_buf.A4 Inst_LD_LUT4c_frame_config_dffesr.inst_cus_mux161_buf.A6
+ _0158_ _0159_ VGND VGND VPWR VPWR _0329_ sky130_fd_sc_hd__mux4_1
XTAP_TAPCELL_ROW_39_427 VGND VPWR sky130_fd_sc_hd__tapvpwrvgnd_1
XFILLER_49_270 VGND VGND VPWR VPWR sky130_fd_sc_hd__decap_3
XFILLER_49_281 VGND VGND VPWR VPWR sky130_fd_sc_hd__decap_3
X_1176_ _0262_ VGND VGND VPWR VPWR _0263_ sky130_fd_sc_hd__inv_1
XTAP_TAPCELL_ROW_47_471 VGND VPWR sky130_fd_sc_hd__tapvpwrvgnd_1
XPHY_EDGE_ROW_50_Right_50 VGND VGND VPWR VPWR sky130_fd_sc_hd__decap_3
Xclkbuf_1_1__f_UserCLK_regs clknet_0_UserCLK_regs VGND VGND VPWR VPWR clknet_1_1__leaf_UserCLK_regs
+ sky130_fd_sc_hd__clkbuf_16
XANTENNA_11 E6END[9] VGND VGND VPWR VPWR sky130_fd_sc_hd__diode_2
XANTENNA_22 EE4END[5] VGND VGND VPWR VPWR sky130_fd_sc_hd__diode_2
XFILLER_32_192 VGND VGND VPWR VPWR sky130_fd_sc_hd__decap_3
XANTENNA_66 N4END[10] VGND VGND VPWR VPWR sky130_fd_sc_hd__diode_2
XANTENNA_33 FrameData[17] VGND VGND VPWR VPWR sky130_fd_sc_hd__diode_2
XANTENNA_44 net66 VGND VGND VPWR VPWR sky130_fd_sc_hd__diode_2
XANTENNA_55 FrameStrobe[7] VGND VGND VPWR VPWR sky130_fd_sc_hd__diode_2
XANTENNA_88 NN4END[4] VGND VGND VPWR VPWR sky130_fd_sc_hd__diode_2
XANTENNA_77 N4END[8] VGND VGND VPWR VPWR sky130_fd_sc_hd__diode_2
XANTENNA_99 net158 VGND VGND VPWR VPWR sky130_fd_sc_hd__diode_2
XTAP_TAPCELL_ROW_30_371 VGND VPWR sky130_fd_sc_hd__tapvpwrvgnd_1
Xoutput151 net151 VGND VGND VPWR VPWR NN4BEG[7] sky130_fd_sc_hd__buf_2
Xoutput140 net140 VGND VGND VPWR VPWR NN4BEG[11] sky130_fd_sc_hd__buf_2
Xoutput173 net173 VGND VGND VPWR VPWR S2BEGb[7] sky130_fd_sc_hd__buf_2
Xoutput162 net162 VGND VGND VPWR VPWR S2BEG[4] sky130_fd_sc_hd__buf_4
Xoutput184 net184 VGND VGND VPWR VPWR S4BEG[4] sky130_fd_sc_hd__buf_2
Xoutput195 net195 VGND VGND VPWR VPWR SS4BEG[14] sky130_fd_sc_hd__buf_6
XFILLER_46_56 VGND VGND VPWR VPWR sky130_fd_sc_hd__decap_3
XFILLER_55_273 VGND VGND VPWR VPWR sky130_fd_sc_hd__decap_3
XFILLER_62_44 VGND VGND VPWR VPWR sky130_fd_sc_hd__decap_3
XFILLER_70_265 VGND VGND VPWR VPWR sky130_fd_sc_hd__fill_2
XFILLER_11_332 VGND VGND VPWR VPWR sky130_fd_sc_hd__decap_3
XFILLER_62_88 VGND VGND VPWR VPWR sky130_fd_sc_hd__fill_1
XFILLER_70_298 VGND VGND VPWR VPWR sky130_fd_sc_hd__decap_3
XFILLER_7_325 VGND VGND VPWR VPWR sky130_fd_sc_hd__decap_3
XFILLER_7_39 VGND VGND VPWR VPWR sky130_fd_sc_hd__decap_3
XFILLER_87_85 VGND VGND VPWR VPWR sky130_fd_sc_hd__decap_3
XFILLER_38_218 VGND VGND VPWR VPWR sky130_fd_sc_hd__decap_3
XTAP_TAPCELL_ROW_36_408 VGND VPWR sky130_fd_sc_hd__tapvpwrvgnd_1
X_1030_ N2MID[6] W2MID[6] E2MID[6] Inst_SimpleCLB_switch_matrix.JN2BEG5 Inst_SimpleCLB_ConfigMem.Inst_frame7_bit11.Q
+ Inst_SimpleCLB_ConfigMem.Inst_frame7_bit10.Q VGND VGND VPWR VPWR _0125_ sky130_fd_sc_hd__mux4_1
XFILLER_61_210 VGND VGND VPWR VPWR sky130_fd_sc_hd__decap_3
XTAP_TAPCELL_ROW_44_452 VGND VPWR sky130_fd_sc_hd__tapvpwrvgnd_1
X_1932_ net737 net668 VGND VGND VPWR VPWR Inst_SimpleCLB_ConfigMem.Inst_frame6_bit7.Q
+ sky130_fd_sc_hd__dlxtp_1
X_1863_ net752 FrameStrobe[8] VGND VGND VPWR VPWR Inst_SimpleCLB_ConfigMem.Inst_frame8_bit2.Q
+ sky130_fd_sc_hd__dlxtp_1
X_0814_ _0644_ _0645_ _0566_ VGND VGND VPWR VPWR _0646_ sky130_fd_sc_hd__mux2_1
X_1794_ net753 net722 VGND VGND VPWR VPWR Inst_SimpleCLB_ConfigMem.Inst_frame11_bit29.Q
+ sky130_fd_sc_hd__dlxtp_1
X_0745_ Inst_LG_LUT4c_frame_config_dffesr.c_I0mux VGND VGND VPWR VPWR _0581_ sky130_fd_sc_hd__inv_1
X_2346_ SS4END[5] VGND VGND VPWR VPWR net197 sky130_fd_sc_hd__buf_2
XFILLER_84_346 VGND VGND VPWR VPWR sky130_fd_sc_hd__fill_1
X_2277_ N4END[4] VGND VGND VPWR VPWR net122 sky130_fd_sc_hd__clkbuf_1
X_1228_ _0289_ _0308_ _0312_ _0300_ VGND VGND VPWR VPWR _0313_ sky130_fd_sc_hd__o211a_1
XFILLER_37_284 VGND VGND VPWR VPWR sky130_fd_sc_hd__fill_1
X_1159_ N2END[3] SS4END[0] E2END[3] W2END[3] Inst_SimpleCLB_ConfigMem.Inst_frame5_bit21.Q
+ Inst_SimpleCLB_ConfigMem.Inst_frame5_bit20.Q VGND VGND VPWR VPWR _0247_ sky130_fd_sc_hd__mux4_2
XFILLER_52_265 VGND VGND VPWR VPWR sky130_fd_sc_hd__fill_2
XFILLER_52_298 VGND VGND VPWR VPWR sky130_fd_sc_hd__fill_1
XFILLER_20_162 VGND VGND VPWR VPWR sky130_fd_sc_hd__decap_3
XTAP_TAPCELL_ROW_50_488 VGND VPWR sky130_fd_sc_hd__tapvpwrvgnd_1
XFILLER_79_129 VGND VGND VPWR VPWR sky130_fd_sc_hd__decap_3
XFILLER_90_305 VGND VGND VPWR VPWR sky130_fd_sc_hd__decap_3
XFILLER_28_251 VGND VGND VPWR VPWR sky130_fd_sc_hd__fill_1
XFILLER_43_254 VGND VGND VPWR VPWR sky130_fd_sc_hd__decap_3
XFILLER_43_287 VGND VGND VPWR VPWR sky130_fd_sc_hd__fill_1
XFILLER_11_162 VGND VGND VPWR VPWR sky130_fd_sc_hd__decap_3
XFILLER_7_122 VGND VGND VPWR VPWR sky130_fd_sc_hd__decap_3
XFILLER_7_100 VGND VGND VPWR VPWR sky130_fd_sc_hd__decap_3
XFILLER_11_184 VGND VGND VPWR VPWR sky130_fd_sc_hd__decap_3
X_2200_ EE4END[15] VGND VGND VPWR VPWR net36 sky130_fd_sc_hd__clkbuf_1
X_2131_ net789 net730 VGND VGND VPWR VPWR Inst_SimpleCLB_ConfigMem.Inst_frame0_bit14.Q
+ sky130_fd_sc_hd__dlxtp_1
XFILLER_78_195 VGND VGND VPWR VPWR sky130_fd_sc_hd__fill_1
X_2062_ net733 net683 VGND VGND VPWR VPWR Inst_SimpleCLB_ConfigMem.Inst_frame2_bit9.Q
+ sky130_fd_sc_hd__dlxtp_1
XFILLER_66_346 VGND VGND VPWR VPWR sky130_fd_sc_hd__fill_1
X_1013_ Inst_LB_LUT4c_frame_config_dffesr.inst_cus_mux161_buf.A5 _0097_ VGND VGND
+ VPWR VPWR _0110_ sky130_fd_sc_hd__or2_1
XFILLER_19_273 VGND VGND VPWR VPWR sky130_fd_sc_hd__decap_3
XFILLER_34_221 VGND VGND VPWR VPWR sky130_fd_sc_hd__fill_1
XFILLER_34_298 VGND VGND VPWR VPWR sky130_fd_sc_hd__fill_1
X_1915_ net768 net663 VGND VGND VPWR VPWR Inst_SimpleCLB_ConfigMem.Inst_frame7_bit22.Q
+ sky130_fd_sc_hd__dlxtp_1
XFILLER_8_82 VGND VGND VPWR VPWR sky130_fd_sc_hd__fill_2
X_1846_ net783 net655 VGND VGND VPWR VPWR Inst_SimpleCLB_ConfigMem.Inst_frame9_bit17.Q
+ sky130_fd_sc_hd__dlxtp_1
X_1777_ net793 net721 VGND VGND VPWR VPWR Inst_SimpleCLB_ConfigMem.Inst_frame11_bit12.Q
+ sky130_fd_sc_hd__dlxtp_1
XPHY_EDGE_ROW_4_Right_4 VGND VGND VPWR VPWR sky130_fd_sc_hd__decap_3
XFILLER_69_140 VGND VGND VPWR VPWR sky130_fd_sc_hd__decap_3
X_2329_ S4END[4] VGND VGND VPWR VPWR net174 sky130_fd_sc_hd__buf_4
XFILLER_84_121 VGND VGND VPWR VPWR sky130_fd_sc_hd__decap_3
XFILLER_57_346 VGND VGND VPWR VPWR sky130_fd_sc_hd__fill_1
XFILLER_84_165 VGND VGND VPWR VPWR sky130_fd_sc_hd__decap_3
XFILLER_27_69 VGND VGND VPWR VPWR sky130_fd_sc_hd__decap_3
XFILLER_25_243 VGND VGND VPWR VPWR sky130_fd_sc_hd__decap_3
XFILLER_25_276 VGND VGND VPWR VPWR sky130_fd_sc_hd__decap_3
XFILLER_43_79 VGND VGND VPWR VPWR sky130_fd_sc_hd__decap_3
XFILLER_4_114 VGND VGND VPWR VPWR sky130_fd_sc_hd__decap_3
XFILLER_4_147 VGND VGND VPWR VPWR sky130_fd_sc_hd__fill_1
XFILLER_4_158 VGND VGND VPWR VPWR sky130_fd_sc_hd__fill_1
XFILLER_4_29 VGND VGND VPWR VPWR sky130_fd_sc_hd__decap_3
XFILLER_68_21 VGND VGND VPWR VPWR sky130_fd_sc_hd__decap_3
XFILLER_68_32 VGND VGND VPWR VPWR sky130_fd_sc_hd__decap_3
XFILLER_68_54 VGND VGND VPWR VPWR sky130_fd_sc_hd__decap_3
XFILLER_75_110 VGND VGND VPWR VPWR sky130_fd_sc_hd__fill_2
XFILLER_75_165 VGND VGND VPWR VPWR sky130_fd_sc_hd__decap_3
XFILLER_16_265 VGND VGND VPWR VPWR sky130_fd_sc_hd__decap_3
XFILLER_31_202 VGND VGND VPWR VPWR sky130_fd_sc_hd__decap_3
X_1700_ net747 net710 VGND VGND VPWR VPWR Inst_SimpleCLB_ConfigMem.Inst_frame14_bit31.Q
+ sky130_fd_sc_hd__dlxtp_1
XFILLER_76_6 VGND VGND VPWR VPWR sky130_fd_sc_hd__decap_3
X_1631_ net761 net699 VGND VGND VPWR VPWR Inst_LE_LUT4c_frame_config_dffesr.inst_cus_mux161_buf.A12
+ sky130_fd_sc_hd__dlxtp_1
X_1562_ net772 net691 VGND VGND VPWR VPWR Inst_LB_LUT4c_frame_config_dffesr.inst_cus_mux161_buf.A0
+ sky130_fd_sc_hd__dlxtp_1
X_1493_ _0522_ VGND VGND VPWR VPWR _0523_ sky130_fd_sc_hd__inv_1
XTAP_TAPCELL_ROW_69_606 VGND VPWR sky130_fd_sc_hd__tapvpwrvgnd_1
X_2114_ net753 net688 VGND VGND VPWR VPWR Inst_SimpleCLB_ConfigMem.Inst_frame1_bit29.Q
+ sky130_fd_sc_hd__dlxtp_1
XTAP_TAPCELL_ROW_77_650 VGND VPWR sky130_fd_sc_hd__tapvpwrvgnd_1
XFILLER_54_305 VGND VGND VPWR VPWR sky130_fd_sc_hd__decap_3
XFILLER_66_176 VGND VGND VPWR VPWR sky130_fd_sc_hd__fill_1
XFILLER_81_102 VGND VGND VPWR VPWR sky130_fd_sc_hd__decap_3
XFILLER_81_113 VGND VGND VPWR VPWR sky130_fd_sc_hd__decap_3
X_2045_ net764 net680 VGND VGND VPWR VPWR Inst_SimpleCLB_ConfigMem.Inst_frame3_bit24.Q
+ sky130_fd_sc_hd__dlxtp_1
XFILLER_81_146 VGND VGND VPWR VPWR sky130_fd_sc_hd__fill_1
XTAP_TAPCELL_ROW_17_293 VGND VPWR sky130_fd_sc_hd__tapvpwrvgnd_1
XTAP_TAPCELL_ROW_60_550 VGND VPWR sky130_fd_sc_hd__tapvpwrvgnd_1
XFILLER_13_49 VGND VGND VPWR VPWR sky130_fd_sc_hd__decap_3
X_1829_ net799 net656 VGND VGND VPWR VPWR Inst_SimpleCLB_ConfigMem.Inst_frame9_bit0.Q
+ sky130_fd_sc_hd__dlxtp_1
XFILLER_89_235 VGND VGND VPWR VPWR sky130_fd_sc_hd__decap_3
XFILLER_57_110 VGND VGND VPWR VPWR sky130_fd_sc_hd__fill_2
XFILLER_38_57 VGND VGND VPWR VPWR sky130_fd_sc_hd__decap_3
XPHY_EDGE_ROW_79_Right_79 VGND VGND VPWR VPWR sky130_fd_sc_hd__decap_3
XFILLER_54_56 VGND VGND VPWR VPWR sky130_fd_sc_hd__decap_3
XTAP_TAPCELL_ROW_83_686 VGND VPWR sky130_fd_sc_hd__tapvpwrvgnd_1
XTAP_TAPCELL_ROW_0_183 VGND VPWR sky130_fd_sc_hd__tapvpwrvgnd_1
XPHY_EDGE_ROW_88_Right_88 VGND VGND VPWR VPWR sky130_fd_sc_hd__decap_3
XFILLER_70_88 VGND VGND VPWR VPWR sky130_fd_sc_hd__fill_1
XFILLER_70_99 VGND VGND VPWR VPWR sky130_fd_sc_hd__fill_2
XFILLER_79_42 VGND VGND VPWR VPWR sky130_fd_sc_hd__decap_3
XFILLER_48_165 VGND VGND VPWR VPWR sky130_fd_sc_hd__decap_3
XFILLER_63_102 VGND VGND VPWR VPWR sky130_fd_sc_hd__decap_3
XFILLER_48_187 VGND VGND VPWR VPWR sky130_fd_sc_hd__decap_3
XFILLER_63_113 VGND VGND VPWR VPWR sky130_fd_sc_hd__decap_3
XFILLER_63_157 VGND VGND VPWR VPWR sky130_fd_sc_hd__decap_3
X_0993_ _0578_ _0689_ VGND VGND VPWR VPWR _0090_ sky130_fd_sc_hd__nor2_1
XTAP_TAPCELL_ROW_14_274 VGND VPWR sky130_fd_sc_hd__tapvpwrvgnd_1
X_1614_ net733 net698 VGND VGND VPWR VPWR Inst_LD_LUT4c_frame_config_dffesr.inst_cus_mux161_buf.A14
+ sky130_fd_sc_hd__dlxtp_1
X_1545_ net743 net693 VGND VGND VPWR VPWR Inst_LA_LUT4c_frame_config_dffesr.inst_cus_mux161_buf.A2
+ sky130_fd_sc_hd__dlxtp_1
XFILLER_5_83 VGND VGND VPWR VPWR sky130_fd_sc_hd__decap_3
X_1476_ net304 _0126_ Inst_SimpleCLB_switch_matrix.E2BEG0 _0142_ Inst_SimpleCLB_ConfigMem.Inst_frame12_bit20.Q
+ Inst_SimpleCLB_ConfigMem.Inst_frame12_bit21.Q VGND VGND VPWR VPWR Inst_SimpleCLB_switch_matrix.S1BEG1
+ sky130_fd_sc_hd__mux4_1
XFILLER_39_154 VGND VGND VPWR VPWR sky130_fd_sc_hd__decap_3
XFILLER_39_187 VGND VGND VPWR VPWR sky130_fd_sc_hd__decap_3
XFILLER_54_113 VGND VGND VPWR VPWR sky130_fd_sc_hd__fill_2
XFILLER_54_135 VGND VGND VPWR VPWR sky130_fd_sc_hd__decap_3
X_2028_ net737 net679 VGND VGND VPWR VPWR Inst_SimpleCLB_ConfigMem.Inst_frame3_bit7.Q
+ sky130_fd_sc_hd__dlxtp_1
XFILLER_24_26 VGND VGND VPWR VPWR sky130_fd_sc_hd__fill_2
XFILLER_24_48 VGND VGND VPWR VPWR sky130_fd_sc_hd__decap_3
XFILLER_6_209 VGND VGND VPWR VPWR sky130_fd_sc_hd__decap_3
XFILLER_40_47 VGND VGND VPWR VPWR sky130_fd_sc_hd__decap_3
XFILLER_6_6 VGND VGND VPWR VPWR sky130_fd_sc_hd__decap_3
XFILLER_49_12 VGND VGND VPWR VPWR sky130_fd_sc_hd__decap_3
XTAP_TAPCELL_ROW_5_220 VGND VPWR sky130_fd_sc_hd__tapvpwrvgnd_1
Xfanout730 net732 VGND VGND VPWR VPWR net730 sky130_fd_sc_hd__buf_2
Xfanout741 FrameData[5] VGND VGND VPWR VPWR net741 sky130_fd_sc_hd__clkbuf_4
XFILLER_49_67 VGND VGND VPWR VPWR sky130_fd_sc_hd__decap_3
Xfanout774 net775 VGND VGND VPWR VPWR net774 sky130_fd_sc_hd__clkbuf_2
Xfanout785 FrameData[16] VGND VGND VPWR VPWR net785 sky130_fd_sc_hd__buf_4
Xfanout763 FrameData[25] VGND VGND VPWR VPWR net763 sky130_fd_sc_hd__buf_4
Xfanout752 FrameData[2] VGND VGND VPWR VPWR net752 sky130_fd_sc_hd__buf_4
Xfanout796 net797 VGND VGND VPWR VPWR net796 sky130_fd_sc_hd__clkbuf_4
XFILLER_18_305 VGND VGND VPWR VPWR sky130_fd_sc_hd__decap_3
XFILLER_45_113 VGND VGND VPWR VPWR sky130_fd_sc_hd__fill_2
XFILLER_65_44 VGND VGND VPWR VPWR sky130_fd_sc_hd__fill_1
XANTENNA_123 W1END[3] VGND VGND VPWR VPWR sky130_fd_sc_hd__diode_2
XANTENNA_101 net170 VGND VGND VPWR VPWR sky130_fd_sc_hd__diode_2
XANTENNA_134 W2END[6] VGND VGND VPWR VPWR sky130_fd_sc_hd__diode_2
XFILLER_65_88 VGND VGND VPWR VPWR sky130_fd_sc_hd__decap_3
XANTENNA_112 S4END[3] VGND VGND VPWR VPWR sky130_fd_sc_hd__diode_2
XANTENNA_167 net748 VGND VGND VPWR VPWR sky130_fd_sc_hd__diode_2
XANTENNA_156 WW4END[2] VGND VGND VPWR VPWR sky130_fd_sc_hd__diode_2
XANTENNA_145 W6END[1] VGND VGND VPWR VPWR sky130_fd_sc_hd__diode_2
XANTENNA_178 net770 VGND VGND VPWR VPWR sky130_fd_sc_hd__diode_2
XANTENNA_189 FrameData[2] VGND VGND VPWR VPWR sky130_fd_sc_hd__diode_2
XFILLER_81_54 VGND VGND VPWR VPWR sky130_fd_sc_hd__fill_2
XFILLER_14_81 VGND VGND VPWR VPWR sky130_fd_sc_hd__decap_3
XTAP_TAPCELL_ROW_11_255 VGND VPWR sky130_fd_sc_hd__tapvpwrvgnd_1
XFILLER_5_231 VGND VGND VPWR VPWR sky130_fd_sc_hd__decap_3
XFILLER_5_220 VGND VGND VPWR VPWR sky130_fd_sc_hd__decap_3
X_1330_ _0140_ net645 Inst_SimpleCLB_ConfigMem.Inst_frame10_bit2.Q VGND VGND VPWR
+ VPWR _0404_ sky130_fd_sc_hd__mux2_1
X_1261_ net652 N2END[1] net649 E2END[1] Inst_SimpleCLB_ConfigMem.Inst_frame2_bit27.Q
+ Inst_SimpleCLB_ConfigMem.Inst_frame2_bit26.Q VGND VGND VPWR VPWR _0343_ sky130_fd_sc_hd__mux4_1
X_1192_ Inst_LG_LUT4c_frame_config_dffesr.inst_cus_mux161_buf.A10 net263 _0257_ VGND
+ VGND VPWR VPWR _0278_ sky130_fd_sc_hd__or3b_1
XFILLER_76_271 VGND VGND VPWR VPWR sky130_fd_sc_hd__decap_3
XFILLER_24_319 VGND VGND VPWR VPWR sky130_fd_sc_hd__decap_3
XFILLER_36_179 VGND VGND VPWR VPWR sky130_fd_sc_hd__decap_3
XFILLER_51_105 VGND VGND VPWR VPWR sky130_fd_sc_hd__decap_3
XFILLER_44_190 VGND VGND VPWR VPWR sky130_fd_sc_hd__decap_3
X_0976_ _0074_ _0071_ Inst_SimpleCLB_ConfigMem.Inst_frame1_bit13.Q VGND VGND VPWR
+ VPWR Inst_SimpleCLB_switch_matrix.JW2BEG4 sky130_fd_sc_hd__mux2_4
X_1528_ Inst_SimpleCLB_ConfigMem.Inst_frame9_bit16.Q _0539_ VGND VGND VPWR VPWR _0554_
+ sky130_fd_sc_hd__nand2_1
XFILLER_59_205 VGND VGND VPWR VPWR sky130_fd_sc_hd__decap_3
X_1459_ _0514_ VGND VGND VPWR VPWR _0515_ sky130_fd_sc_hd__inv_1
XTAP_TAPCELL_ROW_2_201 VGND VPWR sky130_fd_sc_hd__tapvpwrvgnd_1
XFILLER_74_208 VGND VGND VPWR VPWR sky130_fd_sc_hd__decap_3
XFILLER_82_230 VGND VGND VPWR VPWR sky130_fd_sc_hd__decap_3
XFILLER_35_69 VGND VGND VPWR VPWR sky130_fd_sc_hd__decap_3
XFILLER_35_190 VGND VGND VPWR VPWR sky130_fd_sc_hd__decap_3
XTAP_TAPCELL_ROW_33_391 VGND VPWR sky130_fd_sc_hd__tapvpwrvgnd_1
XFILLER_51_57 VGND VGND VPWR VPWR sky130_fd_sc_hd__decap_3
XFILLER_4_3 VGND VGND VPWR VPWR sky130_fd_sc_hd__decap_3
XFILLER_76_21 VGND VGND VPWR VPWR sky130_fd_sc_hd__decap_3
XFILLER_76_32 VGND VGND VPWR VPWR sky130_fd_sc_hd__fill_2
XFILLER_65_208 VGND VGND VPWR VPWR sky130_fd_sc_hd__decap_3
XFILLER_58_282 VGND VGND VPWR VPWR sky130_fd_sc_hd__fill_1
XFILLER_33_116 VGND VGND VPWR VPWR sky130_fd_sc_hd__decap_3
XFILLER_33_149 VGND VGND VPWR VPWR sky130_fd_sc_hd__decap_3
XPHY_EDGE_ROW_38_Left_129 VGND VGND VPWR VPWR sky130_fd_sc_hd__decap_3
XFILLER_41_193 VGND VGND VPWR VPWR sky130_fd_sc_hd__decap_3
X_0830_ _0660_ Inst_SimpleCLB_ConfigMem.Inst_frame2_bit8.Q VGND VGND VPWR VPWR _0661_
+ sky130_fd_sc_hd__or2_4
X_0761_ Inst_SimpleCLB_ConfigMem.Inst_frame5_bit29.Q VGND VGND VPWR VPWR _0597_ sky130_fd_sc_hd__inv_1
XPHY_EDGE_ROW_47_Left_138 VGND VGND VPWR VPWR sky130_fd_sc_hd__decap_3
X_2362_ Inst_SimpleCLB_switch_matrix.W1BEG0 VGND VGND VPWR VPWR net207 sky130_fd_sc_hd__clkbuf_2
X_2293_ NN4END[4] VGND VGND VPWR VPWR net138 sky130_fd_sc_hd__clkbuf_1
X_1313_ _0667_ _0031_ _0151_ _0241_ Inst_SimpleCLB_ConfigMem.Inst_frame10_bit6.Q Inst_SimpleCLB_ConfigMem.Inst_frame10_bit7.Q
+ VGND VGND VPWR VPWR _0388_ sky130_fd_sc_hd__mux4_1
X_1244_ Inst_LD_LUT4c_frame_config_dffesr.inst_cus_mux161_buf.A1 Inst_LD_LUT4c_frame_config_dffesr.inst_cus_mux161_buf.A3
+ Inst_LD_LUT4c_frame_config_dffesr.inst_cus_mux161_buf.A5 Inst_LD_LUT4c_frame_config_dffesr.inst_cus_mux161_buf.A7
+ _0158_ _0159_ VGND VGND VPWR VPWR _0328_ sky130_fd_sc_hd__mux4_1
XFILLER_49_293 VGND VGND VPWR VPWR sky130_fd_sc_hd__decap_3
X_1175_ NN4END[0] W2END[0] net801 Inst_SimpleCLB_switch_matrix.JW2BEG4 Inst_SimpleCLB_ConfigMem.Inst_frame0_bit25.Q
+ Inst_SimpleCLB_ConfigMem.Inst_frame0_bit24.Q VGND VGND VPWR VPWR _0262_ sky130_fd_sc_hd__mux4_2
XFILLER_64_230 VGND VGND VPWR VPWR sky130_fd_sc_hd__decap_3
XTAP_TAPCELL_ROW_47_472 VGND VPWR sky130_fd_sc_hd__tapvpwrvgnd_1
XPHY_EDGE_ROW_56_Left_147 VGND VGND VPWR VPWR sky130_fd_sc_hd__decap_3
XFILLER_24_127 VGND VGND VPWR VPWR sky130_fd_sc_hd__decap_3
XANTENNA_12 EE4END[0] VGND VGND VPWR VPWR sky130_fd_sc_hd__diode_2
XANTENNA_23 EE4END[7] VGND VGND VPWR VPWR sky130_fd_sc_hd__diode_2
XFILLER_32_182 VGND VGND VPWR VPWR sky130_fd_sc_hd__decap_3
XANTENNA_56 net84 VGND VGND VPWR VPWR sky130_fd_sc_hd__diode_2
XANTENNA_34 FrameData[18] VGND VGND VPWR VPWR sky130_fd_sc_hd__diode_2
XANTENNA_45 net72 VGND VGND VPWR VPWR sky130_fd_sc_hd__diode_2
XANTENNA_89 NN4END[5] VGND VGND VPWR VPWR sky130_fd_sc_hd__diode_2
XANTENNA_67 N4END[11] VGND VGND VPWR VPWR sky130_fd_sc_hd__diode_2
XTAP_TAPCELL_ROW_30_372 VGND VPWR sky130_fd_sc_hd__tapvpwrvgnd_1
XANTENNA_78 N4END[9] VGND VGND VPWR VPWR sky130_fd_sc_hd__diode_2
X_0959_ Inst_LC_LUT4c_frame_config_dffesr.inst_cus_mux161_buf.A13 _0053_ _0054_ Inst_LC_LUT4c_frame_config_dffesr.inst_cus_mux161_buf.A11
+ _0058_ VGND VGND VPWR VPWR _0059_ sky130_fd_sc_hd__o221a_1
XPHY_EDGE_ROW_65_Left_156 VGND VGND VPWR VPWR sky130_fd_sc_hd__decap_3
Xoutput141 net141 VGND VGND VPWR VPWR NN4BEG[12] sky130_fd_sc_hd__buf_6
Xoutput152 net152 VGND VGND VPWR VPWR NN4BEG[8] sky130_fd_sc_hd__buf_2
Xoutput130 net130 VGND VGND VPWR VPWR N4BEG[2] sky130_fd_sc_hd__buf_2
Xoutput163 net163 VGND VGND VPWR VPWR S2BEG[5] sky130_fd_sc_hd__buf_8
Xoutput185 net185 VGND VGND VPWR VPWR S4BEG[5] sky130_fd_sc_hd__buf_2
Xoutput174 net174 VGND VGND VPWR VPWR S4BEG[0] sky130_fd_sc_hd__buf_2
Xoutput196 net196 VGND VGND VPWR VPWR SS4BEG[15] sky130_fd_sc_hd__buf_6
XFILLER_47_219 VGND VGND VPWR VPWR sky130_fd_sc_hd__decap_3
XFILLER_46_24 VGND VGND VPWR VPWR sky130_fd_sc_hd__decap_3
XFILLER_46_35 VGND VGND VPWR VPWR sky130_fd_sc_hd__decap_3
XPHY_EDGE_ROW_74_Left_165 VGND VGND VPWR VPWR sky130_fd_sc_hd__decap_3
XFILLER_15_138 VGND VGND VPWR VPWR sky130_fd_sc_hd__fill_1
XFILLER_70_233 VGND VGND VPWR VPWR sky130_fd_sc_hd__decap_3
XFILLER_23_182 VGND VGND VPWR VPWR sky130_fd_sc_hd__decap_3
XFILLER_62_56 VGND VGND VPWR VPWR sky130_fd_sc_hd__decap_3
XFILLER_7_18 VGND VGND VPWR VPWR sky130_fd_sc_hd__decap_3
XPHY_EDGE_ROW_83_Left_174 VGND VGND VPWR VPWR sky130_fd_sc_hd__decap_3
XFILLER_7_337 VGND VGND VPWR VPWR sky130_fd_sc_hd__decap_3
XFILLER_78_300 VGND VGND VPWR VPWR sky130_fd_sc_hd__fill_1
XFILLER_87_53 VGND VGND VPWR VPWR sky130_fd_sc_hd__decap_3
XFILLER_46_230 VGND VGND VPWR VPWR sky130_fd_sc_hd__fill_2
XTAP_TAPCELL_ROW_36_409 VGND VPWR sky130_fd_sc_hd__tapvpwrvgnd_1
XFILLER_46_274 VGND VGND VPWR VPWR sky130_fd_sc_hd__fill_2
XPHY_EDGE_ROW_1_Left_92 VGND VGND VPWR VPWR sky130_fd_sc_hd__decap_3
XFILLER_61_222 VGND VGND VPWR VPWR sky130_fd_sc_hd__fill_2
XTAP_TAPCELL_ROW_44_453 VGND VPWR sky130_fd_sc_hd__tapvpwrvgnd_1
XFILLER_61_277 VGND VGND VPWR VPWR sky130_fd_sc_hd__decap_3
X_1931_ net740 net668 VGND VGND VPWR VPWR Inst_SimpleCLB_ConfigMem.Inst_frame6_bit6.Q
+ sky130_fd_sc_hd__dlxtp_1
XFILLER_14_193 VGND VGND VPWR VPWR sky130_fd_sc_hd__decap_3
X_1862_ net777 net662 VGND VGND VPWR VPWR Inst_SimpleCLB_ConfigMem.Inst_frame8_bit1.Q
+ sky130_fd_sc_hd__dlxtp_1
X_0813_ N2END[6] SS4END[3] E2END[6] W2END[6] Inst_SimpleCLB_ConfigMem.Inst_frame6_bit27.Q
+ Inst_SimpleCLB_ConfigMem.Inst_frame6_bit26.Q VGND VGND VPWR VPWR _0645_ sky130_fd_sc_hd__mux4_2
X_1793_ net756 net722 VGND VGND VPWR VPWR Inst_SimpleCLB_ConfigMem.Inst_frame11_bit28.Q
+ sky130_fd_sc_hd__dlxtp_1
X_0744_ Inst_SimpleCLB_ConfigMem.Inst_frame8_bit6.Q VGND VGND VPWR VPWR _0580_ sky130_fd_sc_hd__inv_2
X_2345_ SS4END[4] VGND VGND VPWR VPWR net190 sky130_fd_sc_hd__buf_4
XFILLER_84_325 VGND VGND VPWR VPWR sky130_fd_sc_hd__fill_1
X_2276_ N2MID[7] VGND VGND VPWR VPWR net121 sky130_fd_sc_hd__clkbuf_2
X_1227_ _0286_ _0288_ _0311_ VGND VGND VPWR VPWR _0312_ sky130_fd_sc_hd__or3_1
XFILLER_37_263 VGND VGND VPWR VPWR sky130_fd_sc_hd__decap_3
X_1158_ N4END[2] W2END[2] SS4END[2] Inst_SimpleCLB_switch_matrix.E2BEG4 Inst_SimpleCLB_ConfigMem.Inst_frame0_bit21.Q
+ Inst_SimpleCLB_ConfigMem.Inst_frame0_bit20.Q VGND VGND VPWR VPWR _0246_ sky130_fd_sc_hd__mux4_2
XFILLER_52_200 VGND VGND VPWR VPWR sky130_fd_sc_hd__fill_1
XFILLER_16_27 VGND VGND VPWR VPWR sky130_fd_sc_hd__fill_1
X_1089_ net651 N2END[6] E1END[2] E2END[6] Inst_SimpleCLB_ConfigMem.Inst_frame1_bit14.Q
+ Inst_SimpleCLB_ConfigMem.Inst_frame1_bit15.Q VGND VGND VPWR VPWR _0182_ sky130_fd_sc_hd__mux4_1
XFILLER_20_141 VGND VGND VPWR VPWR sky130_fd_sc_hd__decap_3
XTAP_TAPCELL_ROW_50_489 VGND VPWR sky130_fd_sc_hd__tapvpwrvgnd_1
XFILLER_20_185 VGND VGND VPWR VPWR sky130_fd_sc_hd__decap_3
XFILLER_4_318 VGND VGND VPWR VPWR sky130_fd_sc_hd__fill_2
XFILLER_57_12 VGND VGND VPWR VPWR sky130_fd_sc_hd__decap_3
XFILLER_90_328 VGND VGND VPWR VPWR sky130_fd_sc_hd__fill_2
XFILLER_43_200 VGND VGND VPWR VPWR sky130_fd_sc_hd__decap_3
XFILLER_73_11 VGND VGND VPWR VPWR sky130_fd_sc_hd__decap_3
XFILLER_28_296 VGND VGND VPWR VPWR sky130_fd_sc_hd__decap_3
XFILLER_73_55 VGND VGND VPWR VPWR sky130_fd_sc_hd__fill_1
XFILLER_43_266 VGND VGND VPWR VPWR sky130_fd_sc_hd__fill_2
XFILLER_73_66 VGND VGND VPWR VPWR sky130_fd_sc_hd__decap_3
XTAP_TAPCELL_ROW_41_434 VGND VPWR sky130_fd_sc_hd__tapvpwrvgnd_1
XFILLER_11_196 VGND VGND VPWR VPWR sky130_fd_sc_hd__decap_3
XFILLER_7_178 VGND VGND VPWR VPWR sky130_fd_sc_hd__decap_3
XFILLER_78_141 VGND VGND VPWR VPWR sky130_fd_sc_hd__fill_2
X_2130_ net790 net729 VGND VGND VPWR VPWR Inst_SimpleCLB_ConfigMem.Inst_frame0_bit13.Q
+ sky130_fd_sc_hd__dlxtp_1
X_2061_ net735 net683 VGND VGND VPWR VPWR Inst_SimpleCLB_ConfigMem.Inst_frame2_bit8.Q
+ sky130_fd_sc_hd__dlxtp_1
X_1012_ _0100_ _0105_ _0108_ VGND VGND VPWR VPWR _0109_ sky130_fd_sc_hd__or3_4
X_1914_ net771 net666 VGND VGND VPWR VPWR Inst_SimpleCLB_ConfigMem.Inst_frame7_bit21.Q
+ sky130_fd_sc_hd__dlxtp_1
XFILLER_8_94 VGND VGND VPWR VPWR sky130_fd_sc_hd__decap_3
X_1845_ net785 net655 VGND VGND VPWR VPWR Inst_SimpleCLB_ConfigMem.Inst_frame9_bit16.Q
+ sky130_fd_sc_hd__dlxtp_1
X_1776_ net795 net721 VGND VGND VPWR VPWR Inst_SimpleCLB_ConfigMem.Inst_frame11_bit11.Q
+ sky130_fd_sc_hd__dlxtp_1
X_2328_ S2MID[7] VGND VGND VPWR VPWR net173 sky130_fd_sc_hd__clkbuf_2
XFILLER_69_163 VGND VGND VPWR VPWR sky130_fd_sc_hd__decap_3
XFILLER_84_144 VGND VGND VPWR VPWR sky130_fd_sc_hd__decap_3
XFILLER_69_196 VGND VGND VPWR VPWR sky130_fd_sc_hd__decap_3
X_2259_ Inst_SimpleCLB_switch_matrix.N1BEG2 VGND VGND VPWR VPWR net104 sky130_fd_sc_hd__buf_6
XFILLER_25_211 VGND VGND VPWR VPWR sky130_fd_sc_hd__decap_3
XTAP_TAPCELL_ROW_63_570 VGND VPWR sky130_fd_sc_hd__tapvpwrvgnd_1
Xclone13 Inst_LE_LUT4c_frame_config_dffesr.O VGND VGND VPWR VPWR net267 sky130_fd_sc_hd__buf_6
XFILLER_4_137 VGND VGND VPWR VPWR sky130_fd_sc_hd__decap_3
XFILLER_4_19 VGND VGND VPWR VPWR sky130_fd_sc_hd__decap_3
XFILLER_0_321 VGND VGND VPWR VPWR sky130_fd_sc_hd__decap_3
XFILLER_68_44 VGND VGND VPWR VPWR sky130_fd_sc_hd__fill_2
XFILLER_68_66 VGND VGND VPWR VPWR sky130_fd_sc_hd__decap_3
XFILLER_84_32 VGND VGND VPWR VPWR sky130_fd_sc_hd__decap_3
XFILLER_75_122 VGND VGND VPWR VPWR sky130_fd_sc_hd__decap_3
XFILLER_90_125 VGND VGND VPWR VPWR sky130_fd_sc_hd__fill_2
XFILLER_75_199 VGND VGND VPWR VPWR sky130_fd_sc_hd__decap_3
XFILLER_31_214 VGND VGND VPWR VPWR sky130_fd_sc_hd__decap_3
XFILLER_31_225 VGND VGND VPWR VPWR sky130_fd_sc_hd__decap_3
XFILLER_33_91 VGND VGND VPWR VPWR sky130_fd_sc_hd__decap_3
X_1630_ FrameData[25] net700 VGND VGND VPWR VPWR Inst_LE_LUT4c_frame_config_dffesr.inst_cus_mux161_buf.A11
+ sky130_fd_sc_hd__dlxtp_1
XFILLER_69_6 VGND VGND VPWR VPWR sky130_fd_sc_hd__decap_3
X_1561_ net775 net693 VGND VGND VPWR VPWR Inst_LA_LUT4c_frame_config_dffesr.c_reset_value
+ sky130_fd_sc_hd__dlxtp_1
XFILLER_3_181 VGND VGND VPWR VPWR sky130_fd_sc_hd__decap_3
X_1492_ net308 _0689_ Inst_SimpleCLB_ConfigMem.Inst_frame0_bit29.Q VGND VGND VPWR
+ VPWR _0522_ sky130_fd_sc_hd__mux2_1
XTAP_TAPCELL_ROW_69_607 VGND VPWR sky130_fd_sc_hd__tapvpwrvgnd_1
X_2113_ net756 net688 VGND VGND VPWR VPWR Inst_SimpleCLB_ConfigMem.Inst_frame1_bit28.Q
+ sky130_fd_sc_hd__dlxtp_1
XFILLER_66_144 VGND VGND VPWR VPWR sky130_fd_sc_hd__decap_3
XFILLER_54_317 VGND VGND VPWR VPWR sky130_fd_sc_hd__fill_1
XTAP_TAPCELL_ROW_77_651 VGND VPWR sky130_fd_sc_hd__tapvpwrvgnd_1
X_2044_ net767 net680 VGND VGND VPWR VPWR Inst_SimpleCLB_ConfigMem.Inst_frame3_bit23.Q
+ sky130_fd_sc_hd__dlxtp_1
XFILLER_66_188 VGND VGND VPWR VPWR sky130_fd_sc_hd__decap_3
XFILLER_22_203 VGND VGND VPWR VPWR sky130_fd_sc_hd__decap_3
XTAP_TAPCELL_ROW_17_294 VGND VPWR sky130_fd_sc_hd__tapvpwrvgnd_1
XFILLER_22_236 VGND VGND VPWR VPWR sky130_fd_sc_hd__decap_3
XTAP_TAPCELL_ROW_60_551 VGND VPWR sky130_fd_sc_hd__tapvpwrvgnd_1
XFILLER_30_280 VGND VGND VPWR VPWR sky130_fd_sc_hd__decap_3
X_1828_ net748 net727 VGND VGND VPWR VPWR Inst_SimpleCLB_ConfigMem.Inst_frame10_bit31.Q
+ sky130_fd_sc_hd__dlxtp_1
X_1759_ net760 net716 VGND VGND VPWR VPWR Inst_SimpleCLB_ConfigMem.Inst_frame12_bit26.Q
+ sky130_fd_sc_hd__dlxtp_1
XFILLER_38_69 VGND VGND VPWR VPWR sky130_fd_sc_hd__decap_3
XFILLER_57_122 VGND VGND VPWR VPWR sky130_fd_sc_hd__decap_3
XFILLER_57_166 VGND VGND VPWR VPWR sky130_fd_sc_hd__fill_2
XFILLER_57_199 VGND VGND VPWR VPWR sky130_fd_sc_hd__fill_1
XFILLER_54_35 VGND VGND VPWR VPWR sky130_fd_sc_hd__decap_3
XTAP_TAPCELL_ROW_83_687 VGND VPWR sky130_fd_sc_hd__tapvpwrvgnd_1
XFILLER_13_225 VGND VGND VPWR VPWR sky130_fd_sc_hd__decap_3
XTAP_TAPCELL_ROW_0_184 VGND VPWR sky130_fd_sc_hd__tapvpwrvgnd_1
XFILLER_54_68 VGND VGND VPWR VPWR sky130_fd_sc_hd__decap_3
XFILLER_13_258 VGND VGND VPWR VPWR sky130_fd_sc_hd__decap_3
XFILLER_70_12 VGND VGND VPWR VPWR sky130_fd_sc_hd__decap_3
XFILLER_79_54 VGND VGND VPWR VPWR sky130_fd_sc_hd__fill_2
XTAP_TAPCELL_ROW_8_240 VGND VPWR sky130_fd_sc_hd__tapvpwrvgnd_1
XFILLER_28_91 VGND VGND VPWR VPWR sky130_fd_sc_hd__fill_2
XTAP_TAPCELL_ROW_74_632 VGND VPWR sky130_fd_sc_hd__tapvpwrvgnd_1
X_0992_ Inst_SimpleCLB_ConfigMem.Inst_frame10_bit26.Q _0688_ VGND VGND VPWR VPWR _0089_
+ sky130_fd_sc_hd__nor2_1
XTAP_TAPCELL_ROW_14_275 VGND VPWR sky130_fd_sc_hd__tapvpwrvgnd_1
XFILLER_67_3 VGND VGND VPWR VPWR sky130_fd_sc_hd__decap_3
X_1613_ net735 net698 VGND VGND VPWR VPWR Inst_LD_LUT4c_frame_config_dffesr.inst_cus_mux161_buf.A13
+ sky130_fd_sc_hd__dlxtp_1
X_1544_ net746 net693 VGND VGND VPWR VPWR Inst_LA_LUT4c_frame_config_dffesr.inst_cus_mux161_buf.A1
+ sky130_fd_sc_hd__dlxtp_1
XFILLER_86_217 VGND VGND VPWR VPWR sky130_fd_sc_hd__decap_3
X_1475_ net613 Inst_SimpleCLB_switch_matrix.E2BEG1 net645 net258 Inst_SimpleCLB_ConfigMem.Inst_frame12_bit23.Q
+ Inst_SimpleCLB_ConfigMem.Inst_frame12_bit22.Q VGND VGND VPWR VPWR Inst_SimpleCLB_switch_matrix.S1BEG2
+ sky130_fd_sc_hd__mux4_2
XFILLER_39_122 VGND VGND VPWR VPWR sky130_fd_sc_hd__fill_1
XFILLER_39_133 VGND VGND VPWR VPWR sky130_fd_sc_hd__decap_3
XFILLER_27_317 VGND VGND VPWR VPWR sky130_fd_sc_hd__fill_2
XFILLER_39_166 VGND VGND VPWR VPWR sky130_fd_sc_hd__fill_2
X_2027_ net739 net679 VGND VGND VPWR VPWR Inst_SimpleCLB_ConfigMem.Inst_frame3_bit6.Q
+ sky130_fd_sc_hd__dlxtp_1
XTAP_TAPCELL_ROW_80_668 VGND VPWR sky130_fd_sc_hd__tapvpwrvgnd_1
XFILLER_10_206 VGND VGND VPWR VPWR sky130_fd_sc_hd__decap_3
XFILLER_40_15 VGND VGND VPWR VPWR sky130_fd_sc_hd__decap_3
XFILLER_40_59 VGND VGND VPWR VPWR sky130_fd_sc_hd__decap_3
XFILLER_49_24 VGND VGND VPWR VPWR sky130_fd_sc_hd__decap_3
XTAP_TAPCELL_ROW_5_221 VGND VPWR sky130_fd_sc_hd__tapvpwrvgnd_1
Xfanout720 net721 VGND VGND VPWR VPWR net720 sky130_fd_sc_hd__buf_2
Xfanout731 net732 VGND VGND VPWR VPWR net731 sky130_fd_sc_hd__buf_2
Xfanout742 FrameData[5] VGND VGND VPWR VPWR net742 sky130_fd_sc_hd__clkbuf_4
XFILLER_49_79 VGND VGND VPWR VPWR sky130_fd_sc_hd__decap_3
Xfanout764 net765 VGND VGND VPWR VPWR net764 sky130_fd_sc_hd__buf_2
Xfanout775 FrameData[20] VGND VGND VPWR VPWR net775 sky130_fd_sc_hd__buf_2
Xfanout753 net755 VGND VGND VPWR VPWR net753 sky130_fd_sc_hd__clkbuf_4
Xfanout797 FrameData[10] VGND VGND VPWR VPWR net797 sky130_fd_sc_hd__buf_4
Xfanout786 net787 VGND VGND VPWR VPWR net786 sky130_fd_sc_hd__clkbuf_4
XFILLER_18_328 VGND VGND VPWR VPWR sky130_fd_sc_hd__decap_3
XFILLER_45_103 VGND VGND VPWR VPWR sky130_fd_sc_hd__decap_3
XANTENNA_113 S4END[6] VGND VGND VPWR VPWR sky130_fd_sc_hd__diode_2
XANTENNA_124 net221 VGND VGND VPWR VPWR sky130_fd_sc_hd__diode_2
XTAP_TAPCELL_ROW_28_356 VGND VPWR sky130_fd_sc_hd__tapvpwrvgnd_1
XANTENNA_102 S2END[6] VGND VGND VPWR VPWR sky130_fd_sc_hd__diode_2
XANTENNA_157 WW4END[3] VGND VGND VPWR VPWR sky130_fd_sc_hd__diode_2
XANTENNA_146 W6END[1] VGND VGND VPWR VPWR sky130_fd_sc_hd__diode_2
XANTENNA_135 W2END[6] VGND VGND VPWR VPWR sky130_fd_sc_hd__diode_2
XFILLER_60_106 VGND VGND VPWR VPWR sky130_fd_sc_hd__decap_3
XFILLER_81_11 VGND VGND VPWR VPWR sky130_fd_sc_hd__decap_3
XANTENNA_168 net755 VGND VGND VPWR VPWR sky130_fd_sc_hd__diode_2
XFILLER_60_139 VGND VGND VPWR VPWR sky130_fd_sc_hd__fill_1
XANTENNA_179 net782 VGND VGND VPWR VPWR sky130_fd_sc_hd__diode_2
XFILLER_81_22 VGND VGND VPWR VPWR sky130_fd_sc_hd__decap_3
XFILLER_81_88 VGND VGND VPWR VPWR sky130_fd_sc_hd__fill_2
XTAP_TAPCELL_ROW_11_256 VGND VPWR sky130_fd_sc_hd__tapvpwrvgnd_1
XFILLER_5_243 VGND VGND VPWR VPWR sky130_fd_sc_hd__decap_3
XFILLER_68_206 VGND VGND VPWR VPWR sky130_fd_sc_hd__decap_3
X_1260_ _0584_ _0341_ Inst_SimpleCLB_ConfigMem.Inst_frame2_bit29.Q VGND VGND VPWR
+ VPWR _0342_ sky130_fd_sc_hd__o21a_1
X_1191_ Inst_LG_LUT4c_frame_config_dffesr.inst_cus_mux161_buf.A12 _0257_ net263 VGND
+ VGND VPWR VPWR _0277_ sky130_fd_sc_hd__or3b_1
XFILLER_39_90 VGND VGND VPWR VPWR sky130_fd_sc_hd__decap_3
XFILLER_36_114 VGND VGND VPWR VPWR sky130_fd_sc_hd__fill_2
X_0975_ _0072_ _0073_ Inst_SimpleCLB_ConfigMem.Inst_frame1_bit12.Q VGND VGND VPWR
+ VPWR _0074_ sky130_fd_sc_hd__mux2_1
X_1527_ Inst_SimpleCLB_ConfigMem.Inst_frame9_bit17.Q _0530_ VGND VGND VPWR VPWR _0553_
+ sky130_fd_sc_hd__nand2_1
X_1458_ net317 _0609_ Inst_SimpleCLB_ConfigMem.Inst_frame13_bit10.Q VGND VGND VPWR
+ VPWR _0514_ sky130_fd_sc_hd__mux2_1
XTAP_TAPCELL_ROW_2_202 VGND VPWR sky130_fd_sc_hd__tapvpwrvgnd_1
XFILLER_67_250 VGND VGND VPWR VPWR sky130_fd_sc_hd__decap_3
XFILLER_27_125 VGND VGND VPWR VPWR sky130_fd_sc_hd__decap_3
X_1389_ Inst_SimpleCLB_ConfigMem.Inst_frame12_bit15.Q _0453_ VGND VGND VPWR VPWR _0454_
+ sky130_fd_sc_hd__nand2_1
XFILLER_82_242 VGND VGND VPWR VPWR sky130_fd_sc_hd__decap_3
XFILLER_27_136 VGND VGND VPWR VPWR sky130_fd_sc_hd__decap_3
XFILLER_82_264 VGND VGND VPWR VPWR sky130_fd_sc_hd__decap_3
XFILLER_42_106 VGND VGND VPWR VPWR sky130_fd_sc_hd__decap_3
XFILLER_50_194 VGND VGND VPWR VPWR sky130_fd_sc_hd__fill_2
XFILLER_2_235 VGND VGND VPWR VPWR sky130_fd_sc_hd__fill_1
XFILLER_58_250 VGND VGND VPWR VPWR sky130_fd_sc_hd__fill_2
XFILLER_76_88 VGND VGND VPWR VPWR sky130_fd_sc_hd__decap_3
XFILLER_18_147 VGND VGND VPWR VPWR sky130_fd_sc_hd__decap_3
XFILLER_73_231 VGND VGND VPWR VPWR sky130_fd_sc_hd__decap_3
XFILLER_33_106 VGND VGND VPWR VPWR sky130_fd_sc_hd__decap_3
XFILLER_33_128 VGND VGND VPWR VPWR sky130_fd_sc_hd__decap_3
XFILLER_41_172 VGND VGND VPWR VPWR sky130_fd_sc_hd__decap_3
X_0760_ Inst_SimpleCLB_ConfigMem.Inst_frame5_bit28.Q VGND VGND VPWR VPWR _0596_ sky130_fd_sc_hd__inv_2
X_2361_ clknet_1_0__leaf_UserCLK VGND VGND VPWR VPWR net206 sky130_fd_sc_hd__buf_2
X_1312_ _0382_ _0384_ _0387_ _0597_ VGND VGND VPWR VPWR Inst_SimpleCLB_switch_matrix.JN2BEG0
+ sky130_fd_sc_hd__a22o_1
X_1243_ _0326_ _0324_ _0320_ VGND VGND VPWR VPWR _0327_ sky130_fd_sc_hd__mux2_4
XFILLER_2_74 VGND VGND VPWR VPWR sky130_fd_sc_hd__decap_3
XFILLER_49_261 VGND VGND VPWR VPWR sky130_fd_sc_hd__decap_3
X_1174_ Inst_LG_LUT4c_frame_config_dffesr.inst_cus_mux161_buf.A9 Inst_LG_LUT4c_frame_config_dffesr.inst_cus_mux161_buf.A11
+ Inst_LG_LUT4c_frame_config_dffesr.inst_cus_mux161_buf.A13 Inst_LG_LUT4c_frame_config_dffesr.inst_cus_mux161_buf.A15
+ _0257_ net263 VGND VGND VPWR VPWR _0261_ sky130_fd_sc_hd__mux4_1
XFILLER_24_106 VGND VGND VPWR VPWR sky130_fd_sc_hd__decap_3
XTAP_TAPCELL_ROW_47_473 VGND VPWR sky130_fd_sc_hd__tapvpwrvgnd_1
XFILLER_64_253 VGND VGND VPWR VPWR sky130_fd_sc_hd__decap_3
XTAP_TAPCELL_ROW_90_730 VGND VPWR sky130_fd_sc_hd__tapvpwrvgnd_1
XFILLER_17_191 VGND VGND VPWR VPWR sky130_fd_sc_hd__fill_2
XFILLER_24_139 VGND VGND VPWR VPWR sky130_fd_sc_hd__fill_1
XFILLER_32_150 VGND VGND VPWR VPWR sky130_fd_sc_hd__decap_3
XANTENNA_13 EE4END[0] VGND VGND VPWR VPWR sky130_fd_sc_hd__diode_2
XANTENNA_57 net85 VGND VGND VPWR VPWR sky130_fd_sc_hd__diode_2
XANTENNA_24 EE4END[9] VGND VGND VPWR VPWR sky130_fd_sc_hd__diode_2
XFILLER_20_345 VGND VGND VPWR VPWR sky130_fd_sc_hd__fill_2
XANTENNA_35 FrameData[18] VGND VGND VPWR VPWR sky130_fd_sc_hd__diode_2
XANTENNA_46 net75 VGND VGND VPWR VPWR sky130_fd_sc_hd__diode_2
XANTENNA_79 NN4END[10] VGND VGND VPWR VPWR sky130_fd_sc_hd__diode_2
XANTENNA_68 N4END[12] VGND VGND VPWR VPWR sky130_fd_sc_hd__diode_2
X_0958_ Inst_LC_LUT4c_frame_config_dffesr.inst_cus_mux161_buf.A9 _0056_ Inst_LC_LUT4c_frame_config_dffesr.inst_cus_mux161_buf.A15
+ _0057_ VGND VGND VPWR VPWR _0058_ sky130_fd_sc_hd__o22a_1
XTAP_TAPCELL_ROW_30_373 VGND VPWR sky130_fd_sc_hd__tapvpwrvgnd_1
X_0889_ Inst_SimpleCLB_ConfigMem.Inst_frame10_bit30.Q _0714_ _0712_ Inst_SimpleCLB_ConfigMem.Inst_frame10_bit31.Q
+ VGND VGND VPWR VPWR _0715_ sky130_fd_sc_hd__o211a_1
Xoutput131 net131 VGND VGND VPWR VPWR N4BEG[3] sky130_fd_sc_hd__buf_2
Xoutput120 net120 VGND VGND VPWR VPWR N2BEGb[6] sky130_fd_sc_hd__buf_2
Xoutput142 Inst_SimpleCLB_switch_matrix.NN4BEG1 VGND VGND VPWR VPWR NN4BEG[13] sky130_fd_sc_hd__buf_6
Xoutput153 net153 VGND VGND VPWR VPWR NN4BEG[9] sky130_fd_sc_hd__buf_2
Xoutput164 net164 VGND VGND VPWR VPWR S2BEG[6] sky130_fd_sc_hd__buf_8
Xoutput186 net186 VGND VGND VPWR VPWR S4BEG[6] sky130_fd_sc_hd__buf_2
Xoutput175 net175 VGND VGND VPWR VPWR S4BEG[10] sky130_fd_sc_hd__buf_2
Xoutput197 net197 VGND VGND VPWR VPWR SS4BEG[1] sky130_fd_sc_hd__buf_2
XFILLER_46_47 VGND VGND VPWR VPWR sky130_fd_sc_hd__decap_3
XFILLER_55_231 VGND VGND VPWR VPWR sky130_fd_sc_hd__decap_3
XFILLER_55_264 VGND VGND VPWR VPWR sky130_fd_sc_hd__decap_3
XFILLER_70_245 VGND VGND VPWR VPWR sky130_fd_sc_hd__decap_3
XFILLER_62_24 VGND VGND VPWR VPWR sky130_fd_sc_hd__decap_3
XFILLER_62_35 VGND VGND VPWR VPWR sky130_fd_sc_hd__decap_3
XFILLER_62_79 VGND VGND VPWR VPWR sky130_fd_sc_hd__decap_3
XFILLER_23_194 VGND VGND VPWR VPWR sky130_fd_sc_hd__fill_1
XFILLER_7_316 VGND VGND VPWR VPWR sky130_fd_sc_hd__decap_3
XFILLER_11_94 VGND VGND VPWR VPWR sky130_fd_sc_hd__fill_2
XFILLER_38_209 VGND VGND VPWR VPWR sky130_fd_sc_hd__decap_3
XFILLER_36_91 VGND VGND VPWR VPWR sky130_fd_sc_hd__fill_2
XTAP_TAPCELL_ROW_44_454 VGND VPWR sky130_fd_sc_hd__tapvpwrvgnd_1
XFILLER_14_150 VGND VGND VPWR VPWR sky130_fd_sc_hd__decap_3
X_1930_ net742 net670 VGND VGND VPWR VPWR Inst_SimpleCLB_ConfigMem.Inst_frame6_bit5.Q
+ sky130_fd_sc_hd__dlxtp_1
X_1861_ net799 net662 VGND VGND VPWR VPWR Inst_SimpleCLB_ConfigMem.Inst_frame8_bit0.Q
+ sky130_fd_sc_hd__dlxtp_1
X_0812_ NN4END[3] WW4END[0] S4END[3] Inst_SimpleCLB_switch_matrix.JN2BEG1 Inst_SimpleCLB_ConfigMem.Inst_frame1_bit27.Q
+ Inst_SimpleCLB_ConfigMem.Inst_frame1_bit26.Q VGND VGND VPWR VPWR _0644_ sky130_fd_sc_hd__mux4_2
X_1792_ net759 net723 VGND VGND VPWR VPWR Inst_SimpleCLB_ConfigMem.Inst_frame11_bit27.Q
+ sky130_fd_sc_hd__dlxtp_1
X_0743_ Inst_LC_LUT4c_frame_config_dffesr.c_I0mux VGND VGND VPWR VPWR _0579_ sky130_fd_sc_hd__inv_2
X_2344_ Inst_SimpleCLB_switch_matrix.S4BEG3 VGND VGND VPWR VPWR net180 sky130_fd_sc_hd__clkbuf_2
XFILLER_69_312 VGND VGND VPWR VPWR sky130_fd_sc_hd__fill_1
XFILLER_69_334 VGND VGND VPWR VPWR sky130_fd_sc_hd__fill_2
XFILLER_84_304 VGND VGND VPWR VPWR sky130_fd_sc_hd__fill_1
XFILLER_69_345 VGND VGND VPWR VPWR sky130_fd_sc_hd__fill_2
X_2275_ N2MID[6] VGND VGND VPWR VPWR net120 sky130_fd_sc_hd__clkbuf_2
X_1226_ _0309_ _0310_ VGND VGND VPWR VPWR _0311_ sky130_fd_sc_hd__nand2_1
XFILLER_37_220 VGND VGND VPWR VPWR sky130_fd_sc_hd__decap_3
XFILLER_37_231 VGND VGND VPWR VPWR sky130_fd_sc_hd__fill_1
XFILLER_37_275 VGND VGND VPWR VPWR sky130_fd_sc_hd__decap_3
X_1157_ _0241_ _0242_ _0244_ _0243_ Inst_SimpleCLB_ConfigMem.Inst_frame8_bit10.Q Inst_SimpleCLB_ConfigMem.Inst_frame8_bit11.Q
+ VGND VGND VPWR VPWR _0245_ sky130_fd_sc_hd__mux4_2
XFILLER_12_109 VGND VGND VPWR VPWR sky130_fd_sc_hd__fill_2
X_1088_ S1END[0] S1END[2] S2END[6] net647 Inst_SimpleCLB_ConfigMem.Inst_frame1_bit14.Q
+ Inst_SimpleCLB_ConfigMem.Inst_frame1_bit15.Q VGND VGND VPWR VPWR _0181_ sky130_fd_sc_hd__mux4_1
XFILLER_32_27 VGND VGND VPWR VPWR sky130_fd_sc_hd__fill_1
XFILLER_75_337 VGND VGND VPWR VPWR sky130_fd_sc_hd__fill_2
XFILLER_28_242 VGND VGND VPWR VPWR sky130_fd_sc_hd__decap_3
XFILLER_43_223 VGND VGND VPWR VPWR sky130_fd_sc_hd__fill_1
XFILLER_43_245 VGND VGND VPWR VPWR sky130_fd_sc_hd__decap_3
XTAP_TAPCELL_ROW_41_435 VGND VPWR sky130_fd_sc_hd__tapvpwrvgnd_1
XFILLER_7_113 VGND VGND VPWR VPWR sky130_fd_sc_hd__decap_3
XFILLER_11_175 VGND VGND VPWR VPWR sky130_fd_sc_hd__decap_3
XFILLER_78_120 VGND VGND VPWR VPWR sky130_fd_sc_hd__fill_2
X_2060_ net737 net684 VGND VGND VPWR VPWR Inst_SimpleCLB_ConfigMem.Inst_frame2_bit7.Q
+ sky130_fd_sc_hd__dlxtp_1
XFILLER_19_220 VGND VGND VPWR VPWR sky130_fd_sc_hd__decap_3
XFILLER_19_231 VGND VGND VPWR VPWR sky130_fd_sc_hd__decap_3
X_1011_ Inst_LB_LUT4c_frame_config_dffesr.inst_cus_mux161_buf.A0 _0009_ _0094_ _0107_
+ VGND VGND VPWR VPWR _0108_ sky130_fd_sc_hd__o211a_1
XFILLER_34_234 VGND VGND VPWR VPWR sky130_fd_sc_hd__decap_3
XFILLER_34_245 VGND VGND VPWR VPWR sky130_fd_sc_hd__decap_3
X_1913_ net774 net666 VGND VGND VPWR VPWR Inst_SimpleCLB_ConfigMem.Inst_frame7_bit20.Q
+ sky130_fd_sc_hd__dlxtp_1
XFILLER_8_73 VGND VGND VPWR VPWR sky130_fd_sc_hd__decap_3
X_1844_ net787 net655 VGND VGND VPWR VPWR Inst_SimpleCLB_ConfigMem.Inst_frame9_bit15.Q
+ sky130_fd_sc_hd__dlxtp_1
X_1775_ net797 net721 VGND VGND VPWR VPWR Inst_SimpleCLB_ConfigMem.Inst_frame11_bit10.Q
+ sky130_fd_sc_hd__dlxtp_1
XFILLER_69_131 VGND VGND VPWR VPWR sky130_fd_sc_hd__decap_3
XFILLER_84_112 VGND VGND VPWR VPWR sky130_fd_sc_hd__decap_3
X_2327_ S2MID[6] VGND VGND VPWR VPWR net172 sky130_fd_sc_hd__clkbuf_2
X_2258_ Inst_SimpleCLB_switch_matrix.N1BEG1 VGND VGND VPWR VPWR net103 sky130_fd_sc_hd__clkbuf_2
X_1209_ _0291_ _0290_ VGND VGND VPWR VPWR _0294_ sky130_fd_sc_hd__nand2b_1
XFILLER_84_156 VGND VGND VPWR VPWR sky130_fd_sc_hd__decap_3
XFILLER_72_329 VGND VGND VPWR VPWR sky130_fd_sc_hd__fill_1
X_2189_ EE4END[4] VGND VGND VPWR VPWR net34 sky130_fd_sc_hd__buf_1
XFILLER_25_223 VGND VGND VPWR VPWR sky130_fd_sc_hd__fill_1
XFILLER_25_234 VGND VGND VPWR VPWR sky130_fd_sc_hd__decap_3
XTAP_TAPCELL_ROW_63_571 VGND VPWR sky130_fd_sc_hd__tapvpwrvgnd_1
XFILLER_40_259 VGND VGND VPWR VPWR sky130_fd_sc_hd__fill_2
Xclone14 Inst_LB_LUT4c_frame_config_dffesr.O VGND VGND VPWR VPWR net268 sky130_fd_sc_hd__clkbuf_1
XFILLER_68_12 VGND VGND VPWR VPWR sky130_fd_sc_hd__decap_3
XFILLER_68_78 VGND VGND VPWR VPWR sky130_fd_sc_hd__decap_3
XFILLER_48_304 VGND VGND VPWR VPWR sky130_fd_sc_hd__decap_3
XFILLER_75_101 VGND VGND VPWR VPWR sky130_fd_sc_hd__decap_3
XFILLER_84_44 VGND VGND VPWR VPWR sky130_fd_sc_hd__fill_2
XFILLER_75_156 VGND VGND VPWR VPWR sky130_fd_sc_hd__decap_3
XFILLER_75_178 VGND VGND VPWR VPWR sky130_fd_sc_hd__fill_1
XFILLER_84_88 VGND VGND VPWR VPWR sky130_fd_sc_hd__decap_3
XFILLER_16_212 VGND VGND VPWR VPWR sky130_fd_sc_hd__decap_3
XFILLER_17_82 VGND VGND VPWR VPWR sky130_fd_sc_hd__fill_1
XFILLER_17_60 VGND VGND VPWR VPWR sky130_fd_sc_hd__fill_2
XFILLER_16_256 VGND VGND VPWR VPWR sky130_fd_sc_hd__decap_3
XFILLER_16_245 VGND VGND VPWR VPWR sky130_fd_sc_hd__decap_3
X_1560_ net779 net693 VGND VGND VPWR VPWR Inst_LA_LUT4c_frame_config_dffesr.c_I0mux
+ sky130_fd_sc_hd__dlxtp_1
X_1491_ _0521_ _0296_ VGND VGND VPWR VPWR net1 sky130_fd_sc_hd__nor2_8
X_2112_ FrameData[27] net688 VGND VGND VPWR VPWR Inst_SimpleCLB_ConfigMem.Inst_frame1_bit27.Q
+ sky130_fd_sc_hd__dlxtp_1
XFILLER_39_337 VGND VGND VPWR VPWR sky130_fd_sc_hd__fill_1
XTAP_TAPCELL_ROW_77_652 VGND VPWR sky130_fd_sc_hd__tapvpwrvgnd_1
X_2043_ net769 net680 VGND VGND VPWR VPWR Inst_SimpleCLB_ConfigMem.Inst_frame3_bit22.Q
+ sky130_fd_sc_hd__dlxtp_1
XFILLER_81_159 VGND VGND VPWR VPWR sky130_fd_sc_hd__decap_3
XTAP_TAPCELL_ROW_17_295 VGND VPWR sky130_fd_sc_hd__tapvpwrvgnd_1
XFILLER_22_248 VGND VGND VPWR VPWR sky130_fd_sc_hd__decap_3
XTAP_TAPCELL_ROW_60_552 VGND VPWR sky130_fd_sc_hd__tapvpwrvgnd_1
XFILLER_30_292 VGND VGND VPWR VPWR sky130_fd_sc_hd__decap_3
X_1827_ net750 net727 VGND VGND VPWR VPWR Inst_SimpleCLB_ConfigMem.Inst_frame10_bit30.Q
+ sky130_fd_sc_hd__dlxtp_1
XFILLER_89_204 VGND VGND VPWR VPWR sky130_fd_sc_hd__decap_3
X_1758_ net762 net716 VGND VGND VPWR VPWR Inst_SimpleCLB_ConfigMem.Inst_frame12_bit25.Q
+ sky130_fd_sc_hd__dlxtp_1
XFILLER_89_215 VGND VGND VPWR VPWR sky130_fd_sc_hd__decap_3
X_1689_ net774 net707 VGND VGND VPWR VPWR Inst_LH_LUT4c_frame_config_dffesr.inst_cus_mux161_buf.A13
+ sky130_fd_sc_hd__dlxtp_1
XFILLER_89_259 VGND VGND VPWR VPWR sky130_fd_sc_hd__decap_3
XFILLER_57_101 VGND VGND VPWR VPWR sky130_fd_sc_hd__decap_3
XFILLER_38_48 VGND VGND VPWR VPWR sky130_fd_sc_hd__decap_3
XFILLER_72_104 VGND VGND VPWR VPWR sky130_fd_sc_hd__fill_2
XFILLER_54_47 VGND VGND VPWR VPWR sky130_fd_sc_hd__decap_3
XTAP_TAPCELL_ROW_83_688 VGND VPWR sky130_fd_sc_hd__tapvpwrvgnd_1
XFILLER_13_215 VGND VGND VPWR VPWR sky130_fd_sc_hd__decap_3
XTAP_TAPCELL_ROW_0_185 VGND VPWR sky130_fd_sc_hd__tapvpwrvgnd_1
XFILLER_9_219 VGND VGND VPWR VPWR sky130_fd_sc_hd__decap_3
XFILLER_21_270 VGND VGND VPWR VPWR sky130_fd_sc_hd__decap_3
XFILLER_79_66 VGND VGND VPWR VPWR sky130_fd_sc_hd__fill_2
XTAP_TAPCELL_ROW_8_241 VGND VPWR sky130_fd_sc_hd__tapvpwrvgnd_1
XFILLER_0_141 VGND VGND VPWR VPWR sky130_fd_sc_hd__decap_3
XFILLER_48_156 VGND VGND VPWR VPWR sky130_fd_sc_hd__decap_3
XTAP_TAPCELL_ROW_74_633 VGND VPWR sky130_fd_sc_hd__tapvpwrvgnd_1
XFILLER_63_148 VGND VGND VPWR VPWR sky130_fd_sc_hd__decap_3
XFILLER_44_80 VGND VGND VPWR VPWR sky130_fd_sc_hd__decap_3
X_0991_ _0088_ Inst_LC_LUT4c_frame_config_dffesr.LUT_flop Inst_LC_LUT4c_frame_config_dffesr.c_out_mux
+ VGND VGND VPWR VPWR Inst_LC_LUT4c_frame_config_dffesr.O sky130_fd_sc_hd__mux2_4
XFILLER_44_91 VGND VGND VPWR VPWR sky130_fd_sc_hd__decap_3
XTAP_TAPCELL_ROW_14_276 VGND VPWR sky130_fd_sc_hd__tapvpwrvgnd_1
XFILLER_8_230 VGND VGND VPWR VPWR sky130_fd_sc_hd__decap_3
X_1612_ net737 net698 VGND VGND VPWR VPWR Inst_LD_LUT4c_frame_config_dffesr.inst_cus_mux161_buf.A12
+ sky130_fd_sc_hd__dlxtp_1
X_1543_ net752 net693 VGND VGND VPWR VPWR Inst_LA_LUT4c_frame_config_dffesr.inst_cus_mux161_buf.A0
+ sky130_fd_sc_hd__dlxtp_1
X_1474_ net609 _0669_ Inst_SimpleCLB_switch_matrix.E2BEG2 _0644_ Inst_SimpleCLB_ConfigMem.Inst_frame12_bit24.Q
+ Inst_SimpleCLB_ConfigMem.Inst_frame12_bit25.Q VGND VGND VPWR VPWR Inst_SimpleCLB_switch_matrix.S1BEG3
+ sky130_fd_sc_hd__mux4_1
XFILLER_54_126 VGND VGND VPWR VPWR sky130_fd_sc_hd__decap_3
X_2026_ net741 net682 VGND VGND VPWR VPWR Inst_SimpleCLB_ConfigMem.Inst_frame3_bit5.Q
+ sky130_fd_sc_hd__dlxtp_1
XFILLER_54_159 VGND VGND VPWR VPWR sky130_fd_sc_hd__decap_3
XFILLER_24_39 VGND VGND VPWR VPWR sky130_fd_sc_hd__decap_3
XTAP_TAPCELL_ROW_80_669 VGND VPWR sky130_fd_sc_hd__tapvpwrvgnd_1
XFILLER_40_27 VGND VGND VPWR VPWR sky130_fd_sc_hd__fill_1
XFILLER_40_38 VGND VGND VPWR VPWR sky130_fd_sc_hd__decap_3
XFILLER_49_36 VGND VGND VPWR VPWR sky130_fd_sc_hd__fill_2
Xfanout710 FrameStrobe[14] VGND VGND VPWR VPWR net710 sky130_fd_sc_hd__buf_2
Xfanout732 FrameStrobe[0] VGND VGND VPWR VPWR net732 sky130_fd_sc_hd__clkbuf_2
Xfanout721 net723 VGND VGND VPWR VPWR net721 sky130_fd_sc_hd__clkbuf_2
XTAP_TAPCELL_ROW_5_222 VGND VPWR sky130_fd_sc_hd__tapvpwrvgnd_1
Xfanout776 FrameData[1] VGND VGND VPWR VPWR net776 sky130_fd_sc_hd__clkbuf_4
Xfanout754 net755 VGND VGND VPWR VPWR net754 sky130_fd_sc_hd__clkbuf_2
Xfanout743 FrameData[4] VGND VGND VPWR VPWR net743 sky130_fd_sc_hd__clkbuf_4
Xfanout765 FrameData[24] VGND VGND VPWR VPWR net765 sky130_fd_sc_hd__clkbuf_8
Xfanout798 FrameData[0] VGND VGND VPWR VPWR net798 sky130_fd_sc_hd__buf_4
Xfanout787 FrameData[15] VGND VGND VPWR VPWR net787 sky130_fd_sc_hd__buf_4
XFILLER_85_284 VGND VGND VPWR VPWR sky130_fd_sc_hd__decap_3
XFILLER_65_57 VGND VGND VPWR VPWR sky130_fd_sc_hd__decap_3
XANTENNA_114 S4END[7] VGND VGND VPWR VPWR sky130_fd_sc_hd__diode_2
XANTENNA_125 net225 VGND VGND VPWR VPWR sky130_fd_sc_hd__diode_2
XANTENNA_103 S2END[6] VGND VGND VPWR VPWR sky130_fd_sc_hd__diode_2
XANTENNA_158 WW4END[3] VGND VGND VPWR VPWR sky130_fd_sc_hd__diode_2
XTAP_TAPCELL_ROW_28_357 VGND VPWR sky130_fd_sc_hd__tapvpwrvgnd_1
XANTENNA_147 W6END[1] VGND VGND VPWR VPWR sky130_fd_sc_hd__diode_2
XANTENNA_136 W2END[6] VGND VGND VPWR VPWR sky130_fd_sc_hd__diode_2
XTAP_TAPCELL_ROW_71_614 VGND VPWR sky130_fd_sc_hd__tapvpwrvgnd_1
XANTENNA_169 net756 VGND VGND VPWR VPWR sky130_fd_sc_hd__diode_2
XFILLER_53_181 VGND VGND VPWR VPWR sky130_fd_sc_hd__fill_1
XFILLER_14_72 VGND VGND VPWR VPWR sky130_fd_sc_hd__decap_3
XTAP_TAPCELL_ROW_11_257 VGND VPWR sky130_fd_sc_hd__tapvpwrvgnd_1
XFILLER_5_211 VGND VGND VPWR VPWR sky130_fd_sc_hd__decap_3
XFILLER_5_255 VGND VGND VPWR VPWR sky130_fd_sc_hd__decap_3
XFILLER_30_82 VGND VGND VPWR VPWR sky130_fd_sc_hd__fill_2
X_1190_ net307 _0274_ _0264_ _0262_ Inst_SimpleCLB_ConfigMem.Inst_frame8_bit12.Q Inst_SimpleCLB_ConfigMem.Inst_frame8_bit13.Q
+ VGND VGND VPWR VPWR _0276_ sky130_fd_sc_hd__mux4_2
XTAP_TAPCELL_ROW_19_302 VGND VPWR sky130_fd_sc_hd__tapvpwrvgnd_1
XFILLER_76_262 VGND VGND VPWR VPWR sky130_fd_sc_hd__decap_3
XFILLER_17_340 VGND VGND VPWR VPWR sky130_fd_sc_hd__decap_3
XFILLER_44_181 VGND VGND VPWR VPWR sky130_fd_sc_hd__decap_3
XFILLER_51_129 VGND VGND VPWR VPWR sky130_fd_sc_hd__decap_3
X_0974_ S1END[1] S2END[5] S1END[3] W1END[1] Inst_SimpleCLB_ConfigMem.Inst_frame1_bit11.Q
+ Inst_SimpleCLB_ConfigMem.Inst_frame1_bit10.Q VGND VGND VPWR VPWR _0073_ sky130_fd_sc_hd__mux4_1
X_1526_ net397 _0552_ _0550_ VGND VGND VPWR VPWR _0003_ sky130_fd_sc_hd__mux2_1
X_1457_ Inst_SimpleCLB_ConfigMem.Inst_frame13_bit11.Q _0512_ VGND VGND VPWR VPWR _0513_
+ sky130_fd_sc_hd__nand2_1
XTAP_TAPCELL_ROW_2_203 VGND VPWR sky130_fd_sc_hd__tapvpwrvgnd_1
X_1388_ net302 net620 Inst_SimpleCLB_ConfigMem.Inst_frame12_bit14.Q VGND VGND VPWR
+ VPWR _0453_ sky130_fd_sc_hd__mux2_1
XFILLER_27_159 VGND VGND VPWR VPWR sky130_fd_sc_hd__decap_3
XFILLER_42_118 VGND VGND VPWR VPWR sky130_fd_sc_hd__decap_3
XFILLER_23_332 VGND VGND VPWR VPWR sky130_fd_sc_hd__decap_3
XTAP_TAPCELL_ROW_25_338 VGND VPWR sky130_fd_sc_hd__tapvpwrvgnd_1
XFILLER_35_181 VGND VGND VPWR VPWR sky130_fd_sc_hd__decap_3
X_2009_ net773 net676 VGND VGND VPWR VPWR Inst_SimpleCLB_ConfigMem.Inst_frame4_bit20.Q
+ sky130_fd_sc_hd__dlxtp_1
XFILLER_2_203 VGND VGND VPWR VPWR sky130_fd_sc_hd__fill_2
XFILLER_18_137 VGND VGND VPWR VPWR sky130_fd_sc_hd__decap_3
XFILLER_73_221 VGND VGND VPWR VPWR sky130_fd_sc_hd__decap_3
XFILLER_25_60 VGND VGND VPWR VPWR sky130_fd_sc_hd__decap_3
XFILLER_41_184 VGND VGND VPWR VPWR sky130_fd_sc_hd__decap_3
XFILLER_44_6 VGND VGND VPWR VPWR sky130_fd_sc_hd__fill_1
X_2360_ Inst_SimpleCLB_switch_matrix.SS4BEG3 VGND VGND VPWR VPWR net196 sky130_fd_sc_hd__clkbuf_2
X_1311_ _0385_ _0386_ _0596_ VGND VGND VPWR VPWR _0387_ sky130_fd_sc_hd__mux2_1
X_2291_ Inst_SimpleCLB_switch_matrix.N4BEG2 VGND VGND VPWR VPWR net127 sky130_fd_sc_hd__buf_1
XPHY_EDGE_ROW_10_Right_10 VGND VGND VPWR VPWR sky130_fd_sc_hd__decap_3
X_1242_ Inst_LD_LUT4c_frame_config_dffesr.inst_cus_mux161_buf.A9 Inst_LD_LUT4c_frame_config_dffesr.inst_cus_mux161_buf.A11
+ Inst_LD_LUT4c_frame_config_dffesr.inst_cus_mux161_buf.A13 Inst_LD_LUT4c_frame_config_dffesr.inst_cus_mux161_buf.A15
+ _0158_ _0159_ VGND VGND VPWR VPWR _0326_ sky130_fd_sc_hd__mux4_1
XFILLER_49_240 VGND VGND VPWR VPWR sky130_fd_sc_hd__decap_3
XFILLER_49_273 VGND VGND VPWR VPWR sky130_fd_sc_hd__decap_3
XFILLER_49_284 VGND VGND VPWR VPWR sky130_fd_sc_hd__decap_3
X_1173_ _0259_ VGND VGND VPWR VPWR _0260_ sky130_fd_sc_hd__inv_1
XTAP_TAPCELL_ROW_90_731 VGND VPWR sky130_fd_sc_hd__tapvpwrvgnd_1
XTAP_TAPCELL_ROW_47_474 VGND VPWR sky130_fd_sc_hd__tapvpwrvgnd_1
XFILLER_32_162 VGND VGND VPWR VPWR sky130_fd_sc_hd__fill_2
XANTENNA_14 EE4END[10] VGND VGND VPWR VPWR sky130_fd_sc_hd__diode_2
XANTENNA_25 EE4END[9] VGND VGND VPWR VPWR sky130_fd_sc_hd__diode_2
XFILLER_32_195 VGND VGND VPWR VPWR sky130_fd_sc_hd__fill_1
XANTENNA_36 FrameData[1] VGND VGND VPWR VPWR sky130_fd_sc_hd__diode_2
XANTENNA_47 FrameStrobe[11] VGND VGND VPWR VPWR sky130_fd_sc_hd__diode_2
XANTENNA_58 net93 VGND VGND VPWR VPWR sky130_fd_sc_hd__diode_2
X_0957_ net301 net260 VGND VGND VPWR VPWR _0057_ sky130_fd_sc_hd__nand2_8
XANTENNA_69 N4END[13] VGND VGND VPWR VPWR sky130_fd_sc_hd__diode_2
Xoutput110 net110 VGND VGND VPWR VPWR N2BEG[4] sky130_fd_sc_hd__clkbuf_4
X_0888_ _0713_ VGND VGND VPWR VPWR _0714_ sky130_fd_sc_hd__inv_2
Xoutput143 net143 VGND VGND VPWR VPWR NN4BEG[14] sky130_fd_sc_hd__buf_6
Xoutput121 net121 VGND VGND VPWR VPWR N2BEGb[7] sky130_fd_sc_hd__buf_2
Xoutput132 net132 VGND VGND VPWR VPWR N4BEG[4] sky130_fd_sc_hd__buf_2
Xoutput165 net165 VGND VGND VPWR VPWR S2BEG[7] sky130_fd_sc_hd__buf_4
Xoutput154 net154 VGND VGND VPWR VPWR S1BEG[0] sky130_fd_sc_hd__clkbuf_4
Xoutput176 net176 VGND VGND VPWR VPWR S4BEG[11] sky130_fd_sc_hd__buf_2
XFILLER_87_335 VGND VGND VPWR VPWR sky130_fd_sc_hd__fill_1
Xoutput187 net187 VGND VGND VPWR VPWR S4BEG[7] sky130_fd_sc_hd__buf_2
Xoutput198 net198 VGND VGND VPWR VPWR SS4BEG[2] sky130_fd_sc_hd__buf_2
X_1509_ _0537_ _0538_ _0534_ VGND VGND VPWR VPWR _0539_ sky130_fd_sc_hd__o21a_4
XFILLER_87_346 VGND VGND VPWR VPWR sky130_fd_sc_hd__fill_1
XFILLER_46_59 VGND VGND VPWR VPWR sky130_fd_sc_hd__fill_1
XFILLER_55_276 VGND VGND VPWR VPWR sky130_fd_sc_hd__decap_3
XFILLER_70_202 VGND VGND VPWR VPWR sky130_fd_sc_hd__fill_2
XFILLER_62_47 VGND VGND VPWR VPWR sky130_fd_sc_hd__decap_3
XFILLER_70_279 VGND VGND VPWR VPWR sky130_fd_sc_hd__decap_3
XFILLER_11_346 VGND VGND VPWR VPWR sky130_fd_sc_hd__fill_1
XFILLER_11_335 VGND VGND VPWR VPWR sky130_fd_sc_hd__fill_1
XFILLER_7_328 VGND VGND VPWR VPWR sky130_fd_sc_hd__decap_3
XFILLER_11_40 VGND VGND VPWR VPWR sky130_fd_sc_hd__decap_3
XFILLER_78_346 VGND VGND VPWR VPWR sky130_fd_sc_hd__fill_1
XFILLER_46_265 VGND VGND VPWR VPWR sky130_fd_sc_hd__decap_3
XFILLER_36_81 VGND VGND VPWR VPWR sky130_fd_sc_hd__decap_3
XFILLER_61_213 VGND VGND VPWR VPWR sky130_fd_sc_hd__decap_3
XTAP_TAPCELL_ROW_44_455 VGND VPWR sky130_fd_sc_hd__tapvpwrvgnd_1
X_1860_ net748 net657 VGND VGND VPWR VPWR Inst_SimpleCLB_ConfigMem.Inst_frame9_bit31.Q
+ sky130_fd_sc_hd__dlxtp_1
X_0811_ Inst_SimpleCLB_ConfigMem.Inst_frame4_bit1.Q _0643_ _0640_ VGND VGND VPWR VPWR
+ Inst_SimpleCLB_switch_matrix.JN2BEG1 sky130_fd_sc_hd__o21ba_1
X_1791_ net761 net723 VGND VGND VPWR VPWR Inst_SimpleCLB_ConfigMem.Inst_frame11_bit26.Q
+ sky130_fd_sc_hd__dlxtp_1
X_0742_ Inst_SimpleCLB_ConfigMem.Inst_frame10_bit26.Q VGND VGND VPWR VPWR _0578_ sky130_fd_sc_hd__inv_2
XFILLER_42_3 VGND VGND VPWR VPWR sky130_fd_sc_hd__fill_2
X_2343_ Inst_SimpleCLB_switch_matrix.S4BEG2 VGND VGND VPWR VPWR net179 sky130_fd_sc_hd__clkbuf_2
X_2274_ N2MID[5] VGND VGND VPWR VPWR net119 sky130_fd_sc_hd__clkbuf_2
X_1225_ Inst_LH_LUT4c_frame_config_dffesr.inst_cus_mux161_buf.A11 _0292_ _0295_ Inst_LH_LUT4c_frame_config_dffesr.inst_cus_mux161_buf.A9
+ VGND VGND VPWR VPWR _0310_ sky130_fd_sc_hd__o22a_1
XFILLER_37_254 VGND VGND VPWR VPWR sky130_fd_sc_hd__decap_3
X_1156_ NN4END[1] S2END[5] E2END[5] W2END[5] Inst_SimpleCLB_ConfigMem.Inst_frame5_bit23.Q
+ Inst_SimpleCLB_ConfigMem.Inst_frame5_bit22.Q VGND VGND VPWR VPWR _0244_ sky130_fd_sc_hd__mux4_2
XFILLER_16_29 VGND VGND VPWR VPWR sky130_fd_sc_hd__decap_3
XTAP_TAPCELL_ROW_35_400 VGND VPWR sky130_fd_sc_hd__tapvpwrvgnd_1
X_1087_ Inst_SimpleCLB_ConfigMem.Inst_frame1_bit16.Q _0177_ Inst_SimpleCLB_ConfigMem.Inst_frame1_bit17.Q
+ VGND VGND VPWR VPWR _0180_ sky130_fd_sc_hd__a21bo_1
XFILLER_20_165 VGND VGND VPWR VPWR sky130_fd_sc_hd__decap_3
X_1989_ net799 net675 VGND VGND VPWR VPWR Inst_SimpleCLB_ConfigMem.Inst_frame4_bit0.Q
+ sky130_fd_sc_hd__dlxtp_1
XTAP_TAPCELL_ROW_58_536 VGND VPWR sky130_fd_sc_hd__tapvpwrvgnd_1
XFILLER_43_257 VGND VGND VPWR VPWR sky130_fd_sc_hd__decap_3
XFILLER_73_57 VGND VGND VPWR VPWR sky130_fd_sc_hd__decap_3
XTAP_TAPCELL_ROW_41_436 VGND VPWR sky130_fd_sc_hd__tapvpwrvgnd_1
XFILLER_11_165 VGND VGND VPWR VPWR sky130_fd_sc_hd__decap_3
XFILLER_7_103 VGND VGND VPWR VPWR sky130_fd_sc_hd__decap_3
XFILLER_11_187 VGND VGND VPWR VPWR sky130_fd_sc_hd__decap_3
XFILLER_7_169 VGND VGND VPWR VPWR sky130_fd_sc_hd__decap_3
XFILLER_78_110 VGND VGND VPWR VPWR sky130_fd_sc_hd__decap_3
XFILLER_78_176 VGND VGND VPWR VPWR sky130_fd_sc_hd__fill_2
X_1010_ Inst_LB_LUT4c_frame_config_dffesr.inst_cus_mux161_buf.A6 _0010_ _0096_ Inst_LB_LUT4c_frame_config_dffesr.inst_cus_mux161_buf.A2
+ _0106_ VGND VGND VPWR VPWR _0107_ sky130_fd_sc_hd__o221a_1
XFILLER_19_276 VGND VGND VPWR VPWR sky130_fd_sc_hd__decap_3
X_1912_ net778 net665 VGND VGND VPWR VPWR Inst_SimpleCLB_ConfigMem.Inst_frame7_bit19.Q
+ sky130_fd_sc_hd__dlxtp_1
XFILLER_8_41 VGND VGND VPWR VPWR sky130_fd_sc_hd__decap_3
XFILLER_8_85 VGND VGND VPWR VPWR sky130_fd_sc_hd__decap_3
X_1843_ net789 net655 VGND VGND VPWR VPWR Inst_SimpleCLB_ConfigMem.Inst_frame9_bit14.Q
+ sky130_fd_sc_hd__dlxtp_1
X_1774_ net733 net720 VGND VGND VPWR VPWR Inst_SimpleCLB_ConfigMem.Inst_frame11_bit9.Q
+ sky130_fd_sc_hd__dlxtp_1
XFILLER_6_180 VGND VGND VPWR VPWR sky130_fd_sc_hd__decap_3
XFILLER_69_143 VGND VGND VPWR VPWR sky130_fd_sc_hd__decap_3
X_2326_ S2MID[5] VGND VGND VPWR VPWR net171 sky130_fd_sc_hd__clkbuf_2
X_2257_ Inst_SimpleCLB_switch_matrix.N1BEG0 VGND VGND VPWR VPWR net102 sky130_fd_sc_hd__buf_4
X_1208_ _0291_ _0290_ VGND VGND VPWR VPWR _0293_ sky130_fd_sc_hd__nand2_4
XFILLER_84_168 VGND VGND VPWR VPWR sky130_fd_sc_hd__decap_3
XFILLER_25_202 VGND VGND VPWR VPWR sky130_fd_sc_hd__decap_3
XFILLER_25_246 VGND VGND VPWR VPWR sky130_fd_sc_hd__decap_3
X_1139_ _0580_ _0225_ _0227_ VGND VGND VPWR VPWR _0228_ sky130_fd_sc_hd__a21oi_2
XFILLER_25_279 VGND VGND VPWR VPWR sky130_fd_sc_hd__fill_1
Xclone48 net303 VGND VGND VPWR VPWR net302 sky130_fd_sc_hd__buf_8
XFILLER_0_312 VGND VGND VPWR VPWR sky130_fd_sc_hd__decap_3
XFILLER_68_24 VGND VGND VPWR VPWR sky130_fd_sc_hd__decap_3
XFILLER_68_35 VGND VGND VPWR VPWR sky130_fd_sc_hd__decap_3
XFILLER_68_57 VGND VGND VPWR VPWR sky130_fd_sc_hd__decap_3
XFILLER_84_12 VGND VGND VPWR VPWR sky130_fd_sc_hd__decap_3
XFILLER_31_205 VGND VGND VPWR VPWR sky130_fd_sc_hd__decap_3
XFILLER_33_60 VGND VGND VPWR VPWR sky130_fd_sc_hd__decap_3
XPHY_EDGE_ROW_89_Left_180 VGND VGND VPWR VPWR sky130_fd_sc_hd__decap_3
X_1490_ _0259_ net284 _0172_ _0293_ _0258_ VGND VGND VPWR VPWR _0521_ sky130_fd_sc_hd__o311a_4
X_2111_ FrameData[26] net688 VGND VGND VPWR VPWR Inst_SimpleCLB_ConfigMem.Inst_frame1_bit26.Q
+ sky130_fd_sc_hd__dlxtp_1
X_2042_ net771 net681 VGND VGND VPWR VPWR Inst_SimpleCLB_ConfigMem.Inst_frame3_bit21.Q
+ sky130_fd_sc_hd__dlxtp_1
XTAP_TAPCELL_ROW_77_653 VGND VPWR sky130_fd_sc_hd__tapvpwrvgnd_1
XFILLER_81_105 VGND VGND VPWR VPWR sky130_fd_sc_hd__decap_3
XFILLER_81_116 VGND VGND VPWR VPWR sky130_fd_sc_hd__decap_3
XPHY_EDGE_ROW_8_Right_8 VGND VGND VPWR VPWR sky130_fd_sc_hd__decap_3
XFILLER_22_227 VGND VGND VPWR VPWR sky130_fd_sc_hd__decap_3
XTAP_TAPCELL_ROW_60_553 VGND VPWR sky130_fd_sc_hd__tapvpwrvgnd_1
X_1826_ net754 net725 VGND VGND VPWR VPWR Inst_SimpleCLB_ConfigMem.Inst_frame10_bit29.Q
+ sky130_fd_sc_hd__dlxtp_1
X_1757_ net764 net716 VGND VGND VPWR VPWR Inst_SimpleCLB_ConfigMem.Inst_frame12_bit24.Q
+ sky130_fd_sc_hd__dlxtp_1
X_1688_ net779 net708 VGND VGND VPWR VPWR Inst_LH_LUT4c_frame_config_dffesr.inst_cus_mux161_buf.A12
+ sky130_fd_sc_hd__dlxtp_1
XPHY_EDGE_ROW_39_Right_39 VGND VGND VPWR VPWR sky130_fd_sc_hd__decap_3
XFILLER_38_27 VGND VGND VPWR VPWR sky130_fd_sc_hd__fill_1
X_2309_ Inst_SimpleCLB_switch_matrix.S1BEG0 VGND VGND VPWR VPWR net154 sky130_fd_sc_hd__clkbuf_1
XFILLER_57_113 VGND VGND VPWR VPWR sky130_fd_sc_hd__decap_3
XFILLER_57_146 VGND VGND VPWR VPWR sky130_fd_sc_hd__fill_2
XFILLER_53_341 VGND VGND VPWR VPWR sky130_fd_sc_hd__decap_3
XFILLER_65_190 VGND VGND VPWR VPWR sky130_fd_sc_hd__decap_3
XTAP_TAPCELL_ROW_83_689 VGND VPWR sky130_fd_sc_hd__tapvpwrvgnd_1
XTAP_TAPCELL_ROW_0_186 VGND VPWR sky130_fd_sc_hd__tapvpwrvgnd_1
XFILLER_54_59 VGND VGND VPWR VPWR sky130_fd_sc_hd__decap_3
XPHY_EDGE_ROW_48_Right_48 VGND VGND VPWR VPWR sky130_fd_sc_hd__decap_3
XFILLER_79_45 VGND VGND VPWR VPWR sky130_fd_sc_hd__decap_3
XPHY_EDGE_ROW_57_Right_57 VGND VGND VPWR VPWR sky130_fd_sc_hd__decap_3
XFILLER_0_131 VGND VGND VPWR VPWR sky130_fd_sc_hd__decap_3
XFILLER_48_168 VGND VGND VPWR VPWR sky130_fd_sc_hd__decap_3
XFILLER_28_82 VGND VGND VPWR VPWR sky130_fd_sc_hd__fill_2
XFILLER_63_105 VGND VGND VPWR VPWR sky130_fd_sc_hd__decap_3
XFILLER_63_116 VGND VGND VPWR VPWR sky130_fd_sc_hd__decap_3
XTAP_TAPCELL_ROW_74_634 VGND VPWR sky130_fd_sc_hd__tapvpwrvgnd_1
XPHY_EDGE_ROW_66_Right_66 VGND VGND VPWR VPWR sky130_fd_sc_hd__decap_3
X_0990_ _0087_ _0081_ _0077_ VGND VGND VPWR VPWR _0088_ sky130_fd_sc_hd__mux2_4
XTAP_TAPCELL_ROW_14_277 VGND VPWR sky130_fd_sc_hd__tapvpwrvgnd_1
XFILLER_12_282 VGND VGND VPWR VPWR sky130_fd_sc_hd__decap_3
X_1611_ net739 net698 VGND VGND VPWR VPWR Inst_LD_LUT4c_frame_config_dffesr.inst_cus_mux161_buf.A11
+ sky130_fd_sc_hd__dlxtp_1
XPHY_EDGE_ROW_75_Right_75 VGND VGND VPWR VPWR sky130_fd_sc_hd__decap_3
X_1542_ net392 _0564_ _0562_ VGND VGND VPWR VPWR _0007_ sky130_fd_sc_hd__mux2_1
XFILLER_5_86 VGND VGND VPWR VPWR sky130_fd_sc_hd__decap_3
X_1473_ net800 S4END[1] S2END[2] net641 Inst_SimpleCLB_ConfigMem.Inst_frame12_bit27.Q
+ Inst_SimpleCLB_ConfigMem.Inst_frame12_bit26.Q VGND VGND VPWR VPWR Inst_SimpleCLB_switch_matrix.S4BEG0
+ sky130_fd_sc_hd__mux4_1
XFILLER_79_260 VGND VGND VPWR VPWR sky130_fd_sc_hd__fill_1
XFILLER_39_102 VGND VGND VPWR VPWR sky130_fd_sc_hd__decap_3
XFILLER_39_113 VGND VGND VPWR VPWR sky130_fd_sc_hd__decap_3
XFILLER_39_157 VGND VGND VPWR VPWR sky130_fd_sc_hd__decap_3
XPHY_EDGE_ROW_84_Right_84 VGND VGND VPWR VPWR sky130_fd_sc_hd__decap_3
X_2025_ net743 net680 VGND VGND VPWR VPWR Inst_SimpleCLB_ConfigMem.Inst_frame3_bit4.Q
+ sky130_fd_sc_hd__dlxtp_1
XFILLER_54_138 VGND VGND VPWR VPWR sky130_fd_sc_hd__fill_2
X_1809_ net793 net726 VGND VGND VPWR VPWR Inst_SimpleCLB_ConfigMem.Inst_frame10_bit12.Q
+ sky130_fd_sc_hd__dlxtp_1
XFILLER_6_9 VGND VGND VPWR VPWR sky130_fd_sc_hd__decap_3
XFILLER_49_15 VGND VGND VPWR VPWR sky130_fd_sc_hd__decap_3
Xfanout700 net701 VGND VGND VPWR VPWR net700 sky130_fd_sc_hd__buf_1
Xfanout733 net734 VGND VGND VPWR VPWR net733 sky130_fd_sc_hd__clkbuf_4
Xfanout711 net715 VGND VGND VPWR VPWR net711 sky130_fd_sc_hd__buf_2
Xfanout722 net723 VGND VGND VPWR VPWR net722 sky130_fd_sc_hd__clkbuf_4
XTAP_TAPCELL_ROW_5_223 VGND VPWR sky130_fd_sc_hd__tapvpwrvgnd_1
Xfanout744 FrameData[4] VGND VGND VPWR VPWR net744 sky130_fd_sc_hd__clkbuf_4
Xfanout755 FrameData[29] VGND VGND VPWR VPWR net755 sky130_fd_sc_hd__clkbuf_4
Xfanout766 net767 VGND VGND VPWR VPWR net766 sky130_fd_sc_hd__buf_4
Xfanout788 net789 VGND VGND VPWR VPWR net788 sky130_fd_sc_hd__clkbuf_4
Xfanout777 FrameData[1] VGND VGND VPWR VPWR net777 sky130_fd_sc_hd__clkbuf_4
Xfanout799 FrameData[0] VGND VGND VPWR VPWR net799 sky130_fd_sc_hd__clkbuf_4
XFILLER_45_127 VGND VGND VPWR VPWR sky130_fd_sc_hd__decap_3
XANTENNA_115 SS4END[0] VGND VGND VPWR VPWR sky130_fd_sc_hd__diode_2
XANTENNA_104 S2MID[6] VGND VGND VPWR VPWR sky130_fd_sc_hd__diode_2
XFILLER_38_190 VGND VGND VPWR VPWR sky130_fd_sc_hd__decap_3
XFILLER_45_149 VGND VGND VPWR VPWR sky130_fd_sc_hd__decap_3
XANTENNA_126 net226 VGND VGND VPWR VPWR sky130_fd_sc_hd__diode_2
XTAP_TAPCELL_ROW_28_358 VGND VPWR sky130_fd_sc_hd__tapvpwrvgnd_1
XANTENNA_148 W6END[1] VGND VGND VPWR VPWR sky130_fd_sc_hd__diode_2
XANTENNA_137 W2END[6] VGND VGND VPWR VPWR sky130_fd_sc_hd__diode_2
XTAP_TAPCELL_ROW_71_615 VGND VPWR sky130_fd_sc_hd__tapvpwrvgnd_1
XANTENNA_159 WW4END[3] VGND VGND VPWR VPWR sky130_fd_sc_hd__diode_2
XFILLER_53_160 VGND VGND VPWR VPWR sky130_fd_sc_hd__decap_3
XFILLER_41_344 VGND VGND VPWR VPWR sky130_fd_sc_hd__decap_3
XFILLER_14_62 VGND VGND VPWR VPWR sky130_fd_sc_hd__fill_2
XTAP_TAPCELL_ROW_11_258 VGND VPWR sky130_fd_sc_hd__tapvpwrvgnd_1
XFILLER_5_234 VGND VGND VPWR VPWR sky130_fd_sc_hd__decap_3
XFILLER_5_223 VGND VGND VPWR VPWR sky130_fd_sc_hd__fill_1
XFILLER_30_50 VGND VGND VPWR VPWR sky130_fd_sc_hd__decap_3
XFILLER_5_278 VGND VGND VPWR VPWR sky130_fd_sc_hd__fill_2
XFILLER_39_9 VGND VGND VPWR VPWR sky130_fd_sc_hd__decap_3
XTAP_TAPCELL_ROW_19_303 VGND VPWR sky130_fd_sc_hd__tapvpwrvgnd_1
XFILLER_76_274 VGND VGND VPWR VPWR sky130_fd_sc_hd__decap_3
XFILLER_51_108 VGND VGND VPWR VPWR sky130_fd_sc_hd__decap_3
XFILLER_44_193 VGND VGND VPWR VPWR sky130_fd_sc_hd__decap_3
X_0973_ N1END[1] N2END[5] E1END[1] E2END[5] Inst_SimpleCLB_ConfigMem.Inst_frame1_bit10.Q
+ Inst_SimpleCLB_ConfigMem.Inst_frame1_bit11.Q VGND VGND VPWR VPWR _0072_ sky130_fd_sc_hd__mux4_1
XFILLER_72_3 VGND VGND VPWR VPWR sky130_fd_sc_hd__fill_1
X_1525_ Inst_LC_LUT4c_frame_config_dffesr.c_reset_value _0088_ _0551_ VGND VGND VPWR
+ VPWR _0552_ sky130_fd_sc_hd__mux2_1
XFILLER_59_208 VGND VGND VPWR VPWR sky130_fd_sc_hd__decap_3
XFILLER_59_219 VGND VGND VPWR VPWR sky130_fd_sc_hd__decap_3
X_1456_ _0050_ _0247_ Inst_SimpleCLB_ConfigMem.Inst_frame13_bit10.Q VGND VGND VPWR
+ VPWR _0512_ sky130_fd_sc_hd__mux2_1
XTAP_TAPCELL_ROW_2_204 VGND VPWR sky130_fd_sc_hd__tapvpwrvgnd_1
X_1387_ Inst_SimpleCLB_ConfigMem.Inst_frame12_bit14.Q _0600_ _0451_ Inst_SimpleCLB_ConfigMem.Inst_frame12_bit15.Q
+ VGND VGND VPWR VPWR _0452_ sky130_fd_sc_hd__a211o_1
XFILLER_27_116 VGND VGND VPWR VPWR sky130_fd_sc_hd__decap_3
XFILLER_82_233 VGND VGND VPWR VPWR sky130_fd_sc_hd__decap_3
XFILLER_23_311 VGND VGND VPWR VPWR sky130_fd_sc_hd__decap_3
XTAP_TAPCELL_ROW_25_339 VGND VPWR sky130_fd_sc_hd__tapvpwrvgnd_1
X_2008_ net778 net676 VGND VGND VPWR VPWR Inst_SimpleCLB_ConfigMem.Inst_frame4_bit19.Q
+ sky130_fd_sc_hd__dlxtp_1
XFILLER_50_141 VGND VGND VPWR VPWR sky130_fd_sc_hd__decap_3
XFILLER_4_6 VGND VGND VPWR VPWR sky130_fd_sc_hd__fill_1
XFILLER_76_24 VGND VGND VPWR VPWR sky130_fd_sc_hd__decap_3
XFILLER_58_241 VGND VGND VPWR VPWR sky130_fd_sc_hd__decap_3
XFILLER_76_79 VGND VGND VPWR VPWR sky130_fd_sc_hd__decap_3
XFILLER_33_119 VGND VGND VPWR VPWR sky130_fd_sc_hd__decap_3
X_1310_ net652 N2END[1] N4END[1] net802 Inst_SimpleCLB_ConfigMem.Inst_frame5_bit26.Q
+ Inst_SimpleCLB_ConfigMem.Inst_frame5_bit27.Q VGND VGND VPWR VPWR _0386_ sky130_fd_sc_hd__mux4_1
X_2290_ Inst_SimpleCLB_switch_matrix.N4BEG1 VGND VGND VPWR VPWR net126 sky130_fd_sc_hd__buf_1
XPHY_EDGE_ROW_16_Left_107 VGND VGND VPWR VPWR sky130_fd_sc_hd__decap_3
X_1241_ _0075_ _0076_ _0068_ _0067_ Inst_SimpleCLB_ConfigMem.Inst_frame9_bit14.Q Inst_SimpleCLB_ConfigMem.Inst_frame9_bit15.Q
+ VGND VGND VPWR VPWR _0325_ sky130_fd_sc_hd__mux4_1
XFILLER_2_65 VGND VGND VPWR VPWR sky130_fd_sc_hd__decap_3
XFILLER_49_252 VGND VGND VPWR VPWR sky130_fd_sc_hd__decap_3
X_1172_ _0257_ _0245_ VGND VGND VPWR VPWR _0259_ sky130_fd_sc_hd__nor2_4
XFILLER_64_233 VGND VGND VPWR VPWR sky130_fd_sc_hd__decap_3
XTAP_TAPCELL_ROW_90_732 VGND VPWR sky130_fd_sc_hd__tapvpwrvgnd_1
XTAP_TAPCELL_ROW_47_475 VGND VPWR sky130_fd_sc_hd__tapvpwrvgnd_1
XFILLER_32_141 VGND VGND VPWR VPWR sky130_fd_sc_hd__decap_3
XPHY_EDGE_ROW_25_Left_116 VGND VGND VPWR VPWR sky130_fd_sc_hd__decap_3
XANTENNA_48 FrameStrobe[14] VGND VGND VPWR VPWR sky130_fd_sc_hd__diode_2
XANTENNA_37 FrameData[21] VGND VGND VPWR VPWR sky130_fd_sc_hd__diode_2
XFILLER_32_185 VGND VGND VPWR VPWR sky130_fd_sc_hd__fill_1
XANTENNA_15 EE4END[11] VGND VGND VPWR VPWR sky130_fd_sc_hd__diode_2
XANTENNA_26 FrameData[0] VGND VGND VPWR VPWR sky130_fd_sc_hd__diode_2
XANTENNA_59 net96 VGND VGND VPWR VPWR sky130_fd_sc_hd__diode_2
X_0956_ net257 net260 VGND VGND VPWR VPWR _0056_ sky130_fd_sc_hd__or2_4
Xoutput100 net100 VGND VGND VPWR VPWR FrameStrobe_O[8] sky130_fd_sc_hd__buf_2
X_0887_ NN4END[3] S2END[6] E2END[6] W2END[6] Inst_SimpleCLB_ConfigMem.Inst_frame5_bit3.Q
+ Inst_SimpleCLB_ConfigMem.Inst_frame5_bit2.Q VGND VGND VPWR VPWR _0713_ sky130_fd_sc_hd__mux4_2
Xoutput111 Inst_SimpleCLB_switch_matrix.JN2BEG5 VGND VGND VPWR VPWR N2BEG[5] sky130_fd_sc_hd__buf_6
Xoutput133 net133 VGND VGND VPWR VPWR N4BEG[5] sky130_fd_sc_hd__buf_2
Xoutput122 net122 VGND VGND VPWR VPWR N4BEG[0] sky130_fd_sc_hd__buf_2
Xoutput144 Inst_SimpleCLB_switch_matrix.NN4BEG3 VGND VGND VPWR VPWR NN4BEG[15] sky130_fd_sc_hd__buf_8
Xoutput155 net155 VGND VGND VPWR VPWR S1BEG[1] sky130_fd_sc_hd__buf_4
Xoutput177 net177 VGND VGND VPWR VPWR S4BEG[12] sky130_fd_sc_hd__buf_2
Xoutput166 net166 VGND VGND VPWR VPWR S2BEGb[0] sky130_fd_sc_hd__buf_2
XPHY_EDGE_ROW_34_Left_125 VGND VGND VPWR VPWR sky130_fd_sc_hd__decap_3
Xoutput188 net188 VGND VGND VPWR VPWR S4BEG[8] sky130_fd_sc_hd__buf_2
Xoutput199 net199 VGND VGND VPWR VPWR SS4BEG[3] sky130_fd_sc_hd__buf_2
X_1508_ Inst_SimpleCLB_ConfigMem.Inst_frame0_bit27.Q _0535_ Inst_SimpleCLB_ConfigMem.Inst_frame0_bit28.Q
+ VGND VGND VPWR VPWR _0538_ sky130_fd_sc_hd__a21bo_1
X_1439_ _0496_ _0497_ Inst_SimpleCLB_ConfigMem.Inst_frame13_bit21.Q VGND VGND VPWR
+ VPWR Inst_SimpleCLB_switch_matrix.NN4BEG3 sky130_fd_sc_hd__mux2_4
XTAP_TAPCELL_ROW_38_420 VGND VPWR sky130_fd_sc_hd__tapvpwrvgnd_1
XFILLER_46_27 VGND VGND VPWR VPWR sky130_fd_sc_hd__fill_1
XFILLER_46_38 VGND VGND VPWR VPWR sky130_fd_sc_hd__decap_3
XFILLER_70_236 VGND VGND VPWR VPWR sky130_fd_sc_hd__decap_3
XFILLER_23_130 VGND VGND VPWR VPWR sky130_fd_sc_hd__fill_2
XPHY_EDGE_ROW_43_Left_134 VGND VGND VPWR VPWR sky130_fd_sc_hd__decap_3
XFILLER_62_59 VGND VGND VPWR VPWR sky130_fd_sc_hd__fill_2
XFILLER_23_185 VGND VGND VPWR VPWR sky130_fd_sc_hd__decap_3
XPHY_EDGE_ROW_52_Left_143 VGND VGND VPWR VPWR sky130_fd_sc_hd__decap_3
XFILLER_2_3 VGND VGND VPWR VPWR sky130_fd_sc_hd__fill_1
XFILLER_46_211 VGND VGND VPWR VPWR sky130_fd_sc_hd__fill_1
XFILLER_46_244 VGND VGND VPWR VPWR sky130_fd_sc_hd__decap_3
XPHY_EDGE_ROW_61_Left_152 VGND VGND VPWR VPWR sky130_fd_sc_hd__decap_3
XTAP_TAPCELL_ROW_44_456 VGND VPWR sky130_fd_sc_hd__tapvpwrvgnd_1
XFILLER_14_163 VGND VGND VPWR VPWR sky130_fd_sc_hd__decap_3
XFILLER_14_141 VGND VGND VPWR VPWR sky130_fd_sc_hd__decap_3
X_0810_ _0642_ _0641_ Inst_SimpleCLB_ConfigMem.Inst_frame4_bit0.Q VGND VGND VPWR VPWR
+ _0643_ sky130_fd_sc_hd__mux2_1
X_1790_ net763 net723 VGND VGND VPWR VPWR Inst_SimpleCLB_ConfigMem.Inst_frame11_bit25.Q
+ sky130_fd_sc_hd__dlxtp_1
X_0741_ Inst_SimpleCLB_ConfigMem.Inst_frame2_bit1.Q VGND VGND VPWR VPWR _0577_ sky130_fd_sc_hd__inv_1
XPHY_EDGE_ROW_70_Left_161 VGND VGND VPWR VPWR sky130_fd_sc_hd__decap_3
X_2342_ Inst_SimpleCLB_switch_matrix.S4BEG1 VGND VGND VPWR VPWR net178 sky130_fd_sc_hd__buf_1
XFILLER_35_3 VGND VGND VPWR VPWR sky130_fd_sc_hd__decap_3
XFILLER_69_325 VGND VGND VPWR VPWR sky130_fd_sc_hd__fill_1
X_2273_ N2MID[4] VGND VGND VPWR VPWR net118 sky130_fd_sc_hd__clkbuf_2
X_1224_ Inst_LH_LUT4c_frame_config_dffesr.inst_cus_mux161_buf.A15 _0293_ _0294_ Inst_LH_LUT4c_frame_config_dffesr.inst_cus_mux161_buf.A13
+ VGND VGND VPWR VPWR _0309_ sky130_fd_sc_hd__o22a_1
XFILLER_37_211 VGND VGND VPWR VPWR sky130_fd_sc_hd__decap_3
XFILLER_37_266 VGND VGND VPWR VPWR sky130_fd_sc_hd__decap_3
X_1155_ net800 S4END[1] WW4END[3] Inst_SimpleCLB_switch_matrix.JS2BEG4 Inst_SimpleCLB_ConfigMem.Inst_frame0_bit22.Q
+ Inst_SimpleCLB_ConfigMem.Inst_frame0_bit23.Q VGND VGND VPWR VPWR _0243_ sky130_fd_sc_hd__mux4_2
XTAP_TAPCELL_ROW_35_401 VGND VPWR sky130_fd_sc_hd__tapvpwrvgnd_1
XFILLER_52_225 VGND VGND VPWR VPWR sky130_fd_sc_hd__decap_3
X_1086_ Inst_SimpleCLB_ConfigMem.Inst_frame1_bit16.Q _0178_ VGND VGND VPWR VPWR _0179_
+ sky130_fd_sc_hd__and2b_1
XFILLER_52_236 VGND VGND VPWR VPWR sky130_fd_sc_hd__decap_3
XFILLER_60_291 VGND VGND VPWR VPWR sky130_fd_sc_hd__decap_3
XFILLER_20_188 VGND VGND VPWR VPWR sky130_fd_sc_hd__decap_3
X_1988_ net748 net672 VGND VGND VPWR VPWR Inst_SimpleCLB_ConfigMem.Inst_frame5_bit31.Q
+ sky130_fd_sc_hd__dlxtp_1
X_0939_ N4END[2] E2END[2] W2END[7] Inst_SimpleCLB_switch_matrix.E2BEG2 Inst_SimpleCLB_ConfigMem.Inst_frame0_bit4.Q
+ Inst_SimpleCLB_ConfigMem.Inst_frame0_bit5.Q VGND VGND VPWR VPWR _0040_ sky130_fd_sc_hd__mux4_2
XFILLER_57_15 VGND VGND VPWR VPWR sky130_fd_sc_hd__fill_1
XFILLER_57_37 VGND VGND VPWR VPWR sky130_fd_sc_hd__fill_1
XTAP_TAPCELL_ROW_58_537 VGND VPWR sky130_fd_sc_hd__tapvpwrvgnd_1
XFILLER_28_233 VGND VGND VPWR VPWR sky130_fd_sc_hd__decap_3
XFILLER_28_299 VGND VGND VPWR VPWR sky130_fd_sc_hd__decap_3
XFILLER_43_203 VGND VGND VPWR VPWR sky130_fd_sc_hd__fill_2
XFILLER_43_214 VGND VGND VPWR VPWR sky130_fd_sc_hd__decap_3
XFILLER_43_225 VGND VGND VPWR VPWR sky130_fd_sc_hd__fill_1
XFILLER_73_69 VGND VGND VPWR VPWR sky130_fd_sc_hd__decap_3
XFILLER_11_122 VGND VGND VPWR VPWR sky130_fd_sc_hd__fill_1
XFILLER_11_111 VGND VGND VPWR VPWR sky130_fd_sc_hd__fill_1
XTAP_TAPCELL_ROW_41_437 VGND VPWR sky130_fd_sc_hd__tapvpwrvgnd_1
XFILLER_11_199 VGND VGND VPWR VPWR sky130_fd_sc_hd__decap_3
XPHY_EDGE_ROW_5_Left_96 VGND VGND VPWR VPWR sky130_fd_sc_hd__decap_3
XFILLER_19_200 VGND VGND VPWR VPWR sky130_fd_sc_hd__decap_3
X_1911_ net780 net665 VGND VGND VPWR VPWR Inst_SimpleCLB_ConfigMem.Inst_frame7_bit18.Q
+ sky130_fd_sc_hd__dlxtp_1
XFILLER_8_20 VGND VGND VPWR VPWR sky130_fd_sc_hd__decap_3
X_1842_ net790 net656 VGND VGND VPWR VPWR Inst_SimpleCLB_ConfigMem.Inst_frame9_bit13.Q
+ sky130_fd_sc_hd__dlxtp_1
XFILLER_8_64 VGND VGND VPWR VPWR sky130_fd_sc_hd__decap_3
XFILLER_8_97 VGND VGND VPWR VPWR sky130_fd_sc_hd__decap_3
X_1773_ net736 net720 VGND VGND VPWR VPWR Inst_SimpleCLB_ConfigMem.Inst_frame11_bit8.Q
+ sky130_fd_sc_hd__dlxtp_1
XFILLER_6_192 VGND VGND VPWR VPWR sky130_fd_sc_hd__decap_3
XFILLER_69_100 VGND VGND VPWR VPWR sky130_fd_sc_hd__decap_3
XFILLER_69_122 VGND VGND VPWR VPWR sky130_fd_sc_hd__decap_3
XFILLER_69_166 VGND VGND VPWR VPWR sky130_fd_sc_hd__fill_2
X_2325_ S2MID[4] VGND VGND VPWR VPWR net170 sky130_fd_sc_hd__clkbuf_2
X_2256_ FrameStrobe[19] VGND VGND VPWR VPWR net92 sky130_fd_sc_hd__clkbuf_1
XFILLER_84_136 VGND VGND VPWR VPWR sky130_fd_sc_hd__decap_3
XFILLER_69_199 VGND VGND VPWR VPWR sky130_fd_sc_hd__fill_1
XFILLER_84_147 VGND VGND VPWR VPWR sky130_fd_sc_hd__decap_3
X_1207_ _0290_ _0291_ VGND VGND VPWR VPWR _0292_ sky130_fd_sc_hd__nand2b_4
X_2187_ Inst_SimpleCLB_switch_matrix.E6BEG0 VGND VGND VPWR VPWR net23 sky130_fd_sc_hd__clkbuf_2
XFILLER_25_214 VGND VGND VPWR VPWR sky130_fd_sc_hd__decap_3
XTAP_TAPCELL_ROW_55_518 VGND VPWR sky130_fd_sc_hd__tapvpwrvgnd_1
XFILLER_25_225 VGND VGND VPWR VPWR sky130_fd_sc_hd__decap_3
X_1138_ Inst_SimpleCLB_ConfigMem.Inst_frame8_bit6.Q _0226_ Inst_SimpleCLB_ConfigMem.Inst_frame8_bit7.Q
+ VGND VGND VPWR VPWR _0227_ sky130_fd_sc_hd__a21o_1
X_1069_ _0014_ _0055_ _0057_ VGND VGND VPWR VPWR _0162_ sky130_fd_sc_hd__o21ai_2
XFILLER_0_324 VGND VGND VPWR VPWR sky130_fd_sc_hd__decap_3
XFILLER_68_69 VGND VGND VPWR VPWR sky130_fd_sc_hd__decap_3
XFILLER_75_125 VGND VGND VPWR VPWR sky130_fd_sc_hd__decap_3
XFILLER_84_35 VGND VGND VPWR VPWR sky130_fd_sc_hd__decap_3
XFILLER_16_236 VGND VGND VPWR VPWR sky130_fd_sc_hd__decap_3
XFILLER_31_217 VGND VGND VPWR VPWR sky130_fd_sc_hd__fill_1
XFILLER_31_228 VGND VGND VPWR VPWR sky130_fd_sc_hd__fill_2
XFILLER_33_72 VGND VGND VPWR VPWR sky130_fd_sc_hd__decap_3
XFILLER_33_94 VGND VGND VPWR VPWR sky130_fd_sc_hd__decap_3
XFILLER_69_9 VGND VGND VPWR VPWR sky130_fd_sc_hd__decap_3
XFILLER_3_184 VGND VGND VPWR VPWR sky130_fd_sc_hd__fill_1
X_2110_ net762 net688 VGND VGND VPWR VPWR Inst_SimpleCLB_ConfigMem.Inst_frame1_bit25.Q
+ sky130_fd_sc_hd__dlxtp_1
XFILLER_58_80 VGND VGND VPWR VPWR sky130_fd_sc_hd__decap_3
X_2041_ net774 net681 VGND VGND VPWR VPWR Inst_SimpleCLB_ConfigMem.Inst_frame3_bit20.Q
+ sky130_fd_sc_hd__dlxtp_1
XTAP_TAPCELL_ROW_77_654 VGND VPWR sky130_fd_sc_hd__tapvpwrvgnd_1
XFILLER_22_206 VGND VGND VPWR VPWR sky130_fd_sc_hd__decap_3
XFILLER_22_239 VGND VGND VPWR VPWR sky130_fd_sc_hd__decap_3
XFILLER_30_261 VGND VGND VPWR VPWR sky130_fd_sc_hd__decap_3
X_1825_ net757 net725 VGND VGND VPWR VPWR Inst_SimpleCLB_ConfigMem.Inst_frame10_bit28.Q
+ sky130_fd_sc_hd__dlxtp_1
XFILLER_30_283 VGND VGND VPWR VPWR sky130_fd_sc_hd__decap_3
X_1756_ net767 net716 VGND VGND VPWR VPWR Inst_SimpleCLB_ConfigMem.Inst_frame12_bit23.Q
+ sky130_fd_sc_hd__dlxtp_1
X_1687_ net781 net707 VGND VGND VPWR VPWR Inst_LH_LUT4c_frame_config_dffesr.inst_cus_mux161_buf.A11
+ sky130_fd_sc_hd__dlxtp_1
XFILLER_57_125 VGND VGND VPWR VPWR sky130_fd_sc_hd__fill_1
XFILLER_57_169 VGND VGND VPWR VPWR sky130_fd_sc_hd__decap_3
X_2239_ net686 VGND VGND VPWR VPWR net94 sky130_fd_sc_hd__clkbuf_2
XFILLER_54_38 VGND VGND VPWR VPWR sky130_fd_sc_hd__decap_3
XFILLER_72_139 VGND VGND VPWR VPWR sky130_fd_sc_hd__fill_1
XFILLER_13_206 VGND VGND VPWR VPWR sky130_fd_sc_hd__decap_3
XTAP_TAPCELL_ROW_0_187 VGND VPWR sky130_fd_sc_hd__tapvpwrvgnd_1
XFILLER_80_150 VGND VGND VPWR VPWR sky130_fd_sc_hd__decap_3
XFILLER_13_228 VGND VGND VPWR VPWR sky130_fd_sc_hd__decap_3
XFILLER_70_15 VGND VGND VPWR VPWR sky130_fd_sc_hd__fill_1
XFILLER_21_250 VGND VGND VPWR VPWR sky130_fd_sc_hd__decap_3
XFILLER_79_57 VGND VGND VPWR VPWR sky130_fd_sc_hd__decap_3
XFILLER_0_110 VGND VGND VPWR VPWR sky130_fd_sc_hd__fill_2
XTAP_TAPCELL_ROW_74_635 VGND VPWR sky130_fd_sc_hd__tapvpwrvgnd_1
XFILLER_44_71 VGND VGND VPWR VPWR sky130_fd_sc_hd__decap_3
XFILLER_71_172 VGND VGND VPWR VPWR sky130_fd_sc_hd__decap_3
XFILLER_8_221 VGND VGND VPWR VPWR sky130_fd_sc_hd__decap_3
XFILLER_81_8 VGND VGND VPWR VPWR sky130_fd_sc_hd__decap_3
X_1610_ net741 net702 VGND VGND VPWR VPWR Inst_LD_LUT4c_frame_config_dffesr.inst_cus_mux161_buf.A10
+ sky130_fd_sc_hd__dlxtp_1
XFILLER_60_81 VGND VGND VPWR VPWR sky130_fd_sc_hd__decap_3
XFILLER_5_10 VGND VGND VPWR VPWR sky130_fd_sc_hd__fill_2
X_1541_ Inst_LG_LUT4c_frame_config_dffesr.c_reset_value _0285_ _0563_ VGND VGND VPWR
+ VPWR _0564_ sky130_fd_sc_hd__mux2_1
X_1472_ net801 S4END[2] S2END[3] net268 Inst_SimpleCLB_ConfigMem.Inst_frame12_bit29.Q
+ Inst_SimpleCLB_ConfigMem.Inst_frame12_bit28.Q VGND VGND VPWR VPWR Inst_SimpleCLB_switch_matrix.S4BEG1
+ sky130_fd_sc_hd__mux4_1
XFILLER_39_136 VGND VGND VPWR VPWR sky130_fd_sc_hd__decap_3
X_2024_ net746 net680 VGND VGND VPWR VPWR Inst_SimpleCLB_ConfigMem.Inst_frame3_bit3.Q
+ sky130_fd_sc_hd__dlxtp_1
XFILLER_24_19 VGND VGND VPWR VPWR sky130_fd_sc_hd__decap_3
XFILLER_10_209 VGND VGND VPWR VPWR sky130_fd_sc_hd__decap_3
XFILLER_40_18 VGND VGND VPWR VPWR sky130_fd_sc_hd__decap_3
X_1808_ net795 net724 VGND VGND VPWR VPWR Inst_SimpleCLB_ConfigMem.Inst_frame10_bit11.Q
+ sky130_fd_sc_hd__dlxtp_1
XFILLER_40_29 VGND VGND VPWR VPWR sky130_fd_sc_hd__decap_3
X_1739_ net740 net718 VGND VGND VPWR VPWR Inst_SimpleCLB_ConfigMem.Inst_frame12_bit6.Q
+ sky130_fd_sc_hd__dlxtp_1
XFILLER_49_27 VGND VGND VPWR VPWR sky130_fd_sc_hd__decap_3
XTAP_TAPCELL_ROW_88_716 VGND VPWR sky130_fd_sc_hd__tapvpwrvgnd_1
Xfanout701 net702 VGND VGND VPWR VPWR net701 sky130_fd_sc_hd__dlymetal6s2s_1
Xfanout712 net713 VGND VGND VPWR VPWR net712 sky130_fd_sc_hd__buf_2
Xfanout723 FrameStrobe[11] VGND VGND VPWR VPWR net723 sky130_fd_sc_hd__buf_4
Xfanout734 FrameData[9] VGND VGND VPWR VPWR net734 sky130_fd_sc_hd__buf_4
Xfanout756 net757 VGND VGND VPWR VPWR net756 sky130_fd_sc_hd__clkbuf_4
Xfanout767 FrameData[23] VGND VGND VPWR VPWR net767 sky130_fd_sc_hd__buf_4
Xfanout745 net746 VGND VGND VPWR VPWR net745 sky130_fd_sc_hd__clkbuf_4
Xfanout778 net779 VGND VGND VPWR VPWR net778 sky130_fd_sc_hd__clkbuf_4
XFILLER_85_231 VGND VGND VPWR VPWR sky130_fd_sc_hd__decap_3
Xfanout789 FrameData[14] VGND VGND VPWR VPWR net789 sky130_fd_sc_hd__buf_4
XFILLER_45_106 VGND VGND VPWR VPWR sky130_fd_sc_hd__decap_3
XANTENNA_105 net189 VGND VGND VPWR VPWR sky130_fd_sc_hd__diode_2
XANTENNA_116 SS4END[0] VGND VGND VPWR VPWR sky130_fd_sc_hd__diode_2
XANTENNA_127 W2END[0] VGND VGND VPWR VPWR sky130_fd_sc_hd__diode_2
XTAP_TAPCELL_ROW_28_359 VGND VPWR sky130_fd_sc_hd__tapvpwrvgnd_1
XANTENNA_149 WW4END[0] VGND VGND VPWR VPWR sky130_fd_sc_hd__diode_2
XANTENNA_138 W2END[6] VGND VGND VPWR VPWR sky130_fd_sc_hd__diode_2
XTAP_TAPCELL_ROW_71_616 VGND VPWR sky130_fd_sc_hd__tapvpwrvgnd_1
XFILLER_81_14 VGND VGND VPWR VPWR sky130_fd_sc_hd__fill_1
XFILLER_81_25 VGND VGND VPWR VPWR sky130_fd_sc_hd__decap_3
XTAP_TAPCELL_ROW_11_259 VGND VPWR sky130_fd_sc_hd__tapvpwrvgnd_1
XFILLER_5_202 VGND VGND VPWR VPWR sky130_fd_sc_hd__decap_3
XFILLER_5_246 VGND VGND VPWR VPWR sky130_fd_sc_hd__decap_3
XFILLER_68_209 VGND VGND VPWR VPWR sky130_fd_sc_hd__decap_3
XFILLER_39_60 VGND VGND VPWR VPWR sky130_fd_sc_hd__decap_3
XFILLER_39_93 VGND VGND VPWR VPWR sky130_fd_sc_hd__decap_3
XTAP_TAPCELL_ROW_19_304 VGND VPWR sky130_fd_sc_hd__tapvpwrvgnd_1
XFILLER_76_253 VGND VGND VPWR VPWR sky130_fd_sc_hd__decap_3
XFILLER_17_331 VGND VGND VPWR VPWR sky130_fd_sc_hd__decap_3
XFILLER_29_191 VGND VGND VPWR VPWR sky130_fd_sc_hd__decap_3
XFILLER_55_81 VGND VGND VPWR VPWR sky130_fd_sc_hd__decap_3
XFILLER_32_345 VGND VGND VPWR VPWR sky130_fd_sc_hd__fill_2
X_0972_ _0070_ _0069_ Inst_SimpleCLB_ConfigMem.Inst_frame1_bit12.Q VGND VGND VPWR
+ VPWR _0071_ sky130_fd_sc_hd__mux2_4
X_1524_ Inst_SimpleCLB_ConfigMem.Inst_frame9_bit6.Q _0539_ VGND VGND VPWR VPWR _0551_
+ sky130_fd_sc_hd__nand2_1
X_1455_ _0509_ _0510_ _0511_ Inst_SimpleCLB_ConfigMem.Inst_frame13_bit15.Q VGND VGND
+ VPWR VPWR Inst_SimpleCLB_switch_matrix.NN4BEG1 sky130_fd_sc_hd__o22a_1
X_1386_ Inst_SimpleCLB_ConfigMem.Inst_frame12_bit14.Q net643 VGND VGND VPWR VPWR _0451_
+ sky130_fd_sc_hd__nor2_1
XTAP_TAPCELL_ROW_2_205 VGND VPWR sky130_fd_sc_hd__tapvpwrvgnd_1
XFILLER_67_253 VGND VGND VPWR VPWR sky130_fd_sc_hd__decap_3
XFILLER_27_128 VGND VGND VPWR VPWR sky130_fd_sc_hd__decap_3
XFILLER_27_139 VGND VGND VPWR VPWR sky130_fd_sc_hd__decap_3
XFILLER_82_267 VGND VGND VPWR VPWR sky130_fd_sc_hd__decap_3
XFILLER_82_245 VGND VGND VPWR VPWR sky130_fd_sc_hd__decap_3
XFILLER_35_18 VGND VGND VPWR VPWR sky130_fd_sc_hd__fill_1
XFILLER_42_109 VGND VGND VPWR VPWR sky130_fd_sc_hd__decap_3
X_2007_ net780 net678 VGND VGND VPWR VPWR Inst_SimpleCLB_ConfigMem.Inst_frame4_bit18.Q
+ sky130_fd_sc_hd__dlxtp_1
XFILLER_35_161 VGND VGND VPWR VPWR sky130_fd_sc_hd__decap_3
XFILLER_35_172 VGND VGND VPWR VPWR sky130_fd_sc_hd__decap_3
XFILLER_50_197 VGND VGND VPWR VPWR sky130_fd_sc_hd__decap_3
XFILLER_18_117 VGND VGND VPWR VPWR sky130_fd_sc_hd__decap_3
XFILLER_33_109 VGND VGND VPWR VPWR sky130_fd_sc_hd__decap_3
XFILLER_73_267 VGND VGND VPWR VPWR sky130_fd_sc_hd__fill_1
XFILLER_14_301 VGND VGND VPWR VPWR sky130_fd_sc_hd__decap_3
XFILLER_26_150 VGND VGND VPWR VPWR sky130_fd_sc_hd__decap_3
Xrebuffer91 Inst_LH_LUT4c_frame_config_dffesr.O VGND VGND VPWR VPWR net345 sky130_fd_sc_hd__dlygate4sd1_1
XFILLER_41_164 VGND VGND VPWR VPWR sky130_fd_sc_hd__decap_3
XFILLER_41_175 VGND VGND VPWR VPWR sky130_fd_sc_hd__decap_3
XFILLER_2_44 VGND VGND VPWR VPWR sky130_fd_sc_hd__decap_3
X_1240_ _0321_ _0322_ _0323_ VGND VGND VPWR VPWR _0324_ sky130_fd_sc_hd__and3_1
XFILLER_49_220 VGND VGND VPWR VPWR sky130_fd_sc_hd__decap_3
XFILLER_49_231 VGND VGND VPWR VPWR sky130_fd_sc_hd__decap_3
X_1171_ _0257_ net263 VGND VGND VPWR VPWR _0258_ sky130_fd_sc_hd__nand2_4
XFILLER_2_77 VGND VGND VPWR VPWR sky130_fd_sc_hd__decap_3
XFILLER_49_264 VGND VGND VPWR VPWR sky130_fd_sc_hd__decap_3
XFILLER_64_256 VGND VGND VPWR VPWR sky130_fd_sc_hd__decap_3
XTAP_TAPCELL_ROW_90_733 VGND VPWR sky130_fd_sc_hd__tapvpwrvgnd_1
XFILLER_17_172 VGND VGND VPWR VPWR sky130_fd_sc_hd__decap_3
XFILLER_24_109 VGND VGND VPWR VPWR sky130_fd_sc_hd__decap_3
XFILLER_32_153 VGND VGND VPWR VPWR sky130_fd_sc_hd__decap_3
XFILLER_32_197 VGND VGND VPWR VPWR sky130_fd_sc_hd__decap_3
XANTENNA_38 FrameData[3] VGND VGND VPWR VPWR sky130_fd_sc_hd__diode_2
XANTENNA_27 FrameData[0] VGND VGND VPWR VPWR sky130_fd_sc_hd__diode_2
XANTENNA_16 EE4END[12] VGND VGND VPWR VPWR sky130_fd_sc_hd__diode_2
X_0955_ _0033_ net262 VGND VGND VPWR VPWR _0055_ sky130_fd_sc_hd__nor2_8
XANTENNA_49 FrameStrobe[15] VGND VGND VPWR VPWR sky130_fd_sc_hd__diode_2
X_0886_ Inst_SimpleCLB_ConfigMem.Inst_frame10_bit30.Q _0711_ VGND VGND VPWR VPWR _0712_
+ sky130_fd_sc_hd__nand2_1
Xoutput101 net101 VGND VGND VPWR VPWR FrameStrobe_O[9] sky130_fd_sc_hd__buf_2
Xoutput123 net123 VGND VGND VPWR VPWR N4BEG[10] sky130_fd_sc_hd__buf_2
Xoutput134 net134 VGND VGND VPWR VPWR N4BEG[6] sky130_fd_sc_hd__buf_2
Xoutput112 net112 VGND VGND VPWR VPWR N2BEG[6] sky130_fd_sc_hd__buf_8
Xoutput145 net145 VGND VGND VPWR VPWR NN4BEG[1] sky130_fd_sc_hd__buf_2
Xoutput167 net167 VGND VGND VPWR VPWR S2BEGb[1] sky130_fd_sc_hd__buf_2
Xoutput156 Inst_SimpleCLB_switch_matrix.S1BEG2 VGND VGND VPWR VPWR S1BEG[2] sky130_fd_sc_hd__buf_6
Xoutput189 net189 VGND VGND VPWR VPWR S4BEG[9] sky130_fd_sc_hd__buf_2
Xoutput178 net178 VGND VGND VPWR VPWR S4BEG[13] sky130_fd_sc_hd__buf_2
X_1507_ Inst_SimpleCLB_ConfigMem.Inst_frame0_bit27.Q _0536_ VGND VGND VPWR VPWR _0537_
+ sky130_fd_sc_hd__and2b_1
X_1438_ net267 net261 _0241_ _0618_ Inst_SimpleCLB_ConfigMem.Inst_frame13_bit19.Q
+ Inst_SimpleCLB_ConfigMem.Inst_frame13_bit20.Q VGND VGND VPWR VPWR _0497_ sky130_fd_sc_hd__mux4_2
X_1369_ Inst_SimpleCLB_ConfigMem.Inst_frame11_bit9.Q _0436_ _0434_ Inst_SimpleCLB_ConfigMem.Inst_frame11_bit10.Q
+ VGND VGND VPWR VPWR _0437_ sky130_fd_sc_hd__o211a_1
XTAP_TAPCELL_ROW_38_421 VGND VPWR sky130_fd_sc_hd__tapvpwrvgnd_1
XFILLER_55_223 VGND VGND VPWR VPWR sky130_fd_sc_hd__fill_1
XFILLER_55_234 VGND VGND VPWR VPWR sky130_fd_sc_hd__decap_3
XFILLER_62_27 VGND VGND VPWR VPWR sky130_fd_sc_hd__fill_1
XFILLER_70_248 VGND VGND VPWR VPWR sky130_fd_sc_hd__decap_3
XFILLER_70_259 VGND VGND VPWR VPWR sky130_fd_sc_hd__decap_3
XFILLER_62_38 VGND VGND VPWR VPWR sky130_fd_sc_hd__decap_3
XFILLER_11_337 VGND VGND VPWR VPWR sky130_fd_sc_hd__decap_3
XFILLER_7_319 VGND VGND VPWR VPWR sky130_fd_sc_hd__decap_3
XFILLER_87_57 VGND VGND VPWR VPWR sky130_fd_sc_hd__decap_3
XFILLER_14_131 VGND VGND VPWR VPWR sky130_fd_sc_hd__decap_3
XFILLER_14_120 VGND VGND VPWR VPWR sky130_fd_sc_hd__decap_3
XFILLER_61_237 VGND VGND VPWR VPWR sky130_fd_sc_hd__decap_3
XFILLER_61_259 VGND VGND VPWR VPWR sky130_fd_sc_hd__decap_3
XFILLER_14_153 VGND VGND VPWR VPWR sky130_fd_sc_hd__decap_3
XTAP_TAPCELL_ROW_44_457 VGND VPWR sky130_fd_sc_hd__tapvpwrvgnd_1
X_0740_ Inst_SimpleCLB_ConfigMem.Inst_frame2_bit0.Q VGND VGND VPWR VPWR _0576_ sky130_fd_sc_hd__inv_2
XFILLER_6_330 VGND VGND VPWR VPWR sky130_fd_sc_hd__decap_3
X_2341_ Inst_SimpleCLB_switch_matrix.S4BEG0 VGND VGND VPWR VPWR net177 sky130_fd_sc_hd__buf_1
X_2272_ N2MID[3] VGND VGND VPWR VPWR net117 sky130_fd_sc_hd__buf_1
X_1223_ _0306_ _0307_ VGND VGND VPWR VPWR _0308_ sky130_fd_sc_hd__nand2_1
XFILLER_37_223 VGND VGND VPWR VPWR sky130_fd_sc_hd__fill_1
X_1154_ N2MID[5] E2MID[5] S2MID[5] W2MID[5] Inst_SimpleCLB_ConfigMem.Inst_frame6_bit22.Q
+ Inst_SimpleCLB_ConfigMem.Inst_frame6_bit23.Q VGND VGND VPWR VPWR _0242_ sky130_fd_sc_hd__mux4_1
XTAP_TAPCELL_ROW_35_402 VGND VPWR sky130_fd_sc_hd__tapvpwrvgnd_1
XFILLER_37_278 VGND VGND VPWR VPWR sky130_fd_sc_hd__fill_2
XFILLER_37_289 VGND VGND VPWR VPWR sky130_fd_sc_hd__fill_2
X_1085_ W2END[6] net638 net642 net629 Inst_SimpleCLB_ConfigMem.Inst_frame1_bit15.Q
+ Inst_SimpleCLB_ConfigMem.Inst_frame1_bit14.Q VGND VGND VPWR VPWR _0178_ sky130_fd_sc_hd__mux4_1
XFILLER_20_123 VGND VGND VPWR VPWR sky130_fd_sc_hd__decap_3
XFILLER_20_101 VGND VGND VPWR VPWR sky130_fd_sc_hd__decap_3
XFILLER_20_156 VGND VGND VPWR VPWR sky130_fd_sc_hd__decap_3
X_1987_ FrameData[30] net672 VGND VGND VPWR VPWR Inst_SimpleCLB_ConfigMem.Inst_frame5_bit30.Q
+ sky130_fd_sc_hd__dlxtp_1
X_0938_ _0039_ _0036_ Inst_SimpleCLB_ConfigMem.Inst_frame3_bit5.Q VGND VGND VPWR VPWR
+ Inst_SimpleCLB_switch_matrix.E2BEG2 sky130_fd_sc_hd__mux2_4
X_0869_ Inst_LA_LUT4c_frame_config_dffesr.inst_cus_mux161_buf.A12 Inst_LA_LUT4c_frame_config_dffesr.inst_cus_mux161_buf.A13
+ _0648_ VGND VGND VPWR VPWR _0697_ sky130_fd_sc_hd__mux2_1
XTAP_TAPCELL_ROW_58_538 VGND VPWR sky130_fd_sc_hd__tapvpwrvgnd_1
XFILLER_28_245 VGND VGND VPWR VPWR sky130_fd_sc_hd__decap_3
XFILLER_43_248 VGND VGND VPWR VPWR sky130_fd_sc_hd__decap_3
XTAP_TAPCELL_ROW_41_438 VGND VPWR sky130_fd_sc_hd__tapvpwrvgnd_1
XFILLER_11_178 VGND VGND VPWR VPWR sky130_fd_sc_hd__decap_3
XFILLER_7_116 VGND VGND VPWR VPWR sky130_fd_sc_hd__decap_3
XFILLER_22_85 VGND VGND VPWR VPWR sky130_fd_sc_hd__fill_1
XFILLER_78_134 VGND VGND VPWR VPWR sky130_fd_sc_hd__decap_3
XFILLER_19_223 VGND VGND VPWR VPWR sky130_fd_sc_hd__fill_1
XFILLER_34_215 VGND VGND VPWR VPWR sky130_fd_sc_hd__decap_3
XFILLER_34_248 VGND VGND VPWR VPWR sky130_fd_sc_hd__decap_3
X_1910_ net783 net663 VGND VGND VPWR VPWR Inst_SimpleCLB_ConfigMem.Inst_frame7_bit17.Q
+ sky130_fd_sc_hd__dlxtp_1
XFILLER_42_270 VGND VGND VPWR VPWR sky130_fd_sc_hd__decap_3
XFILLER_63_92 VGND VGND VPWR VPWR sky130_fd_sc_hd__fill_1
X_1841_ net793 net656 VGND VGND VPWR VPWR Inst_SimpleCLB_ConfigMem.Inst_frame9_bit12.Q
+ sky130_fd_sc_hd__dlxtp_1
XFILLER_8_76 VGND VGND VPWR VPWR sky130_fd_sc_hd__decap_3
X_1772_ net737 net721 VGND VGND VPWR VPWR Inst_SimpleCLB_ConfigMem.Inst_frame11_bit7.Q
+ sky130_fd_sc_hd__dlxtp_1
XFILLER_6_171 VGND VGND VPWR VPWR sky130_fd_sc_hd__decap_3
X_2324_ S2MID[3] VGND VGND VPWR VPWR net169 sky130_fd_sc_hd__clkbuf_2
XFILLER_69_134 VGND VGND VPWR VPWR sky130_fd_sc_hd__decap_3
XFILLER_84_115 VGND VGND VPWR VPWR sky130_fd_sc_hd__decap_3
X_2255_ net693 VGND VGND VPWR VPWR net91 sky130_fd_sc_hd__clkbuf_2
X_2186_ E6END[11] VGND VGND VPWR VPWR net33 sky130_fd_sc_hd__buf_1
X_1206_ _0255_ _0256_ _0247_ _0246_ Inst_SimpleCLB_ConfigMem.Inst_frame8_bit18.Q Inst_SimpleCLB_ConfigMem.Inst_frame8_bit19.Q
+ VGND VGND VPWR VPWR _0291_ sky130_fd_sc_hd__mux4_2
XFILLER_84_159 VGND VGND VPWR VPWR sky130_fd_sc_hd__decap_3
X_1137_ N2MID[7] E2MID[7] S2MID[7] W2MID[7] Inst_SimpleCLB_ConfigMem.Inst_frame6_bit18.Q
+ Inst_SimpleCLB_ConfigMem.Inst_frame6_bit19.Q VGND VGND VPWR VPWR _0226_ sky130_fd_sc_hd__mux4_1
XTAP_TAPCELL_ROW_55_519 VGND VPWR sky130_fd_sc_hd__tapvpwrvgnd_1
XFILLER_25_237 VGND VGND VPWR VPWR sky130_fd_sc_hd__decap_3
X_1068_ _0158_ _0159_ VGND VGND VPWR VPWR _0161_ sky130_fd_sc_hd__nand2_1
XFILLER_33_270 VGND VGND VPWR VPWR sky130_fd_sc_hd__decap_3
XFILLER_4_108 VGND VGND VPWR VPWR sky130_fd_sc_hd__decap_3
XFILLER_4_119 VGND VGND VPWR VPWR sky130_fd_sc_hd__fill_2
XFILLER_0_303 VGND VGND VPWR VPWR sky130_fd_sc_hd__decap_3
XFILLER_68_15 VGND VGND VPWR VPWR sky130_fd_sc_hd__decap_3
XFILLER_48_307 VGND VGND VPWR VPWR sky130_fd_sc_hd__fill_1
XFILLER_75_104 VGND VGND VPWR VPWR sky130_fd_sc_hd__decap_3
XFILLER_75_159 VGND VGND VPWR VPWR sky130_fd_sc_hd__decap_3
XFILLER_16_215 VGND VGND VPWR VPWR sky130_fd_sc_hd__decap_3
XFILLER_83_192 VGND VGND VPWR VPWR sky130_fd_sc_hd__decap_3
XFILLER_16_248 VGND VGND VPWR VPWR sky130_fd_sc_hd__decap_3
XFILLER_16_259 VGND VGND VPWR VPWR sky130_fd_sc_hd__decap_3
X_2040_ net779 net681 VGND VGND VPWR VPWR Inst_SimpleCLB_ConfigMem.Inst_frame3_bit19.Q
+ sky130_fd_sc_hd__dlxtp_1
XTAP_TAPCELL_ROW_77_655 VGND VPWR sky130_fd_sc_hd__tapvpwrvgnd_1
XFILLER_62_321 VGND VGND VPWR VPWR sky130_fd_sc_hd__fill_1
X_1824_ net758 net724 VGND VGND VPWR VPWR Inst_SimpleCLB_ConfigMem.Inst_frame10_bit27.Q
+ sky130_fd_sc_hd__dlxtp_1
XFILLER_30_295 VGND VGND VPWR VPWR sky130_fd_sc_hd__decap_3
X_1755_ net769 net716 VGND VGND VPWR VPWR Inst_SimpleCLB_ConfigMem.Inst_frame12_bit22.Q
+ sky130_fd_sc_hd__dlxtp_1
XFILLER_89_218 VGND VGND VPWR VPWR sky130_fd_sc_hd__decap_3
XFILLER_89_207 VGND VGND VPWR VPWR sky130_fd_sc_hd__decap_3
X_1686_ FrameData[17] net707 VGND VGND VPWR VPWR Inst_LH_LUT4c_frame_config_dffesr.inst_cus_mux161_buf.A10
+ sky130_fd_sc_hd__dlxtp_1
XFILLER_57_104 VGND VGND VPWR VPWR sky130_fd_sc_hd__decap_3
X_2307_ Inst_SimpleCLB_switch_matrix.NN4BEG2 VGND VGND VPWR VPWR net143 sky130_fd_sc_hd__clkbuf_2
XTAP_TAPCELL_ROW_68_600 VGND VPWR sky130_fd_sc_hd__tapvpwrvgnd_1
X_2238_ FrameStrobe[1] VGND VGND VPWR VPWR net93 sky130_fd_sc_hd__clkbuf_2
XFILLER_72_118 VGND VGND VPWR VPWR sky130_fd_sc_hd__decap_3
X_2169_ E2MID[0] VGND VGND VPWR VPWR net14 sky130_fd_sc_hd__clkbuf_2
XFILLER_54_17 VGND VGND VPWR VPWR sky130_fd_sc_hd__decap_3
XFILLER_65_181 VGND VGND VPWR VPWR sky130_fd_sc_hd__decap_3
XTAP_TAPCELL_ROW_0_188 VGND VPWR sky130_fd_sc_hd__tapvpwrvgnd_1
XFILLER_13_218 VGND VGND VPWR VPWR sky130_fd_sc_hd__decap_3
XFILLER_21_273 VGND VGND VPWR VPWR sky130_fd_sc_hd__decap_3
XFILLER_0_122 VGND VGND VPWR VPWR sky130_fd_sc_hd__decap_3
XFILLER_48_115 VGND VGND VPWR VPWR sky130_fd_sc_hd__decap_3
XFILLER_88_295 VGND VGND VPWR VPWR sky130_fd_sc_hd__decap_3
XFILLER_48_159 VGND VGND VPWR VPWR sky130_fd_sc_hd__decap_3
XTAP_TAPCELL_ROW_74_636 VGND VPWR sky130_fd_sc_hd__tapvpwrvgnd_1
XTAP_TAPCELL_ROW_82_680 VGND VPWR sky130_fd_sc_hd__tapvpwrvgnd_1
XFILLER_44_83 VGND VGND VPWR VPWR sky130_fd_sc_hd__fill_1
XFILLER_44_94 VGND VGND VPWR VPWR sky130_fd_sc_hd__decap_3
XFILLER_12_262 VGND VGND VPWR VPWR sky130_fd_sc_hd__fill_2
XFILLER_12_251 VGND VGND VPWR VPWR sky130_fd_sc_hd__fill_1
XFILLER_8_200 VGND VGND VPWR VPWR sky130_fd_sc_hd__decap_3
XFILLER_8_233 VGND VGND VPWR VPWR sky130_fd_sc_hd__decap_3
X_1540_ Inst_SimpleCLB_ConfigMem.Inst_frame8_bit14.Q _0539_ VGND VGND VPWR VPWR _0563_
+ sky130_fd_sc_hd__nand2_1
XFILLER_5_77 VGND VGND VPWR VPWR sky130_fd_sc_hd__decap_3
X_1471_ S2END[0] W6END[1] S4END[3] net628 Inst_SimpleCLB_ConfigMem.Inst_frame12_bit31.Q
+ Inst_SimpleCLB_ConfigMem.Inst_frame12_bit30.Q VGND VGND VPWR VPWR Inst_SimpleCLB_switch_matrix.S4BEG2
+ sky130_fd_sc_hd__mux4_1
XFILLER_10_3 VGND VGND VPWR VPWR sky130_fd_sc_hd__fill_2
X_2023_ net752 net680 VGND VGND VPWR VPWR Inst_SimpleCLB_ConfigMem.Inst_frame3_bit2.Q
+ sky130_fd_sc_hd__dlxtp_1
XFILLER_54_129 VGND VGND VPWR VPWR sky130_fd_sc_hd__decap_3
X_1807_ net797 net724 VGND VGND VPWR VPWR Inst_SimpleCLB_ConfigMem.Inst_frame10_bit10.Q
+ sky130_fd_sc_hd__dlxtp_1
X_1738_ net742 net718 VGND VGND VPWR VPWR Inst_SimpleCLB_ConfigMem.Inst_frame12_bit5.Q
+ sky130_fd_sc_hd__dlxtp_1
X_1669_ net799 net709 VGND VGND VPWR VPWR Inst_LG_LUT4c_frame_config_dffesr.inst_cus_mux161_buf.A12
+ sky130_fd_sc_hd__dlxtp_1
Xfanout724 net725 VGND VGND VPWR VPWR net724 sky130_fd_sc_hd__clkbuf_2
Xfanout702 FrameStrobe[16] VGND VGND VPWR VPWR net702 sky130_fd_sc_hd__dlymetal6s2s_1
Xfanout713 net714 VGND VGND VPWR VPWR net713 sky130_fd_sc_hd__clkbuf_2
XTAP_TAPCELL_ROW_88_717 VGND VPWR sky130_fd_sc_hd__tapvpwrvgnd_1
Xfanout735 net736 VGND VGND VPWR VPWR net735 sky130_fd_sc_hd__clkbuf_4
Xfanout757 FrameData[28] VGND VGND VPWR VPWR net757 sky130_fd_sc_hd__buf_4
Xfanout746 FrameData[3] VGND VGND VPWR VPWR net746 sky130_fd_sc_hd__buf_4
XFILLER_85_221 VGND VGND VPWR VPWR sky130_fd_sc_hd__decap_3
Xfanout768 net769 VGND VGND VPWR VPWR net768 sky130_fd_sc_hd__clkbuf_4
Xfanout779 FrameData[19] VGND VGND VPWR VPWR net779 sky130_fd_sc_hd__buf_4
XANTENNA_106 S4END[0] VGND VGND VPWR VPWR sky130_fd_sc_hd__diode_2
XANTENNA_128 W2END[0] VGND VGND VPWR VPWR sky130_fd_sc_hd__diode_2
XANTENNA_117 SS4END[0] VGND VGND VPWR VPWR sky130_fd_sc_hd__diode_2
XANTENNA_139 W2END[6] VGND VGND VPWR VPWR sky130_fd_sc_hd__diode_2
XTAP_TAPCELL_ROW_71_617 VGND VPWR sky130_fd_sc_hd__tapvpwrvgnd_1
XFILLER_14_75 VGND VGND VPWR VPWR sky130_fd_sc_hd__decap_3
XFILLER_5_225 VGND VGND VPWR VPWR sky130_fd_sc_hd__decap_3
XFILLER_5_214 VGND VGND VPWR VPWR sky130_fd_sc_hd__decap_3
XFILLER_30_41 VGND VGND VPWR VPWR sky130_fd_sc_hd__decap_3
XFILLER_5_258 VGND VGND VPWR VPWR sky130_fd_sc_hd__decap_3
XFILLER_76_265 VGND VGND VPWR VPWR sky130_fd_sc_hd__decap_3
XTAP_TAPCELL_ROW_19_305 VGND VPWR sky130_fd_sc_hd__tapvpwrvgnd_1
XFILLER_17_343 VGND VGND VPWR VPWR sky130_fd_sc_hd__decap_3
XFILLER_55_60 VGND VGND VPWR VPWR sky130_fd_sc_hd__decap_3
XFILLER_44_184 VGND VGND VPWR VPWR sky130_fd_sc_hd__decap_3
X_0971_ W2END[5] net639 net644 net630 Inst_SimpleCLB_ConfigMem.Inst_frame1_bit11.Q
+ Inst_SimpleCLB_ConfigMem.Inst_frame1_bit10.Q VGND VGND VPWR VPWR _0070_ sky130_fd_sc_hd__mux4_1
XFILLER_58_3 VGND VGND VPWR VPWR sky130_fd_sc_hd__decap_3
X_1523_ Inst_SimpleCLB_ConfigMem.Inst_frame9_bit7.Q _0530_ VGND VGND VPWR VPWR _0550_
+ sky130_fd_sc_hd__nand2_1
X_1454_ net648 net802 net646 net643 Inst_SimpleCLB_ConfigMem.Inst_frame13_bit13.Q
+ Inst_SimpleCLB_ConfigMem.Inst_frame13_bit14.Q VGND VGND VPWR VPWR _0511_ sky130_fd_sc_hd__mux4_1
XFILLER_67_221 VGND VGND VPWR VPWR sky130_fd_sc_hd__decap_3
XFILLER_67_243 VGND VGND VPWR VPWR sky130_fd_sc_hd__fill_1
X_1385_ Inst_SimpleCLB_ConfigMem.Inst_frame12_bit15.Q _0449_ Inst_SimpleCLB_ConfigMem.Inst_frame12_bit16.Q
+ VGND VGND VPWR VPWR _0450_ sky130_fd_sc_hd__a21oi_1
X_2006_ net782 net677 VGND VGND VPWR VPWR Inst_SimpleCLB_ConfigMem.Inst_frame4_bit17.Q
+ sky130_fd_sc_hd__dlxtp_1
XFILLER_23_302 VGND VGND VPWR VPWR sky130_fd_sc_hd__decap_3
XFILLER_23_335 VGND VGND VPWR VPWR sky130_fd_sc_hd__fill_1
XFILLER_23_346 VGND VGND VPWR VPWR sky130_fd_sc_hd__fill_1
XFILLER_50_121 VGND VGND VPWR VPWR sky130_fd_sc_hd__decap_3
XFILLER_2_217 VGND VGND VPWR VPWR sky130_fd_sc_hd__decap_3
XFILLER_58_232 VGND VGND VPWR VPWR sky130_fd_sc_hd__decap_3
XFILLER_14_346 VGND VGND VPWR VPWR sky130_fd_sc_hd__fill_1
XFILLER_25_63 VGND VGND VPWR VPWR sky130_fd_sc_hd__decap_3
XFILLER_25_96 VGND VGND VPWR VPWR sky130_fd_sc_hd__fill_2
XFILLER_41_187 VGND VGND VPWR VPWR sky130_fd_sc_hd__decap_3
XFILLER_49_210 VGND VGND VPWR VPWR sky130_fd_sc_hd__decap_3
X_1170_ _0255_ _0256_ _0247_ _0246_ Inst_SimpleCLB_ConfigMem.Inst_frame8_bit8.Q Inst_SimpleCLB_ConfigMem.Inst_frame8_bit9.Q
+ VGND VGND VPWR VPWR _0257_ sky130_fd_sc_hd__mux4_2
XFILLER_49_243 VGND VGND VPWR VPWR sky130_fd_sc_hd__decap_3
XFILLER_49_276 VGND VGND VPWR VPWR sky130_fd_sc_hd__decap_3
XFILLER_49_287 VGND VGND VPWR VPWR sky130_fd_sc_hd__decap_3
XFILLER_66_81 VGND VGND VPWR VPWR sky130_fd_sc_hd__decap_3
XFILLER_66_92 VGND VGND VPWR VPWR sky130_fd_sc_hd__fill_1
XTAP_TAPCELL_ROW_90_734 VGND VPWR sky130_fd_sc_hd__tapvpwrvgnd_1
XFILLER_32_132 VGND VGND VPWR VPWR sky130_fd_sc_hd__decap_3
XFILLER_32_176 VGND VGND VPWR VPWR sky130_fd_sc_hd__decap_3
XANTENNA_39 FrameData[3] VGND VGND VPWR VPWR sky130_fd_sc_hd__diode_2
XANTENNA_17 EE4END[14] VGND VGND VPWR VPWR sky130_fd_sc_hd__diode_2
XANTENNA_28 FrameData[14] VGND VGND VPWR VPWR sky130_fd_sc_hd__diode_2
X_0954_ net257 _0052_ VGND VGND VPWR VPWR _0054_ sky130_fd_sc_hd__or2_1
X_0885_ E2END[3] WW4END[2] SS4END[3] Inst_SimpleCLB_switch_matrix.JN2BEG2 Inst_SimpleCLB_ConfigMem.Inst_frame0_bit3.Q
+ Inst_SimpleCLB_ConfigMem.Inst_frame0_bit2.Q VGND VGND VPWR VPWR _0711_ sky130_fd_sc_hd__mux4_2
Xoutput124 net124 VGND VGND VPWR VPWR N4BEG[11] sky130_fd_sc_hd__buf_2
Xoutput113 net113 VGND VGND VPWR VPWR N2BEG[7] sky130_fd_sc_hd__buf_4
Xoutput102 net102 VGND VGND VPWR VPWR N1BEG[0] sky130_fd_sc_hd__buf_4
Xoutput146 net146 VGND VGND VPWR VPWR NN4BEG[2] sky130_fd_sc_hd__buf_2
Xoutput135 net135 VGND VGND VPWR VPWR N4BEG[7] sky130_fd_sc_hd__buf_2
Xoutput168 net168 VGND VGND VPWR VPWR S2BEGb[2] sky130_fd_sc_hd__buf_2
Xoutput157 net157 VGND VGND VPWR VPWR S1BEG[3] sky130_fd_sc_hd__clkbuf_4
Xoutput179 net179 VGND VGND VPWR VPWR S4BEG[14] sky130_fd_sc_hd__buf_4
X_1506_ Inst_SimpleCLB_switch_matrix.JN2BEG1 Inst_SimpleCLB_switch_matrix.E2BEG1 Inst_SimpleCLB_ConfigMem.Inst_frame0_bit26.Q
+ VGND VGND VPWR VPWR _0536_ sky130_fd_sc_hd__mux2_1
X_1437_ net652 E1END[1] W1END[1] net620 Inst_SimpleCLB_ConfigMem.Inst_frame13_bit19.Q
+ Inst_SimpleCLB_ConfigMem.Inst_frame13_bit20.Q VGND VGND VPWR VPWR _0496_ sky130_fd_sc_hd__mux4_1
X_1368_ _0435_ VGND VGND VPWR VPWR _0436_ sky130_fd_sc_hd__inv_1
XFILLER_46_18 VGND VGND VPWR VPWR sky130_fd_sc_hd__decap_3
XFILLER_55_202 VGND VGND VPWR VPWR sky130_fd_sc_hd__decap_3
X_1299_ _0594_ _0375_ VGND VGND VPWR VPWR _0376_ sky130_fd_sc_hd__or2_1
XFILLER_55_279 VGND VGND VPWR VPWR sky130_fd_sc_hd__fill_1
XFILLER_11_43 VGND VGND VPWR VPWR sky130_fd_sc_hd__fill_1
XFILLER_46_224 VGND VGND VPWR VPWR sky130_fd_sc_hd__fill_1
XFILLER_46_268 VGND VGND VPWR VPWR sky130_fd_sc_hd__decap_3
XFILLER_61_216 VGND VGND VPWR VPWR sky130_fd_sc_hd__decap_3
XFILLER_54_290 VGND VGND VPWR VPWR sky130_fd_sc_hd__decap_3
XFILLER_14_187 VGND VGND VPWR VPWR sky130_fd_sc_hd__decap_3
X_2340_ S4END[15] VGND VGND VPWR VPWR net176 sky130_fd_sc_hd__buf_4
X_2271_ N2MID[2] VGND VGND VPWR VPWR net116 sky130_fd_sc_hd__buf_1
X_1222_ Inst_LH_LUT4c_frame_config_dffesr.inst_cus_mux161_buf.A10 _0292_ _0293_ Inst_LH_LUT4c_frame_config_dffesr.inst_cus_mux161_buf.A14
+ VGND VGND VPWR VPWR _0307_ sky130_fd_sc_hd__o22a_1
XFILLER_37_202 VGND VGND VPWR VPWR sky130_fd_sc_hd__decap_3
XFILLER_37_257 VGND VGND VPWR VPWR sky130_fd_sc_hd__decap_3
X_1153_ E2MID[4] W2MID[4] S2MID[4] Inst_SimpleCLB_switch_matrix.JS2BEG6 Inst_SimpleCLB_ConfigMem.Inst_frame7_bit23.Q
+ Inst_SimpleCLB_ConfigMem.Inst_frame7_bit22.Q VGND VGND VPWR VPWR _0241_ sky130_fd_sc_hd__mux4_2
XTAP_TAPCELL_ROW_35_403 VGND VPWR sky130_fd_sc_hd__tapvpwrvgnd_1
X_1084_ net619 net317 net267 net264 Inst_SimpleCLB_ConfigMem.Inst_frame1_bit15.Q Inst_SimpleCLB_ConfigMem.Inst_frame1_bit14.Q
+ VGND VGND VPWR VPWR _0177_ sky130_fd_sc_hd__mux4_2
X_1986_ net753 net671 VGND VGND VPWR VPWR Inst_SimpleCLB_ConfigMem.Inst_frame5_bit29.Q
+ sky130_fd_sc_hd__dlxtp_1
XFILLER_20_168 VGND VGND VPWR VPWR sky130_fd_sc_hd__fill_2
X_0937_ _0038_ _0037_ Inst_SimpleCLB_ConfigMem.Inst_frame3_bit4.Q VGND VGND VPWR VPWR
+ _0039_ sky130_fd_sc_hd__mux2_1
X_0868_ _0695_ _0672_ _0670_ VGND VGND VPWR VPWR _0696_ sky130_fd_sc_hd__mux2_4
X_0799_ N2MID[7] E2MID[7] S2MID[7] W2MID[7] Inst_SimpleCLB_ConfigMem.Inst_frame7_bit26.Q
+ Inst_SimpleCLB_ConfigMem.Inst_frame7_bit27.Q VGND VGND VPWR VPWR _0632_ sky130_fd_sc_hd__mux4_2
XFILLER_87_113 VGND VGND VPWR VPWR sky130_fd_sc_hd__fill_2
XTAP_TAPCELL_ROW_58_539 VGND VPWR sky130_fd_sc_hd__tapvpwrvgnd_1
XTAP_TAPCELL_ROW_41_439 VGND VPWR sky130_fd_sc_hd__tapvpwrvgnd_1
XFILLER_7_106 VGND VGND VPWR VPWR sky130_fd_sc_hd__decap_3
XFILLER_22_53 VGND VGND VPWR VPWR sky130_fd_sc_hd__fill_1
XFILLER_3_312 VGND VGND VPWR VPWR sky130_fd_sc_hd__fill_1
XFILLER_3_334 VGND VGND VPWR VPWR sky130_fd_sc_hd__fill_2
XFILLER_19_279 VGND VGND VPWR VPWR sky130_fd_sc_hd__fill_1
XFILLER_27_290 VGND VGND VPWR VPWR sky130_fd_sc_hd__decap_3
X_1840_ net795 net656 VGND VGND VPWR VPWR Inst_SimpleCLB_ConfigMem.Inst_frame9_bit11.Q
+ sky130_fd_sc_hd__dlxtp_1
XFILLER_8_44 VGND VGND VPWR VPWR sky130_fd_sc_hd__decap_3
XFILLER_8_88 VGND VGND VPWR VPWR sky130_fd_sc_hd__decap_3
X_1771_ net740 net720 VGND VGND VPWR VPWR Inst_SimpleCLB_ConfigMem.Inst_frame11_bit6.Q
+ sky130_fd_sc_hd__dlxtp_1
XFILLER_10_190 VGND VGND VPWR VPWR sky130_fd_sc_hd__decap_3
XFILLER_6_150 VGND VGND VPWR VPWR sky130_fd_sc_hd__decap_3
XFILLER_6_183 VGND VGND VPWR VPWR sky130_fd_sc_hd__decap_3
X_2323_ S2MID[2] VGND VGND VPWR VPWR net168 sky130_fd_sc_hd__buf_1
XFILLER_69_113 VGND VGND VPWR VPWR sky130_fd_sc_hd__decap_3
XFILLER_69_146 VGND VGND VPWR VPWR sky130_fd_sc_hd__decap_3
X_2254_ net696 VGND VGND VPWR VPWR net90 sky130_fd_sc_hd__clkbuf_2
X_2185_ E6END[10] VGND VGND VPWR VPWR net32 sky130_fd_sc_hd__buf_1
X_1205_ _0241_ _0242_ _0244_ _0243_ Inst_SimpleCLB_ConfigMem.Inst_frame8_bit20.Q Inst_SimpleCLB_ConfigMem.Inst_frame8_bit21.Q
+ VGND VGND VPWR VPWR _0290_ sky130_fd_sc_hd__mux4_2
XFILLER_25_205 VGND VGND VPWR VPWR sky130_fd_sc_hd__decap_3
X_1136_ N2MID[6] S2MID[6] E2MID[6] Inst_SimpleCLB_switch_matrix.JN2BEG6 Inst_SimpleCLB_ConfigMem.Inst_frame7_bit19.Q
+ Inst_SimpleCLB_ConfigMem.Inst_frame7_bit18.Q VGND VGND VPWR VPWR _0225_ sky130_fd_sc_hd__mux4_2
XFILLER_25_249 VGND VGND VPWR VPWR sky130_fd_sc_hd__decap_3
X_1067_ _0158_ _0159_ VGND VGND VPWR VPWR _0160_ sky130_fd_sc_hd__or2_2
X_1969_ net792 net673 VGND VGND VPWR VPWR Inst_SimpleCLB_ConfigMem.Inst_frame5_bit12.Q
+ sky130_fd_sc_hd__dlxtp_1
XFILLER_0_315 VGND VGND VPWR VPWR sky130_fd_sc_hd__decap_3
XFILLER_0_337 VGND VGND VPWR VPWR sky130_fd_sc_hd__fill_2
XFILLER_68_27 VGND VGND VPWR VPWR sky130_fd_sc_hd__fill_1
XFILLER_68_38 VGND VGND VPWR VPWR sky130_fd_sc_hd__decap_3
XFILLER_75_116 VGND VGND VPWR VPWR sky130_fd_sc_hd__decap_3
XFILLER_84_15 VGND VGND VPWR VPWR sky130_fd_sc_hd__fill_1
XFILLER_31_208 VGND VGND VPWR VPWR sky130_fd_sc_hd__decap_3
XFILLER_33_63 VGND VGND VPWR VPWR sky130_fd_sc_hd__decap_3
XPHY_EDGE_ROW_49_Left_140 VGND VGND VPWR VPWR sky130_fd_sc_hd__decap_3
XFILLER_3_197 VGND VGND VPWR VPWR sky130_fd_sc_hd__decap_3
XFILLER_59_190 VGND VGND VPWR VPWR sky130_fd_sc_hd__decap_3
XFILLER_81_108 VGND VGND VPWR VPWR sky130_fd_sc_hd__decap_3
XFILLER_81_119 VGND VGND VPWR VPWR sky130_fd_sc_hd__decap_3
XFILLER_88_3 VGND VGND VPWR VPWR sky130_fd_sc_hd__fill_1
X_1823_ net760 net725 VGND VGND VPWR VPWR Inst_SimpleCLB_ConfigMem.Inst_frame10_bit26.Q
+ sky130_fd_sc_hd__dlxtp_1
XFILLER_30_274 VGND VGND VPWR VPWR sky130_fd_sc_hd__decap_3
X_1754_ net772 net716 VGND VGND VPWR VPWR Inst_SimpleCLB_ConfigMem.Inst_frame12_bit21.Q
+ sky130_fd_sc_hd__dlxtp_1
X_1685_ net784 net707 VGND VGND VPWR VPWR Inst_LH_LUT4c_frame_config_dffesr.inst_cus_mux161_buf.A9
+ sky130_fd_sc_hd__dlxtp_1
XFILLER_57_116 VGND VGND VPWR VPWR sky130_fd_sc_hd__decap_3
XTAP_TAPCELL_ROW_68_601 VGND VPWR sky130_fd_sc_hd__tapvpwrvgnd_1
X_2237_ net732 VGND VGND VPWR VPWR net82 sky130_fd_sc_hd__clkbuf_2
XFILLER_53_311 VGND VGND VPWR VPWR sky130_fd_sc_hd__fill_1
XFILLER_53_344 VGND VGND VPWR VPWR sky130_fd_sc_hd__decap_3
X_1119_ Inst_LE_LUT4c_frame_config_dffesr.inst_cus_mux161_buf.A8 _0155_ _0156_ Inst_LE_LUT4c_frame_config_dffesr.inst_cus_mux161_buf.A14
+ _0209_ VGND VGND VPWR VPWR _0210_ sky130_fd_sc_hd__o221a_1
X_2099_ net788 net689 VGND VGND VPWR VPWR Inst_SimpleCLB_ConfigMem.Inst_frame1_bit14.Q
+ sky130_fd_sc_hd__dlxtp_1
XFILLER_65_193 VGND VGND VPWR VPWR sky130_fd_sc_hd__decap_3
XFILLER_80_141 VGND VGND VPWR VPWR sky130_fd_sc_hd__decap_3
XTAP_TAPCELL_ROW_0_189 VGND VPWR sky130_fd_sc_hd__tapvpwrvgnd_1
XFILLER_80_163 VGND VGND VPWR VPWR sky130_fd_sc_hd__decap_3
XFILLER_21_241 VGND VGND VPWR VPWR sky130_fd_sc_hd__decap_3
XPHY_EDGE_ROW_17_Right_17 VGND VGND VPWR VPWR sky130_fd_sc_hd__decap_3
XFILLER_79_48 VGND VGND VPWR VPWR sky130_fd_sc_hd__decap_3
XFILLER_0_134 VGND VGND VPWR VPWR sky130_fd_sc_hd__decap_3
XPHY_EDGE_ROW_26_Right_26 VGND VGND VPWR VPWR sky130_fd_sc_hd__decap_3
XFILLER_28_41 VGND VGND VPWR VPWR sky130_fd_sc_hd__fill_2
XFILLER_28_63 VGND VGND VPWR VPWR sky130_fd_sc_hd__decap_3
XFILLER_63_108 VGND VGND VPWR VPWR sky130_fd_sc_hd__decap_3
XFILLER_63_119 VGND VGND VPWR VPWR sky130_fd_sc_hd__decap_3
XFILLER_28_85 VGND VGND VPWR VPWR sky130_fd_sc_hd__decap_3
XFILLER_28_96 VGND VGND VPWR VPWR sky130_fd_sc_hd__decap_3
XTAP_TAPCELL_ROW_74_637 VGND VPWR sky130_fd_sc_hd__tapvpwrvgnd_1
XFILLER_44_333 VGND VGND VPWR VPWR sky130_fd_sc_hd__fill_1
XFILLER_44_344 VGND VGND VPWR VPWR sky130_fd_sc_hd__decap_3
XTAP_TAPCELL_ROW_82_681 VGND VPWR sky130_fd_sc_hd__tapvpwrvgnd_1
XFILLER_71_152 VGND VGND VPWR VPWR sky130_fd_sc_hd__fill_1
XFILLER_8_212 VGND VGND VPWR VPWR sky130_fd_sc_hd__decap_3
XPHY_EDGE_ROW_35_Right_35 VGND VGND VPWR VPWR sky130_fd_sc_hd__decap_3
XFILLER_12_285 VGND VGND VPWR VPWR sky130_fd_sc_hd__decap_3
XFILLER_60_50 VGND VGND VPWR VPWR sky130_fd_sc_hd__decap_3
X_1470_ S2END[1] S4END[0] W6END[0] net617 Inst_SimpleCLB_ConfigMem.Inst_frame11_bit0.Q
+ Inst_SimpleCLB_ConfigMem.Inst_frame11_bit1.Q VGND VGND VPWR VPWR Inst_SimpleCLB_switch_matrix.S4BEG3
+ sky130_fd_sc_hd__mux4_1
XFILLER_5_89 VGND VGND VPWR VPWR sky130_fd_sc_hd__fill_1
XPHY_EDGE_ROW_44_Right_44 VGND VGND VPWR VPWR sky130_fd_sc_hd__decap_3
XFILLER_69_70 VGND VGND VPWR VPWR sky130_fd_sc_hd__fill_2
XFILLER_39_105 VGND VGND VPWR VPWR sky130_fd_sc_hd__fill_1
XFILLER_39_116 VGND VGND VPWR VPWR sky130_fd_sc_hd__decap_3
X_2022_ net776 net680 VGND VGND VPWR VPWR Inst_SimpleCLB_ConfigMem.Inst_frame3_bit1.Q
+ sky130_fd_sc_hd__dlxtp_1
XFILLER_62_130 VGND VGND VPWR VPWR sky130_fd_sc_hd__decap_3
XPHY_EDGE_ROW_53_Right_53 VGND VGND VPWR VPWR sky130_fd_sc_hd__decap_3
X_1806_ net734 net727 VGND VGND VPWR VPWR Inst_SimpleCLB_ConfigMem.Inst_frame10_bit9.Q
+ sky130_fd_sc_hd__dlxtp_1
X_1737_ net744 net718 VGND VGND VPWR VPWR Inst_SimpleCLB_ConfigMem.Inst_frame12_bit4.Q
+ sky130_fd_sc_hd__dlxtp_1
XFILLER_49_18 VGND VGND VPWR VPWR sky130_fd_sc_hd__decap_3
XPHY_EDGE_ROW_62_Right_62 VGND VGND VPWR VPWR sky130_fd_sc_hd__decap_3
X_1668_ net748 net705 VGND VGND VPWR VPWR Inst_LG_LUT4c_frame_config_dffesr.inst_cus_mux161_buf.A11
+ sky130_fd_sc_hd__dlxtp_1
Xfanout714 net715 VGND VGND VPWR VPWR net714 sky130_fd_sc_hd__clkbuf_2
Xfanout703 net706 VGND VGND VPWR VPWR net703 sky130_fd_sc_hd__clkbuf_2
Xfanout736 FrameData[8] VGND VGND VPWR VPWR net736 sky130_fd_sc_hd__buf_4
XTAP_TAPCELL_ROW_88_718 VGND VPWR sky130_fd_sc_hd__tapvpwrvgnd_1
Xfanout725 net726 VGND VGND VPWR VPWR net725 sky130_fd_sc_hd__dlymetal6s2s_1
X_1599_ net760 net697 VGND VGND VPWR VPWR Inst_LC_LUT4c_frame_config_dffesr.c_reset_value
+ sky130_fd_sc_hd__dlxtp_1
Xfanout747 FrameData[31] VGND VGND VPWR VPWR net747 sky130_fd_sc_hd__clkbuf_4
Xfanout758 net759 VGND VGND VPWR VPWR net758 sky130_fd_sc_hd__buf_4
Xfanout769 FrameData[22] VGND VGND VPWR VPWR net769 sky130_fd_sc_hd__buf_4
XANTENNA_107 S4END[0] VGND VGND VPWR VPWR sky130_fd_sc_hd__diode_2
XANTENNA_129 W2END[0] VGND VGND VPWR VPWR sky130_fd_sc_hd__diode_2
XANTENNA_118 SS4END[1] VGND VGND VPWR VPWR sky130_fd_sc_hd__diode_2
XFILLER_26_333 VGND VGND VPWR VPWR sky130_fd_sc_hd__decap_3
XFILLER_38_193 VGND VGND VPWR VPWR sky130_fd_sc_hd__decap_3
XFILLER_53_163 VGND VGND VPWR VPWR sky130_fd_sc_hd__decap_3
XTAP_TAPCELL_ROW_71_618 VGND VPWR sky130_fd_sc_hd__tapvpwrvgnd_1
XPHY_EDGE_ROW_71_Right_71 VGND VGND VPWR VPWR sky130_fd_sc_hd__decap_3
XFILLER_5_237 VGND VGND VPWR VPWR sky130_fd_sc_hd__decap_3
XFILLER_30_20 VGND VGND VPWR VPWR sky130_fd_sc_hd__fill_1
XFILLER_30_53 VGND VGND VPWR VPWR sky130_fd_sc_hd__decap_3
XPHY_EDGE_ROW_80_Right_80 VGND VGND VPWR VPWR sky130_fd_sc_hd__decap_3
XFILLER_30_97 VGND VGND VPWR VPWR sky130_fd_sc_hd__fill_2
XFILLER_39_40 VGND VGND VPWR VPWR sky130_fd_sc_hd__decap_3
XFILLER_76_277 VGND VGND VPWR VPWR sky130_fd_sc_hd__decap_3
XTAP_TAPCELL_ROW_19_306 VGND VPWR sky130_fd_sc_hd__tapvpwrvgnd_1
XFILLER_29_182 VGND VGND VPWR VPWR sky130_fd_sc_hd__decap_3
XFILLER_44_141 VGND VGND VPWR VPWR sky130_fd_sc_hd__fill_1
XFILLER_55_72 VGND VGND VPWR VPWR sky130_fd_sc_hd__decap_3
XTAP_TAPCELL_ROW_27_350 VGND VPWR sky130_fd_sc_hd__tapvpwrvgnd_1
X_0970_ net618 net614 net633 net610 Inst_SimpleCLB_ConfigMem.Inst_frame1_bit11.Q Inst_SimpleCLB_ConfigMem.Inst_frame1_bit10.Q
+ VGND VGND VPWR VPWR _0069_ sky130_fd_sc_hd__mux4_2
XTAP_TAPCELL_ROW_10_250 VGND VPWR sky130_fd_sc_hd__tapvpwrvgnd_1
X_1522_ net391 _0549_ _0547_ VGND VGND VPWR VPWR _0002_ sky130_fd_sc_hd__mux2_1
X_1453_ _0507_ Inst_SimpleCLB_ConfigMem.Inst_frame13_bit14.Q Inst_SimpleCLB_ConfigMem.Inst_frame13_bit15.Q
+ VGND VGND VPWR VPWR _0510_ sky130_fd_sc_hd__a21bo_1
X_1384_ S1END[2] net647 Inst_SimpleCLB_ConfigMem.Inst_frame12_bit14.Q VGND VGND VPWR
+ VPWR _0449_ sky130_fd_sc_hd__mux2_1
XFILLER_27_108 VGND VGND VPWR VPWR sky130_fd_sc_hd__decap_3
XFILLER_27_119 VGND VGND VPWR VPWR sky130_fd_sc_hd__decap_3
XFILLER_82_236 VGND VGND VPWR VPWR sky130_fd_sc_hd__decap_3
X_2005_ net784 net677 VGND VGND VPWR VPWR Inst_SimpleCLB_ConfigMem.Inst_frame4_bit16.Q
+ sky130_fd_sc_hd__dlxtp_1
XFILLER_23_314 VGND VGND VPWR VPWR sky130_fd_sc_hd__decap_3
XFILLER_50_100 VGND VGND VPWR VPWR sky130_fd_sc_hd__decap_3
XFILLER_50_133 VGND VGND VPWR VPWR sky130_fd_sc_hd__decap_3
XFILLER_50_144 VGND VGND VPWR VPWR sky130_fd_sc_hd__decap_3
XTAP_TAPCELL_ROW_33_386 VGND VPWR sky130_fd_sc_hd__tapvpwrvgnd_1
XFILLER_58_200 VGND VGND VPWR VPWR sky130_fd_sc_hd__decap_3
XFILLER_76_27 VGND VGND VPWR VPWR sky130_fd_sc_hd__fill_1
XFILLER_58_244 VGND VGND VPWR VPWR sky130_fd_sc_hd__decap_3
XFILLER_73_225 VGND VGND VPWR VPWR sky130_fd_sc_hd__decap_3
XFILLER_26_141 VGND VGND VPWR VPWR sky130_fd_sc_hd__decap_3
Xrebuffer60 _0305_ VGND VGND VPWR VPWR net314 sky130_fd_sc_hd__clkbuf_2
XFILLER_25_31 VGND VGND VPWR VPWR sky130_fd_sc_hd__decap_3
XFILLER_41_111 VGND VGND VPWR VPWR sky130_fd_sc_hd__fill_1
XFILLER_2_68 VGND VGND VPWR VPWR sky130_fd_sc_hd__decap_3
XFILLER_49_255 VGND VGND VPWR VPWR sky130_fd_sc_hd__decap_3
XFILLER_64_236 VGND VGND VPWR VPWR sky130_fd_sc_hd__fill_2
XFILLER_17_152 VGND VGND VPWR VPWR sky130_fd_sc_hd__fill_1
XTAP_TAPCELL_ROW_90_735 VGND VPWR sky130_fd_sc_hd__tapvpwrvgnd_1
XFILLER_17_196 VGND VGND VPWR VPWR sky130_fd_sc_hd__fill_1
XFILLER_32_111 VGND VGND VPWR VPWR sky130_fd_sc_hd__decap_3
XFILLER_32_144 VGND VGND VPWR VPWR sky130_fd_sc_hd__decap_3
XANTENNA_18 EE4END[15] VGND VGND VPWR VPWR sky130_fd_sc_hd__diode_2
XANTENNA_29 FrameData[14] VGND VGND VPWR VPWR sky130_fd_sc_hd__diode_2
X_0953_ net257 _0052_ VGND VGND VPWR VPWR _0053_ sky130_fd_sc_hd__nand2_1
X_0884_ _0710_ _0707_ Inst_SimpleCLB_ConfigMem.Inst_frame4_bit5.Q VGND VGND VPWR VPWR
+ Inst_SimpleCLB_switch_matrix.JN2BEG2 sky130_fd_sc_hd__mux2_4
XFILLER_70_3 VGND VGND VPWR VPWR sky130_fd_sc_hd__decap_3
Xoutput125 net125 VGND VGND VPWR VPWR N4BEG[12] sky130_fd_sc_hd__buf_4
Xoutput103 net103 VGND VGND VPWR VPWR N1BEG[1] sky130_fd_sc_hd__buf_4
Xoutput114 net114 VGND VGND VPWR VPWR N2BEGb[0] sky130_fd_sc_hd__buf_2
Xoutput147 net147 VGND VGND VPWR VPWR NN4BEG[3] sky130_fd_sc_hd__buf_2
Xoutput136 net136 VGND VGND VPWR VPWR N4BEG[8] sky130_fd_sc_hd__buf_2
X_1505_ Inst_SimpleCLB_switch_matrix.JS2BEG1 Inst_SimpleCLB_switch_matrix.JW2BEG1
+ Inst_SimpleCLB_ConfigMem.Inst_frame0_bit26.Q VGND VGND VPWR VPWR _0535_ sky130_fd_sc_hd__mux2_2
Xoutput158 net158 VGND VGND VPWR VPWR S2BEG[0] sky130_fd_sc_hd__buf_4
Xoutput169 net169 VGND VGND VPWR VPWR S2BEGb[3] sky130_fd_sc_hd__buf_2
X_1436_ _0493_ _0495_ _0491_ VGND VGND VPWR VPWR Inst_SimpleCLB_switch_matrix.EE4BEG0
+ sky130_fd_sc_hd__a21oi_2
X_1367_ net628 _0140_ Inst_SimpleCLB_ConfigMem.Inst_frame11_bit8.Q VGND VGND VPWR
+ VPWR _0435_ sky130_fd_sc_hd__mux2_1
XFILLER_55_225 VGND VGND VPWR VPWR sky130_fd_sc_hd__decap_3
X_1298_ net618 net624 net633 net348 Inst_SimpleCLB_ConfigMem.Inst_frame4_bit22.Q Inst_SimpleCLB_ConfigMem.Inst_frame4_bit23.Q
+ VGND VGND VPWR VPWR _0375_ sky130_fd_sc_hd__mux4_1
XFILLER_23_111 VGND VGND VPWR VPWR sky130_fd_sc_hd__fill_1
XFILLER_62_18 VGND VGND VPWR VPWR sky130_fd_sc_hd__decap_3
XFILLER_70_239 VGND VGND VPWR VPWR sky130_fd_sc_hd__decap_3
XFILLER_62_29 VGND VGND VPWR VPWR sky130_fd_sc_hd__decap_3
XFILLER_23_188 VGND VGND VPWR VPWR sky130_fd_sc_hd__decap_3
XPHY_EDGE_ROW_12_Left_103 VGND VGND VPWR VPWR sky130_fd_sc_hd__decap_3
XPHY_EDGE_ROW_21_Left_112 VGND VGND VPWR VPWR sky130_fd_sc_hd__decap_3
Xclone109 net611 VGND VGND VPWR VPWR net363 sky130_fd_sc_hd__clkbuf_1
XFILLER_46_247 VGND VGND VPWR VPWR sky130_fd_sc_hd__decap_3
XFILLER_36_85 VGND VGND VPWR VPWR sky130_fd_sc_hd__decap_3
XFILLER_14_144 VGND VGND VPWR VPWR sky130_fd_sc_hd__decap_3
XFILLER_14_166 VGND VGND VPWR VPWR sky130_fd_sc_hd__decap_3
XPHY_EDGE_ROW_30_Left_121 VGND VGND VPWR VPWR sky130_fd_sc_hd__decap_3
XFILLER_6_321 VGND VGND VPWR VPWR sky130_fd_sc_hd__decap_3
X_2270_ N2MID[1] VGND VGND VPWR VPWR net115 sky130_fd_sc_hd__buf_4
XFILLER_84_309 VGND VGND VPWR VPWR sky130_fd_sc_hd__fill_2
X_1221_ Inst_LH_LUT4c_frame_config_dffesr.inst_cus_mux161_buf.A12 _0294_ _0295_ Inst_LH_LUT4c_frame_config_dffesr.inst_cus_mux161_buf.A8
+ VGND VGND VPWR VPWR _0306_ sky130_fd_sc_hd__o22a_1
XFILLER_77_70 VGND VGND VPWR VPWR sky130_fd_sc_hd__decap_3
XFILLER_37_214 VGND VGND VPWR VPWR sky130_fd_sc_hd__decap_3
X_1152_ _0240_ _0237_ Inst_SimpleCLB_ConfigMem.Inst_frame2_bit21.Q VGND VGND VPWR
+ VPWR Inst_SimpleCLB_switch_matrix.JS2BEG6 sky130_fd_sc_hd__mux2_4
XFILLER_37_225 VGND VGND VPWR VPWR sky130_fd_sc_hd__decap_3
X_1083_ NN4END[2] E2END[1] S2END[1] W2END[1] Inst_SimpleCLB_ConfigMem.Inst_frame5_bit16.Q
+ Inst_SimpleCLB_ConfigMem.Inst_frame5_bit17.Q VGND VGND VPWR VPWR _0176_ sky130_fd_sc_hd__mux4_2
XFILLER_37_269 VGND VGND VPWR VPWR sky130_fd_sc_hd__decap_3
XFILLER_52_239 VGND VGND VPWR VPWR sky130_fd_sc_hd__fill_1
XFILLER_60_272 VGND VGND VPWR VPWR sky130_fd_sc_hd__decap_3
X_1985_ net756 net671 VGND VGND VPWR VPWR Inst_SimpleCLB_ConfigMem.Inst_frame5_bit28.Q
+ sky130_fd_sc_hd__dlxtp_1
XFILLER_60_294 VGND VGND VPWR VPWR sky130_fd_sc_hd__fill_1
X_0936_ net652 N2END[3] net649 N4END[3] Inst_SimpleCLB_ConfigMem.Inst_frame3_bit3.Q
+ Inst_SimpleCLB_ConfigMem.Inst_frame3_bit2.Q VGND VGND VPWR VPWR _0038_ sky130_fd_sc_hd__mux4_1
X_0867_ _0693_ _0694_ _0619_ VGND VGND VPWR VPWR _0695_ sky130_fd_sc_hd__mux2_1
X_0798_ Inst_SimpleCLB_ConfigMem.Inst_frame8_bit27.Q _0630_ _0629_ VGND VGND VPWR
+ VPWR _0631_ sky130_fd_sc_hd__a21oi_1
XFILLER_87_136 VGND VGND VPWR VPWR sky130_fd_sc_hd__fill_2
X_1419_ net654 E1END[0] S1END[0] net639 Inst_SimpleCLB_ConfigMem.Inst_frame12_bit4.Q
+ Inst_SimpleCLB_ConfigMem.Inst_frame12_bit5.Q VGND VGND VPWR VPWR _0481_ sky130_fd_sc_hd__mux4_1
XFILLER_75_309 VGND VGND VPWR VPWR sky130_fd_sc_hd__fill_1
X_2399_ WW4END[9] VGND VGND VPWR VPWR net250 sky130_fd_sc_hd__clkbuf_2
XFILLER_28_236 VGND VGND VPWR VPWR sky130_fd_sc_hd__decap_3
XFILLER_43_217 VGND VGND VPWR VPWR sky130_fd_sc_hd__decap_3
XTAP_TAPCELL_ROW_66_584 VGND VPWR sky130_fd_sc_hd__tapvpwrvgnd_1
XFILLER_11_169 VGND VGND VPWR VPWR sky130_fd_sc_hd__decap_3
XFILLER_3_302 VGND VGND VPWR VPWR sky130_fd_sc_hd__fill_1
XFILLER_22_98 VGND VGND VPWR VPWR sky130_fd_sc_hd__fill_2
XFILLER_0_3 VGND VGND VPWR VPWR sky130_fd_sc_hd__decap_3
XFILLER_3_346 VGND VGND VPWR VPWR sky130_fd_sc_hd__fill_1
XFILLER_19_203 VGND VGND VPWR VPWR sky130_fd_sc_hd__decap_3
XFILLER_19_214 VGND VGND VPWR VPWR sky130_fd_sc_hd__decap_3
XFILLER_19_225 VGND VGND VPWR VPWR sky130_fd_sc_hd__decap_3
XFILLER_47_73 VGND VGND VPWR VPWR sky130_fd_sc_hd__fill_2
XFILLER_63_83 VGND VGND VPWR VPWR sky130_fd_sc_hd__decap_3
XFILLER_8_67 VGND VGND VPWR VPWR sky130_fd_sc_hd__decap_3
X_1770_ net741 net720 VGND VGND VPWR VPWR Inst_SimpleCLB_ConfigMem.Inst_frame11_bit5.Q
+ sky130_fd_sc_hd__dlxtp_1
XFILLER_6_162 VGND VGND VPWR VPWR sky130_fd_sc_hd__decap_3
XFILLER_6_195 VGND VGND VPWR VPWR sky130_fd_sc_hd__fill_1
X_2322_ S2MID[1] VGND VGND VPWR VPWR net167 sky130_fd_sc_hd__buf_1
XFILLER_69_103 VGND VGND VPWR VPWR sky130_fd_sc_hd__decap_3
XFILLER_69_125 VGND VGND VPWR VPWR sky130_fd_sc_hd__decap_3
XFILLER_84_106 VGND VGND VPWR VPWR sky130_fd_sc_hd__decap_3
X_2253_ net701 VGND VGND VPWR VPWR net89 sky130_fd_sc_hd__buf_1
X_2184_ E6END[9] VGND VGND VPWR VPWR net31 sky130_fd_sc_hd__buf_1
XFILLER_84_139 VGND VGND VPWR VPWR sky130_fd_sc_hd__fill_1
XFILLER_77_191 VGND VGND VPWR VPWR sky130_fd_sc_hd__decap_3
X_1204_ _0286_ _0288_ VGND VGND VPWR VPWR _0289_ sky130_fd_sc_hd__nor2_4
X_1135_ _0224_ _0221_ Inst_SimpleCLB_ConfigMem.Inst_frame4_bit21.Q VGND VGND VPWR
+ VPWR Inst_SimpleCLB_switch_matrix.JN2BEG6 sky130_fd_sc_hd__mux2_4
XFILLER_25_217 VGND VGND VPWR VPWR sky130_fd_sc_hd__decap_3
XFILLER_25_228 VGND VGND VPWR VPWR sky130_fd_sc_hd__decap_3
X_1066_ net255 _0032_ _0023_ _0022_ Inst_SimpleCLB_ConfigMem.Inst_frame9_bit12.Q Inst_SimpleCLB_ConfigMem.Inst_frame9_bit13.Q
+ VGND VGND VPWR VPWR _0159_ sky130_fd_sc_hd__mux4_2
XFILLER_33_261 VGND VGND VPWR VPWR sky130_fd_sc_hd__decap_3
X_1968_ net794 net673 VGND VGND VPWR VPWR Inst_SimpleCLB_ConfigMem.Inst_frame5_bit11.Q
+ sky130_fd_sc_hd__dlxtp_1
X_0919_ NN4END[1] EE4END[1] S4END[1] Inst_SimpleCLB_switch_matrix.JS2BEG2 Inst_SimpleCLB_ConfigMem.Inst_frame0_bit6.Q
+ Inst_SimpleCLB_ConfigMem.Inst_frame0_bit7.Q VGND VGND VPWR VPWR _0022_ sky130_fd_sc_hd__mux4_2
X_1899_ net740 net665 VGND VGND VPWR VPWR Inst_SimpleCLB_ConfigMem.Inst_frame7_bit6.Q
+ sky130_fd_sc_hd__dlxtp_1
XFILLER_0_327 VGND VGND VPWR VPWR sky130_fd_sc_hd__decap_3
XFILLER_84_38 VGND VGND VPWR VPWR sky130_fd_sc_hd__decap_3
XFILLER_56_331 VGND VGND VPWR VPWR sky130_fd_sc_hd__decap_3
XFILLER_75_128 VGND VGND VPWR VPWR sky130_fd_sc_hd__fill_1
XFILLER_83_183 VGND VGND VPWR VPWR sky130_fd_sc_hd__decap_3
XFILLER_83_172 VGND VGND VPWR VPWR sky130_fd_sc_hd__fill_2
XFILLER_83_161 VGND VGND VPWR VPWR sky130_fd_sc_hd__decap_3
XFILLER_17_54 VGND VGND VPWR VPWR sky130_fd_sc_hd__fill_2
XFILLER_16_239 VGND VGND VPWR VPWR sky130_fd_sc_hd__decap_3
XFILLER_71_301 VGND VGND VPWR VPWR sky130_fd_sc_hd__decap_3
XFILLER_33_42 VGND VGND VPWR VPWR sky130_fd_sc_hd__fill_2
XFILLER_33_75 VGND VGND VPWR VPWR sky130_fd_sc_hd__fill_1
XFILLER_33_97 VGND VGND VPWR VPWR sky130_fd_sc_hd__decap_3
XFILLER_58_83 VGND VGND VPWR VPWR sky130_fd_sc_hd__fill_1
XFILLER_47_320 VGND VGND VPWR VPWR sky130_fd_sc_hd__decap_3
XFILLER_74_82 VGND VGND VPWR VPWR sky130_fd_sc_hd__fill_2
XFILLER_74_194 VGND VGND VPWR VPWR sky130_fd_sc_hd__fill_2
XFILLER_22_209 VGND VGND VPWR VPWR sky130_fd_sc_hd__decap_3
X_1822_ net763 net724 VGND VGND VPWR VPWR Inst_SimpleCLB_ConfigMem.Inst_frame10_bit25.Q
+ sky130_fd_sc_hd__dlxtp_1
XFILLER_30_253 VGND VGND VPWR VPWR sky130_fd_sc_hd__decap_3
XFILLER_30_264 VGND VGND VPWR VPWR sky130_fd_sc_hd__decap_3
XFILLER_30_286 VGND VGND VPWR VPWR sky130_fd_sc_hd__decap_3
X_1753_ net775 net716 VGND VGND VPWR VPWR Inst_SimpleCLB_ConfigMem.Inst_frame12_bit20.Q
+ sky130_fd_sc_hd__dlxtp_1
X_1684_ net787 net708 VGND VGND VPWR VPWR Inst_LH_LUT4c_frame_config_dffesr.inst_cus_mux161_buf.A8
+ sky130_fd_sc_hd__dlxtp_1
X_2305_ Inst_SimpleCLB_switch_matrix.NN4BEG0 VGND VGND VPWR VPWR net141 sky130_fd_sc_hd__clkbuf_2
X_2236_ net748 VGND VGND VPWR VPWR net74 sky130_fd_sc_hd__clkbuf_2
X_2167_ Inst_SimpleCLB_switch_matrix.E2BEG6 VGND VGND VPWR VPWR net12 sky130_fd_sc_hd__buf_6
XFILLER_65_161 VGND VGND VPWR VPWR sky130_fd_sc_hd__decap_3
XFILLER_65_172 VGND VGND VPWR VPWR sky130_fd_sc_hd__decap_3
X_1118_ Inst_LE_LUT4c_frame_config_dffesr.inst_cus_mux161_buf.A10 _0202_ _0203_ Inst_LE_LUT4c_frame_config_dffesr.inst_cus_mux161_buf.A12
+ VGND VGND VPWR VPWR _0209_ sky130_fd_sc_hd__o22a_1
X_2098_ net790 net689 VGND VGND VPWR VPWR Inst_SimpleCLB_ConfigMem.Inst_frame1_bit13.Q
+ sky130_fd_sc_hd__dlxtp_1
XFILLER_80_131 VGND VGND VPWR VPWR sky130_fd_sc_hd__decap_3
XFILLER_13_209 VGND VGND VPWR VPWR sky130_fd_sc_hd__decap_3
X_1049_ N2END[5] E2END[5] SS4END[1] W2END[5] Inst_SimpleCLB_ConfigMem.Inst_frame5_bit14.Q
+ Inst_SimpleCLB_ConfigMem.Inst_frame5_bit15.Q VGND VGND VPWR VPWR _0143_ sky130_fd_sc_hd__mux4_2
XFILLER_80_153 VGND VGND VPWR VPWR sky130_fd_sc_hd__decap_3
XFILLER_21_231 VGND VGND VPWR VPWR sky130_fd_sc_hd__decap_3
XFILLER_21_253 VGND VGND VPWR VPWR sky130_fd_sc_hd__decap_3
XFILLER_21_264 VGND VGND VPWR VPWR sky130_fd_sc_hd__decap_3
XFILLER_70_29 VGND VGND VPWR VPWR sky130_fd_sc_hd__decap_3
XFILLER_56_172 VGND VGND VPWR VPWR sky130_fd_sc_hd__decap_3
XFILLER_71_131 VGND VGND VPWR VPWR sky130_fd_sc_hd__decap_3
XFILLER_71_175 VGND VGND VPWR VPWR sky130_fd_sc_hd__decap_3
XTAP_TAPCELL_ROW_82_682 VGND VPWR sky130_fd_sc_hd__tapvpwrvgnd_1
XFILLER_44_74 VGND VGND VPWR VPWR sky130_fd_sc_hd__decap_3
XFILLER_44_85 VGND VGND VPWR VPWR sky130_fd_sc_hd__decap_3
XFILLER_12_253 VGND VGND VPWR VPWR sky130_fd_sc_hd__decap_3
XFILLER_8_224 VGND VGND VPWR VPWR sky130_fd_sc_hd__decap_3
XFILLER_67_9 VGND VGND VPWR VPWR sky130_fd_sc_hd__decap_3
XFILLER_39_139 VGND VGND VPWR VPWR sky130_fd_sc_hd__decap_3
X_2021_ net798 net679 VGND VGND VPWR VPWR Inst_SimpleCLB_ConfigMem.Inst_frame3_bit0.Q
+ sky130_fd_sc_hd__dlxtp_1
XFILLER_35_301 VGND VGND VPWR VPWR sky130_fd_sc_hd__fill_2
XFILLER_47_172 VGND VGND VPWR VPWR sky130_fd_sc_hd__fill_1
XFILLER_62_153 VGND VGND VPWR VPWR sky130_fd_sc_hd__decap_3
XTAP_TAPCELL_ROW_13_270 VGND VPWR sky130_fd_sc_hd__tapvpwrvgnd_1
X_1805_ net736 net728 VGND VGND VPWR VPWR Inst_SimpleCLB_ConfigMem.Inst_frame10_bit8.Q
+ sky130_fd_sc_hd__dlxtp_1
X_1736_ net745 net718 VGND VGND VPWR VPWR Inst_SimpleCLB_ConfigMem.Inst_frame12_bit3.Q
+ sky130_fd_sc_hd__dlxtp_1
XPHY_EDGE_ROW_68_Left_159 VGND VGND VPWR VPWR sky130_fd_sc_hd__decap_3
X_1667_ net750 net705 VGND VGND VPWR VPWR Inst_LG_LUT4c_frame_config_dffesr.inst_cus_mux161_buf.A10
+ sky130_fd_sc_hd__dlxtp_1
Xfanout715 FrameStrobe[13] VGND VGND VPWR VPWR net715 sky130_fd_sc_hd__clkbuf_2
X_1598_ net762 net696 VGND VGND VPWR VPWR Inst_LC_LUT4c_frame_config_dffesr.c_I0mux
+ sky130_fd_sc_hd__dlxtp_1
Xfanout704 net706 VGND VGND VPWR VPWR net704 sky130_fd_sc_hd__clkbuf_2
XTAP_TAPCELL_ROW_88_719 VGND VPWR sky130_fd_sc_hd__tapvpwrvgnd_1
XFILLER_85_201 VGND VGND VPWR VPWR sky130_fd_sc_hd__decap_3
Xfanout737 net738 VGND VGND VPWR VPWR net737 sky130_fd_sc_hd__buf_4
Xfanout748 FrameData[31] VGND VGND VPWR VPWR net748 sky130_fd_sc_hd__buf_4
Xfanout726 net727 VGND VGND VPWR VPWR net726 sky130_fd_sc_hd__dlymetal6s2s_1
XFILLER_85_234 VGND VGND VPWR VPWR sky130_fd_sc_hd__fill_1
Xfanout759 FrameData[27] VGND VGND VPWR VPWR net759 sky130_fd_sc_hd__clkbuf_4
XFILLER_45_109 VGND VGND VPWR VPWR sky130_fd_sc_hd__decap_3
X_2219_ net788 VGND VGND VPWR VPWR net55 sky130_fd_sc_hd__clkbuf_2
XANTENNA_108 S4END[0] VGND VGND VPWR VPWR sky130_fd_sc_hd__diode_2
XFILLER_26_345 VGND VGND VPWR VPWR sky130_fd_sc_hd__fill_2
XANTENNA_119 SS4END[1] VGND VGND VPWR VPWR sky130_fd_sc_hd__diode_2
XPHY_EDGE_ROW_77_Left_168 VGND VGND VPWR VPWR sky130_fd_sc_hd__decap_3
XTAP_TAPCELL_ROW_71_619 VGND VPWR sky130_fd_sc_hd__tapvpwrvgnd_1
XFILLER_81_28 VGND VGND VPWR VPWR sky130_fd_sc_hd__decap_3
XPHY_EDGE_ROW_86_Left_177 VGND VGND VPWR VPWR sky130_fd_sc_hd__decap_3
XFILLER_5_205 VGND VGND VPWR VPWR sky130_fd_sc_hd__decap_3
XFILLER_5_249 VGND VGND VPWR VPWR sky130_fd_sc_hd__decap_3
XFILLER_39_52 VGND VGND VPWR VPWR sky130_fd_sc_hd__decap_3
XFILLER_39_96 VGND VGND VPWR VPWR sky130_fd_sc_hd__decap_3
XFILLER_76_256 VGND VGND VPWR VPWR sky130_fd_sc_hd__decap_3
XTAP_TAPCELL_ROW_19_307 VGND VPWR sky130_fd_sc_hd__tapvpwrvgnd_1
XFILLER_29_172 VGND VGND VPWR VPWR sky130_fd_sc_hd__decap_3
XFILLER_17_334 VGND VGND VPWR VPWR sky130_fd_sc_hd__fill_2
XFILLER_44_131 VGND VGND VPWR VPWR sky130_fd_sc_hd__decap_3
XFILLER_55_40 VGND VGND VPWR VPWR sky130_fd_sc_hd__decap_3
XTAP_TAPCELL_ROW_27_351 VGND VPWR sky130_fd_sc_hd__tapvpwrvgnd_1
XFILLER_55_84 VGND VGND VPWR VPWR sky130_fd_sc_hd__decap_3
XFILLER_44_175 VGND VGND VPWR VPWR sky130_fd_sc_hd__decap_3
XFILLER_44_197 VGND VGND VPWR VPWR sky130_fd_sc_hd__decap_3
XTAP_TAPCELL_ROW_10_251 VGND VPWR sky130_fd_sc_hd__tapvpwrvgnd_1
X_1521_ Inst_LB_LUT4c_frame_config_dffesr.c_reset_value _0117_ _0548_ VGND VGND VPWR
+ VPWR _0549_ sky130_fd_sc_hd__mux2_1
XFILLER_4_282 VGND VGND VPWR VPWR sky130_fd_sc_hd__fill_2
X_1452_ Inst_SimpleCLB_ConfigMem.Inst_frame13_bit13.Q _0668_ _0508_ Inst_SimpleCLB_ConfigMem.Inst_frame13_bit14.Q
+ VGND VGND VPWR VPWR _0509_ sky130_fd_sc_hd__a211oi_1
X_1383_ _0565_ Inst_SimpleCLB_ConfigMem.Inst_frame12_bit14.Q Inst_SimpleCLB_ConfigMem.Inst_frame12_bit15.Q
+ _0447_ VGND VGND VPWR VPWR _0448_ sky130_fd_sc_hd__a211o_1
XFILLER_82_248 VGND VGND VPWR VPWR sky130_fd_sc_hd__decap_3
X_2004_ net786 net677 VGND VGND VPWR VPWR Inst_SimpleCLB_ConfigMem.Inst_frame4_bit15.Q
+ sky130_fd_sc_hd__dlxtp_1
XFILLER_35_164 VGND VGND VPWR VPWR sky130_fd_sc_hd__decap_3
XFILLER_90_281 VGND VGND VPWR VPWR sky130_fd_sc_hd__fill_1
XFILLER_35_175 VGND VGND VPWR VPWR sky130_fd_sc_hd__decap_3
XFILLER_50_112 VGND VGND VPWR VPWR sky130_fd_sc_hd__decap_3
XTAP_TAPCELL_ROW_33_387 VGND VPWR sky130_fd_sc_hd__tapvpwrvgnd_1
X_1719_ net780 net712 VGND VGND VPWR VPWR Inst_SimpleCLB_ConfigMem.Inst_frame13_bit18.Q
+ sky130_fd_sc_hd__dlxtp_1
XFILLER_58_256 VGND VGND VPWR VPWR sky130_fd_sc_hd__decap_3
XFILLER_73_204 VGND VGND VPWR VPWR sky130_fd_sc_hd__fill_2
XFILLER_14_304 VGND VGND VPWR VPWR sky130_fd_sc_hd__decap_3
XFILLER_26_153 VGND VGND VPWR VPWR sky130_fd_sc_hd__decap_3
Xrebuffer61 net331 VGND VGND VPWR VPWR net315 sky130_fd_sc_hd__buf_6
XFILLER_26_197 VGND VGND VPWR VPWR sky130_fd_sc_hd__decap_3
XTAP_TAPCELL_ROW_24_332 VGND VPWR sky130_fd_sc_hd__tapvpwrvgnd_1
XFILLER_41_167 VGND VGND VPWR VPWR sky130_fd_sc_hd__fill_1
XFILLER_41_178 VGND VGND VPWR VPWR sky130_fd_sc_hd__decap_3
XFILLER_41_75 VGND VGND VPWR VPWR sky130_fd_sc_hd__decap_3
XFILLER_49_201 VGND VGND VPWR VPWR sky130_fd_sc_hd__decap_3
XFILLER_49_223 VGND VGND VPWR VPWR sky130_fd_sc_hd__fill_1
XFILLER_2_47 VGND VGND VPWR VPWR sky130_fd_sc_hd__fill_1
XFILLER_49_234 VGND VGND VPWR VPWR sky130_fd_sc_hd__decap_3
XFILLER_49_267 VGND VGND VPWR VPWR sky130_fd_sc_hd__decap_3
XFILLER_64_259 VGND VGND VPWR VPWR sky130_fd_sc_hd__fill_2
XTAP_TAPCELL_ROW_90_736 VGND VPWR sky130_fd_sc_hd__tapvpwrvgnd_1
XFILLER_17_175 VGND VGND VPWR VPWR sky130_fd_sc_hd__fill_1
XFILLER_32_156 VGND VGND VPWR VPWR sky130_fd_sc_hd__decap_3
XANTENNA_19 EE4END[2] VGND VGND VPWR VPWR sky130_fd_sc_hd__diode_2
X_0952_ net260 VGND VGND VPWR VPWR _0052_ sky130_fd_sc_hd__inv_2
XFILLER_32_189 VGND VGND VPWR VPWR sky130_fd_sc_hd__decap_3
XTAP_TAPCELL_ROW_30_368 VGND VPWR sky130_fd_sc_hd__tapvpwrvgnd_1
X_0883_ _0708_ _0709_ Inst_SimpleCLB_ConfigMem.Inst_frame4_bit4.Q VGND VGND VPWR VPWR
+ _0710_ sky130_fd_sc_hd__mux2_1
XFILLER_63_3 VGND VGND VPWR VPWR sky130_fd_sc_hd__fill_1
Xoutput115 net115 VGND VGND VPWR VPWR N2BEGb[1] sky130_fd_sc_hd__buf_2
Xoutput104 net104 VGND VGND VPWR VPWR N1BEG[2] sky130_fd_sc_hd__buf_8
Xoutput148 net148 VGND VGND VPWR VPWR NN4BEG[4] sky130_fd_sc_hd__buf_2
Xoutput126 net126 VGND VGND VPWR VPWR N4BEG[13] sky130_fd_sc_hd__buf_4
Xoutput137 net137 VGND VGND VPWR VPWR N4BEG[9] sky130_fd_sc_hd__buf_2
Xoutput159 net159 VGND VGND VPWR VPWR S2BEG[1] sky130_fd_sc_hd__buf_4
X_1504_ _0531_ _0532_ _0533_ Inst_SimpleCLB_ConfigMem.Inst_frame0_bit27.Q Inst_SimpleCLB_ConfigMem.Inst_frame0_bit28.Q
+ VGND VGND VPWR VPWR _0534_ sky130_fd_sc_hd__a221o_1
X_1435_ Inst_SimpleCLB_ConfigMem.Inst_frame13_bit31.Q _0494_ Inst_SimpleCLB_ConfigMem.Inst_frame12_bit0.Q
+ VGND VGND VPWR VPWR _0495_ sky130_fd_sc_hd__a21oi_1
X_1366_ Inst_SimpleCLB_ConfigMem.Inst_frame11_bit9.Q _0433_ VGND VGND VPWR VPWR _0434_
+ sky130_fd_sc_hd__nand2_1
X_1297_ W2END[0] net638 net642 net629 Inst_SimpleCLB_ConfigMem.Inst_frame4_bit23.Q
+ Inst_SimpleCLB_ConfigMem.Inst_frame4_bit22.Q VGND VGND VPWR VPWR _0374_ sky130_fd_sc_hd__mux4_1
XFILLER_55_237 VGND VGND VPWR VPWR sky130_fd_sc_hd__decap_3
XFILLER_11_329 VGND VGND VPWR VPWR sky130_fd_sc_hd__decap_3
XFILLER_11_12 VGND VGND VPWR VPWR sky130_fd_sc_hd__fill_1
XFILLER_11_34 VGND VGND VPWR VPWR sky130_fd_sc_hd__decap_3
XFILLER_36_64 VGND VGND VPWR VPWR sky130_fd_sc_hd__fill_2
XFILLER_61_207 VGND VGND VPWR VPWR sky130_fd_sc_hd__decap_3
XFILLER_54_281 VGND VGND VPWR VPWR sky130_fd_sc_hd__decap_3
XFILLER_14_134 VGND VGND VPWR VPWR sky130_fd_sc_hd__decap_3
XFILLER_14_156 VGND VGND VPWR VPWR sky130_fd_sc_hd__fill_1
XFILLER_52_52 VGND VGND VPWR VPWR sky130_fd_sc_hd__fill_2
XFILLER_52_85 VGND VGND VPWR VPWR sky130_fd_sc_hd__decap_3
XFILLER_6_333 VGND VGND VPWR VPWR sky130_fd_sc_hd__decap_3
X_1220_ _0298_ _0289_ net306 _0304_ VGND VGND VPWR VPWR _0305_ sky130_fd_sc_hd__o211a_1
XFILLER_77_82 VGND VGND VPWR VPWR sky130_fd_sc_hd__decap_3
X_1151_ _0238_ _0239_ Inst_SimpleCLB_ConfigMem.Inst_frame2_bit20.Q VGND VGND VPWR
+ VPWR _0240_ sky130_fd_sc_hd__mux2_1
X_1082_ EE4END[3] WW4END[1] S4END[0] Inst_SimpleCLB_switch_matrix.JW2BEG3 Inst_SimpleCLB_ConfigMem.Inst_frame0_bit17.Q
+ Inst_SimpleCLB_ConfigMem.Inst_frame0_bit16.Q VGND VGND VPWR VPWR _0175_ sky130_fd_sc_hd__mux4_2
XFILLER_20_104 VGND VGND VPWR VPWR sky130_fd_sc_hd__decap_3
XFILLER_60_251 VGND VGND VPWR VPWR sky130_fd_sc_hd__fill_1
XFILLER_20_126 VGND VGND VPWR VPWR sky130_fd_sc_hd__fill_2
X_1984_ net758 net672 VGND VGND VPWR VPWR Inst_SimpleCLB_ConfigMem.Inst_frame5_bit27.Q
+ sky130_fd_sc_hd__dlxtp_1
XFILLER_20_159 VGND VGND VPWR VPWR sky130_fd_sc_hd__decap_3
X_0935_ E2END[3] S2END[3] net800 W2END[3] Inst_SimpleCLB_ConfigMem.Inst_frame3_bit3.Q
+ Inst_SimpleCLB_ConfigMem.Inst_frame3_bit2.Q VGND VGND VPWR VPWR _0037_ sky130_fd_sc_hd__mux4_1
X_0866_ Inst_LA_LUT4c_frame_config_dffesr.inst_cus_mux161_buf.A2 Inst_LA_LUT4c_frame_config_dffesr.inst_cus_mux161_buf.A3
+ _0648_ VGND VGND VPWR VPWR _0694_ sky130_fd_sc_hd__mux2_1
X_0797_ W2MID[6] Inst_SimpleCLB_switch_matrix.JN2BEG3 Inst_SimpleCLB_ConfigMem.Inst_frame8_bit26.Q
+ VGND VGND VPWR VPWR _0630_ sky130_fd_sc_hd__mux2_1
X_1418_ Inst_SimpleCLB_ConfigMem.Inst_frame12_bit5.Q _0479_ _0477_ Inst_SimpleCLB_ConfigMem.Inst_frame12_bit6.Q
+ VGND VGND VPWR VPWR _0480_ sky130_fd_sc_hd__o211a_1
X_2398_ WW4END[8] VGND VGND VPWR VPWR net249 sky130_fd_sc_hd__clkbuf_2
XFILLER_83_321 VGND VGND VPWR VPWR sky130_fd_sc_hd__fill_1
XFILLER_28_248 VGND VGND VPWR VPWR sky130_fd_sc_hd__decap_3
X_1349_ Inst_SimpleCLB_ConfigMem.Inst_frame11_bit23.Q _0418_ VGND VGND VPWR VPWR _0419_
+ sky130_fd_sc_hd__nand2_1
XTAP_TAPCELL_ROW_66_585 VGND VPWR sky130_fd_sc_hd__tapvpwrvgnd_1
XFILLER_51_262 VGND VGND VPWR VPWR sky130_fd_sc_hd__decap_3
XFILLER_11_159 VGND VGND VPWR VPWR sky130_fd_sc_hd__decap_3
XFILLER_7_119 VGND VGND VPWR VPWR sky130_fd_sc_hd__decap_3
XFILLER_78_137 VGND VGND VPWR VPWR sky130_fd_sc_hd__decap_3
XFILLER_86_192 VGND VGND VPWR VPWR sky130_fd_sc_hd__decap_3
XFILLER_47_41 VGND VGND VPWR VPWR sky130_fd_sc_hd__decap_3
XTAP_TAPCELL_ROW_57_530 VGND VPWR sky130_fd_sc_hd__tapvpwrvgnd_1
XFILLER_27_281 VGND VGND VPWR VPWR sky130_fd_sc_hd__decap_3
XFILLER_63_51 VGND VGND VPWR VPWR sky130_fd_sc_hd__decap_3
XFILLER_42_273 VGND VGND VPWR VPWR sky130_fd_sc_hd__decap_3
XTAP_TAPCELL_ROW_40_430 VGND VPWR sky130_fd_sc_hd__tapvpwrvgnd_1
XFILLER_8_79 VGND VGND VPWR VPWR sky130_fd_sc_hd__decap_3
XFILLER_10_181 VGND VGND VPWR VPWR sky130_fd_sc_hd__decap_3
XFILLER_6_141 VGND VGND VPWR VPWR sky130_fd_sc_hd__decap_3
XFILLER_6_174 VGND VGND VPWR VPWR sky130_fd_sc_hd__decap_3
X_2321_ S2MID[0] VGND VGND VPWR VPWR net166 sky130_fd_sc_hd__buf_1
X_2252_ net705 VGND VGND VPWR VPWR net88 sky130_fd_sc_hd__clkbuf_1
XFILLER_69_137 VGND VGND VPWR VPWR sky130_fd_sc_hd__decap_3
XFILLER_84_118 VGND VGND VPWR VPWR sky130_fd_sc_hd__decap_3
X_1203_ Inst_LH_LUT4c_frame_config_dffesr.c_I0mux _0287_ VGND VGND VPWR VPWR _0288_
+ sky130_fd_sc_hd__nor2_1
X_2183_ E6END[8] VGND VGND VPWR VPWR net30 sky130_fd_sc_hd__buf_1
X_1134_ _0222_ _0223_ Inst_SimpleCLB_ConfigMem.Inst_frame4_bit20.Q VGND VGND VPWR
+ VPWR _0224_ sky130_fd_sc_hd__mux2_1
X_1065_ _0049_ _0050_ _0041_ _0040_ Inst_SimpleCLB_ConfigMem.Inst_frame9_bit10.Q Inst_SimpleCLB_ConfigMem.Inst_frame9_bit11.Q
+ VGND VGND VPWR VPWR _0158_ sky130_fd_sc_hd__mux4_2
XFILLER_33_240 VGND VGND VPWR VPWR sky130_fd_sc_hd__decap_3
XTAP_TAPCELL_ROW_63_566 VGND VPWR sky130_fd_sc_hd__tapvpwrvgnd_1
XFILLER_33_273 VGND VGND VPWR VPWR sky130_fd_sc_hd__decap_3
X_1967_ net796 net673 VGND VGND VPWR VPWR Inst_SimpleCLB_ConfigMem.Inst_frame5_bit10.Q
+ sky130_fd_sc_hd__dlxtp_1
X_0918_ _0021_ _0018_ Inst_SimpleCLB_ConfigMem.Inst_frame2_bit5.Q VGND VGND VPWR VPWR
+ Inst_SimpleCLB_switch_matrix.JS2BEG2 sky130_fd_sc_hd__mux2_4
X_1898_ net741 net664 VGND VGND VPWR VPWR Inst_SimpleCLB_ConfigMem.Inst_frame7_bit5.Q
+ sky130_fd_sc_hd__dlxtp_1
X_0849_ _0678_ _0675_ Inst_SimpleCLB_ConfigMem.Inst_frame1_bit1.Q VGND VGND VPWR VPWR
+ Inst_SimpleCLB_switch_matrix.JW2BEG1 sky130_fd_sc_hd__mux2_4
XFILLER_0_306 VGND VGND VPWR VPWR sky130_fd_sc_hd__fill_2
XFILLER_68_18 VGND VGND VPWR VPWR sky130_fd_sc_hd__decap_3
XFILLER_68_29 VGND VGND VPWR VPWR sky130_fd_sc_hd__decap_3
XFILLER_75_107 VGND VGND VPWR VPWR sky130_fd_sc_hd__fill_1
XFILLER_68_192 VGND VGND VPWR VPWR sky130_fd_sc_hd__decap_3
XFILLER_83_195 VGND VGND VPWR VPWR sky130_fd_sc_hd__fill_2
XFILLER_71_335 VGND VGND VPWR VPWR sky130_fd_sc_hd__fill_1
XFILLER_24_251 VGND VGND VPWR VPWR sky130_fd_sc_hd__fill_1
XFILLER_24_262 VGND VGND VPWR VPWR sky130_fd_sc_hd__decap_3
XFILLER_59_181 VGND VGND VPWR VPWR sky130_fd_sc_hd__decap_3
XFILLER_62_346 VGND VGND VPWR VPWR sky130_fd_sc_hd__fill_1
X_1821_ net765 net724 VGND VGND VPWR VPWR Inst_SimpleCLB_ConfigMem.Inst_frame10_bit24.Q
+ sky130_fd_sc_hd__dlxtp_1
XFILLER_30_298 VGND VGND VPWR VPWR sky130_fd_sc_hd__decap_3
X_1752_ net779 net717 VGND VGND VPWR VPWR Inst_SimpleCLB_ConfigMem.Inst_frame12_bit19.Q
+ sky130_fd_sc_hd__dlxtp_1
X_1683_ net789 net707 VGND VGND VPWR VPWR Inst_LH_LUT4c_frame_config_dffesr.inst_cus_mux161_buf.A7
+ sky130_fd_sc_hd__dlxtp_1
XFILLER_57_107 VGND VGND VPWR VPWR sky130_fd_sc_hd__decap_3
X_2304_ NN4END[15] VGND VGND VPWR VPWR net140 sky130_fd_sc_hd__clkbuf_1
X_2235_ net750 VGND VGND VPWR VPWR net73 sky130_fd_sc_hd__buf_1
X_2166_ Inst_SimpleCLB_switch_matrix.E2BEG5 VGND VGND VPWR VPWR net11 sky130_fd_sc_hd__buf_1
XFILLER_65_140 VGND VGND VPWR VPWR sky130_fd_sc_hd__decap_3
X_1117_ _0207_ _0206_ Inst_SimpleCLB_ConfigMem.Inst_frame9_bit25.Q VGND VGND VPWR
+ VPWR _0208_ sky130_fd_sc_hd__mux2_1
XFILLER_65_184 VGND VGND VPWR VPWR sky130_fd_sc_hd__decap_3
X_2097_ net792 net689 VGND VGND VPWR VPWR Inst_SimpleCLB_ConfigMem.Inst_frame1_bit12.Q
+ sky130_fd_sc_hd__dlxtp_1
X_1048_ N4END[1] SS4END[1] W2END[4] Inst_SimpleCLB_switch_matrix.JS2BEG3 Inst_SimpleCLB_ConfigMem.Inst_frame0_bit14.Q
+ Inst_SimpleCLB_ConfigMem.Inst_frame0_bit15.Q VGND VGND VPWR VPWR _0142_ sky130_fd_sc_hd__mux4_2
XFILLER_0_91 VGND VGND VPWR VPWR sky130_fd_sc_hd__decap_3
XPHY_EDGE_ROW_3_Right_3 VGND VGND VPWR VPWR sky130_fd_sc_hd__decap_3
XFILLER_79_39 VGND VGND VPWR VPWR sky130_fd_sc_hd__decap_3
XTAP_TAPCELL_ROW_8_236 VGND VPWR sky130_fd_sc_hd__tapvpwrvgnd_1
XFILLER_0_125 VGND VGND VPWR VPWR sky130_fd_sc_hd__decap_3
XFILLER_0_169 VGND VGND VPWR VPWR sky130_fd_sc_hd__decap_3
XFILLER_88_298 VGND VGND VPWR VPWR sky130_fd_sc_hd__fill_1
XFILLER_48_118 VGND VGND VPWR VPWR sky130_fd_sc_hd__fill_1
XFILLER_71_110 VGND VGND VPWR VPWR sky130_fd_sc_hd__fill_2
XTAP_TAPCELL_ROW_82_683 VGND VPWR sky130_fd_sc_hd__tapvpwrvgnd_1
XFILLER_12_221 VGND VGND VPWR VPWR sky130_fd_sc_hd__fill_2
XFILLER_8_203 VGND VGND VPWR VPWR sky130_fd_sc_hd__decap_3
XFILLER_44_97 VGND VGND VPWR VPWR sky130_fd_sc_hd__decap_3
XFILLER_12_276 VGND VGND VPWR VPWR sky130_fd_sc_hd__decap_3
XFILLER_8_236 VGND VGND VPWR VPWR sky130_fd_sc_hd__decap_3
XFILLER_60_85 VGND VGND VPWR VPWR sky130_fd_sc_hd__decap_3
X_2020_ net747 net675 VGND VGND VPWR VPWR Inst_SimpleCLB_ConfigMem.Inst_frame4_bit31.Q
+ sky130_fd_sc_hd__dlxtp_1
XFILLER_85_82 VGND VGND VPWR VPWR sky130_fd_sc_hd__decap_3
XFILLER_47_162 VGND VGND VPWR VPWR sky130_fd_sc_hd__decap_3
XFILLER_35_346 VGND VGND VPWR VPWR sky130_fd_sc_hd__fill_1
XFILLER_62_121 VGND VGND VPWR VPWR sky130_fd_sc_hd__decap_3
XFILLER_50_338 VGND VGND VPWR VPWR sky130_fd_sc_hd__fill_1
XTAP_TAPCELL_ROW_13_271 VGND VPWR sky130_fd_sc_hd__tapvpwrvgnd_1
X_1804_ net738 net728 VGND VGND VPWR VPWR Inst_SimpleCLB_ConfigMem.Inst_frame10_bit7.Q
+ sky130_fd_sc_hd__dlxtp_1
X_1735_ net751 net718 VGND VGND VPWR VPWR Inst_SimpleCLB_ConfigMem.Inst_frame12_bit2.Q
+ sky130_fd_sc_hd__dlxtp_1
X_1666_ net755 net705 VGND VGND VPWR VPWR Inst_LG_LUT4c_frame_config_dffesr.inst_cus_mux161_buf.A9
+ sky130_fd_sc_hd__dlxtp_1
X_1597_ net764 net697 VGND VGND VPWR VPWR Inst_LC_LUT4c_frame_config_dffesr.c_out_mux
+ sky130_fd_sc_hd__dlxtp_1
Xfanout705 net706 VGND VGND VPWR VPWR net705 sky130_fd_sc_hd__clkbuf_2
Xfanout738 FrameData[7] VGND VGND VPWR VPWR net738 sky130_fd_sc_hd__buf_4
Xfanout716 net717 VGND VGND VPWR VPWR net716 sky130_fd_sc_hd__clkbuf_2
Xfanout749 net750 VGND VGND VPWR VPWR net749 sky130_fd_sc_hd__clkbuf_4
Xfanout727 net728 VGND VGND VPWR VPWR net727 sky130_fd_sc_hd__clkbuf_2
XFILLER_85_279 VGND VGND VPWR VPWR sky130_fd_sc_hd__fill_1
X_2218_ net791 VGND VGND VPWR VPWR net54 sky130_fd_sc_hd__clkbuf_2
XANTENNA_109 S4END[0] VGND VGND VPWR VPWR sky130_fd_sc_hd__diode_2
X_2149_ clknet_1_1__leaf_UserCLK_regs _0000_ VGND VGND VPWR VPWR Inst_LH_LUT4c_frame_config_dffesr.LUT_flop
+ sky130_fd_sc_hd__dfxtp_1
XFILLER_14_78 VGND VGND VPWR VPWR sky130_fd_sc_hd__decap_3
XFILLER_14_56 VGND VGND VPWR VPWR sky130_fd_sc_hd__decap_3
XFILLER_5_228 VGND VGND VPWR VPWR sky130_fd_sc_hd__decap_3
XFILLER_5_217 VGND VGND VPWR VPWR sky130_fd_sc_hd__decap_3
XFILLER_30_44 VGND VGND VPWR VPWR sky130_fd_sc_hd__decap_3
XFILLER_17_346 VGND VGND VPWR VPWR sky130_fd_sc_hd__fill_1
XTAP_TAPCELL_ROW_27_352 VGND VPWR sky130_fd_sc_hd__tapvpwrvgnd_1
XFILLER_55_63 VGND VGND VPWR VPWR sky130_fd_sc_hd__decap_3
XFILLER_44_187 VGND VGND VPWR VPWR sky130_fd_sc_hd__decap_3
XFILLER_71_73 VGND VGND VPWR VPWR sky130_fd_sc_hd__fill_2
XTAP_TAPCELL_ROW_10_252 VGND VPWR sky130_fd_sc_hd__tapvpwrvgnd_1
X_1520_ Inst_SimpleCLB_ConfigMem.Inst_frame10_bit28.Q _0539_ VGND VGND VPWR VPWR _0548_
+ sky130_fd_sc_hd__nand2_1
XFILLER_4_250 VGND VGND VPWR VPWR sky130_fd_sc_hd__fill_2
X_1451_ Inst_SimpleCLB_ConfigMem.Inst_frame13_bit13.Q net264 VGND VGND VPWR VPWR _0508_
+ sky130_fd_sc_hd__nor2_1
X_1382_ net651 Inst_SimpleCLB_ConfigMem.Inst_frame12_bit14.Q VGND VGND VPWR VPWR _0447_
+ sky130_fd_sc_hd__nor2_1
XFILLER_82_227 VGND VGND VPWR VPWR sky130_fd_sc_hd__decap_3
X_2003_ net788 net677 VGND VGND VPWR VPWR Inst_SimpleCLB_ConfigMem.Inst_frame4_bit14.Q
+ sky130_fd_sc_hd__dlxtp_1
XFILLER_23_305 VGND VGND VPWR VPWR sky130_fd_sc_hd__decap_3
XFILLER_50_124 VGND VGND VPWR VPWR sky130_fd_sc_hd__decap_3
XTAP_TAPCELL_ROW_33_388 VGND VPWR sky130_fd_sc_hd__tapvpwrvgnd_1
X_1718_ net782 net712 VGND VGND VPWR VPWR Inst_SimpleCLB_ConfigMem.Inst_frame13_bit17.Q
+ sky130_fd_sc_hd__dlxtp_1
X_1649_ net792 net704 VGND VGND VPWR VPWR Inst_LF_LUT4c_frame_config_dffesr.inst_cus_mux161_buf.A11
+ sky130_fd_sc_hd__dlxtp_1
XFILLER_76_29 VGND VGND VPWR VPWR sky130_fd_sc_hd__decap_3
XFILLER_58_235 VGND VGND VPWR VPWR sky130_fd_sc_hd__decap_3
XFILLER_58_279 VGND VGND VPWR VPWR sky130_fd_sc_hd__decap_3
Xrebuffer62 net315 VGND VGND VPWR VPWR net316 sky130_fd_sc_hd__dlygate4sd1_1
XFILLER_41_113 VGND VGND VPWR VPWR sky130_fd_sc_hd__fill_2
XTAP_TAPCELL_ROW_24_333 VGND VPWR sky130_fd_sc_hd__tapvpwrvgnd_1
XFILLER_25_66 VGND VGND VPWR VPWR sky130_fd_sc_hd__fill_1
XFILLER_41_135 VGND VGND VPWR VPWR sky130_fd_sc_hd__fill_1
XFILLER_41_54 VGND VGND VPWR VPWR sky130_fd_sc_hd__fill_2
XFILLER_49_213 VGND VGND VPWR VPWR sky130_fd_sc_hd__fill_1
XFILLER_1_297 VGND VGND VPWR VPWR sky130_fd_sc_hd__decap_3
XFILLER_49_246 VGND VGND VPWR VPWR sky130_fd_sc_hd__decap_3
XFILLER_49_279 VGND VGND VPWR VPWR sky130_fd_sc_hd__fill_1
XFILLER_66_62 VGND VGND VPWR VPWR sky130_fd_sc_hd__decap_3
XFILLER_17_110 VGND VGND VPWR VPWR sky130_fd_sc_hd__fill_2
XTAP_TAPCELL_ROW_90_737 VGND VPWR sky130_fd_sc_hd__tapvpwrvgnd_1
XFILLER_82_50 VGND VGND VPWR VPWR sky130_fd_sc_hd__decap_3
XFILLER_17_165 VGND VGND VPWR VPWR sky130_fd_sc_hd__decap_3
XFILLER_82_83 VGND VGND VPWR VPWR sky130_fd_sc_hd__fill_1
XFILLER_32_135 VGND VGND VPWR VPWR sky130_fd_sc_hd__decap_3
XFILLER_32_179 VGND VGND VPWR VPWR sky130_fd_sc_hd__decap_3
X_0951_ _0049_ _0050_ _0041_ _0040_ Inst_SimpleCLB_ConfigMem.Inst_frame9_bit0.Q Inst_SimpleCLB_ConfigMem.Inst_frame9_bit1.Q
+ VGND VGND VPWR VPWR _0051_ sky130_fd_sc_hd__mux4_2
XTAP_TAPCELL_ROW_30_369 VGND VPWR sky130_fd_sc_hd__tapvpwrvgnd_1
X_0882_ E2END[3] S2END[3] E6END[1] W2END[3] Inst_SimpleCLB_ConfigMem.Inst_frame4_bit3.Q
+ Inst_SimpleCLB_ConfigMem.Inst_frame4_bit2.Q VGND VGND VPWR VPWR _0709_ sky130_fd_sc_hd__mux4_1
Xoutput105 net105 VGND VGND VPWR VPWR N1BEG[3] sky130_fd_sc_hd__buf_4
Xoutput116 net116 VGND VGND VPWR VPWR N2BEGb[2] sky130_fd_sc_hd__buf_2
XFILLER_56_3 VGND VGND VPWR VPWR sky130_fd_sc_hd__decap_3
Xoutput127 net127 VGND VGND VPWR VPWR N4BEG[14] sky130_fd_sc_hd__clkbuf_4
Xoutput138 net138 VGND VGND VPWR VPWR NN4BEG[0] sky130_fd_sc_hd__buf_2
Xoutput149 net149 VGND VGND VPWR VPWR NN4BEG[5] sky130_fd_sc_hd__buf_2
X_1503_ _0724_ _0126_ Inst_SimpleCLB_ConfigMem.Inst_frame0_bit26.Q VGND VGND VPWR
+ VPWR _0533_ sky130_fd_sc_hd__mux2_1
XFILLER_87_319 VGND VGND VPWR VPWR sky130_fd_sc_hd__fill_2
X_1434_ S1END[2] net634 Inst_SimpleCLB_ConfigMem.Inst_frame13_bit30.Q VGND VGND VPWR
+ VPWR _0494_ sky130_fd_sc_hd__mux2_1
X_1365_ net645 _0068_ Inst_SimpleCLB_ConfigMem.Inst_frame11_bit8.Q VGND VGND VPWR
+ VPWR _0433_ sky130_fd_sc_hd__mux2_1
X_1296_ _0368_ _0370_ _0373_ _0593_ VGND VGND VPWR VPWR Inst_SimpleCLB_switch_matrix.E2BEG0
+ sky130_fd_sc_hd__a22o_1
XFILLER_23_102 VGND VGND VPWR VPWR sky130_fd_sc_hd__decap_3
XFILLER_23_113 VGND VGND VPWR VPWR sky130_fd_sc_hd__fill_2
XFILLER_63_271 VGND VGND VPWR VPWR sky130_fd_sc_hd__decap_3
XTAP_TAPCELL_ROW_21_314 VGND VPWR sky130_fd_sc_hd__tapvpwrvgnd_1
XFILLER_31_190 VGND VGND VPWR VPWR sky130_fd_sc_hd__decap_3
XFILLER_11_57 VGND VGND VPWR VPWR sky130_fd_sc_hd__fill_2
XFILLER_46_227 VGND VGND VPWR VPWR sky130_fd_sc_hd__decap_3
XFILLER_36_43 VGND VGND VPWR VPWR sky130_fd_sc_hd__decap_3
XFILLER_54_260 VGND VGND VPWR VPWR sky130_fd_sc_hd__decap_3
XFILLER_61_219 VGND VGND VPWR VPWR sky130_fd_sc_hd__fill_1
XFILLER_54_293 VGND VGND VPWR VPWR sky130_fd_sc_hd__decap_3
XFILLER_52_20 VGND VGND VPWR VPWR sky130_fd_sc_hd__decap_3
XFILLER_77_50 VGND VGND VPWR VPWR sky130_fd_sc_hd__decap_3
X_1150_ S1END[3] W1END[1] S2END[7] W1END[3] Inst_SimpleCLB_ConfigMem.Inst_frame2_bit19.Q
+ Inst_SimpleCLB_ConfigMem.Inst_frame2_bit18.Q VGND VGND VPWR VPWR _0239_ sky130_fd_sc_hd__mux4_1
XFILLER_37_205 VGND VGND VPWR VPWR sky130_fd_sc_hd__decap_3
X_1081_ Inst_LF_LUT4c_frame_config_dffesr.inst_cus_mux161_buf.A8 Inst_LF_LUT4c_frame_config_dffesr.inst_cus_mux161_buf.A10
+ Inst_LF_LUT4c_frame_config_dffesr.inst_cus_mux161_buf.A12 Inst_LF_LUT4c_frame_config_dffesr.inst_cus_mux161_buf.A14
+ _0167_ _0166_ VGND VGND VPWR VPWR _0174_ sky130_fd_sc_hd__mux4_1
XTAP_TAPCELL_ROW_43_450 VGND VPWR sky130_fd_sc_hd__tapvpwrvgnd_1
X_1983_ net760 net672 VGND VGND VPWR VPWR Inst_SimpleCLB_ConfigMem.Inst_frame5_bit26.Q
+ sky130_fd_sc_hd__dlxtp_1
X_0934_ _0035_ _0034_ Inst_SimpleCLB_ConfigMem.Inst_frame3_bit4.Q VGND VGND VPWR VPWR
+ _0036_ sky130_fd_sc_hd__mux2_4
X_0865_ Inst_LA_LUT4c_frame_config_dffesr.inst_cus_mux161_buf.A0 Inst_LA_LUT4c_frame_config_dffesr.inst_cus_mux161_buf.A1
+ _0648_ VGND VGND VPWR VPWR _0693_ sky130_fd_sc_hd__mux2_1
X_0796_ Inst_SimpleCLB_ConfigMem.Inst_frame8_bit27.Q _0628_ VGND VGND VPWR VPWR _0629_
+ sky130_fd_sc_hd__and2b_1
X_1417_ _0478_ VGND VGND VPWR VPWR _0479_ sky130_fd_sc_hd__inv_1
X_2397_ WW4END[7] VGND VGND VPWR VPWR net248 sky130_fd_sc_hd__clkbuf_2
XFILLER_68_341 VGND VGND VPWR VPWR sky130_fd_sc_hd__fill_2
X_1348_ _0050_ _0244_ Inst_SimpleCLB_ConfigMem.Inst_frame11_bit22.Q VGND VGND VPWR
+ VPWR _0418_ sky130_fd_sc_hd__mux2_1
X_1279_ _0357_ _0358_ Inst_SimpleCLB_ConfigMem.Inst_frame3_bit28.Q VGND VGND VPWR
+ VPWR _0359_ sky130_fd_sc_hd__mux2_1
XTAP_TAPCELL_ROW_66_586 VGND VPWR sky130_fd_sc_hd__tapvpwrvgnd_1
XFILLER_7_109 VGND VGND VPWR VPWR sky130_fd_sc_hd__decap_3
XTAP_TAPCELL_ROW_57_531 VGND VPWR sky130_fd_sc_hd__tapvpwrvgnd_1
XFILLER_74_344 VGND VGND VPWR VPWR sky130_fd_sc_hd__decap_3
XFILLER_27_293 VGND VGND VPWR VPWR sky130_fd_sc_hd__decap_3
XFILLER_63_63 VGND VGND VPWR VPWR sky130_fd_sc_hd__decap_3
XFILLER_63_96 VGND VGND VPWR VPWR sky130_fd_sc_hd__decap_3
XFILLER_8_47 VGND VGND VPWR VPWR sky130_fd_sc_hd__decap_3
XTAP_TAPCELL_ROW_40_431 VGND VPWR sky130_fd_sc_hd__tapvpwrvgnd_1
XFILLER_10_193 VGND VGND VPWR VPWR sky130_fd_sc_hd__decap_3
XFILLER_6_153 VGND VGND VPWR VPWR sky130_fd_sc_hd__decap_3
XFILLER_6_131 VGND VGND VPWR VPWR sky130_fd_sc_hd__decap_3
XFILLER_6_186 VGND VGND VPWR VPWR sky130_fd_sc_hd__decap_3
XFILLER_6_197 VGND VGND VPWR VPWR sky130_fd_sc_hd__decap_3
X_2320_ Inst_SimpleCLB_switch_matrix.JS2BEG7 VGND VGND VPWR VPWR net165 sky130_fd_sc_hd__buf_1
XFILLER_69_116 VGND VGND VPWR VPWR sky130_fd_sc_hd__decap_3
X_2251_ net708 VGND VGND VPWR VPWR net87 sky130_fd_sc_hd__clkbuf_1
XPHY_EDGE_ROW_0_Left_91 VGND VGND VPWR VPWR sky130_fd_sc_hd__decap_3
XFILLER_69_149 VGND VGND VPWR VPWR sky130_fd_sc_hd__fill_2
X_1202_ _0225_ _0226_ _0231_ _0229_ Inst_SimpleCLB_ConfigMem.Inst_frame8_bit16.Q Inst_SimpleCLB_ConfigMem.Inst_frame8_bit17.Q
+ VGND VGND VPWR VPWR _0287_ sky130_fd_sc_hd__mux4_1
X_2182_ E6END[7] VGND VGND VPWR VPWR net29 sky130_fd_sc_hd__buf_1
XFILLER_19_3 VGND VGND VPWR VPWR sky130_fd_sc_hd__fill_2
X_1133_ S1END[3] W1END[1] S2END[7] net646 Inst_SimpleCLB_ConfigMem.Inst_frame4_bit19.Q
+ Inst_SimpleCLB_ConfigMem.Inst_frame4_bit18.Q VGND VGND VPWR VPWR _0223_ sky130_fd_sc_hd__mux4_1
XFILLER_65_344 VGND VGND VPWR VPWR sky130_fd_sc_hd__decap_3
XFILLER_25_208 VGND VGND VPWR VPWR sky130_fd_sc_hd__decap_3
X_1064_ _0156_ VGND VGND VPWR VPWR _0157_ sky130_fd_sc_hd__inv_2
XFILLER_33_252 VGND VGND VPWR VPWR sky130_fd_sc_hd__decap_3
XTAP_TAPCELL_ROW_63_567 VGND VPWR sky130_fd_sc_hd__tapvpwrvgnd_1
X_1966_ net733 net672 VGND VGND VPWR VPWR Inst_SimpleCLB_ConfigMem.Inst_frame5_bit9.Q
+ sky130_fd_sc_hd__dlxtp_1
X_0917_ _0019_ _0020_ Inst_SimpleCLB_ConfigMem.Inst_frame2_bit4.Q VGND VGND VPWR VPWR
+ _0021_ sky130_fd_sc_hd__mux2_1
X_1897_ net743 net664 VGND VGND VPWR VPWR Inst_SimpleCLB_ConfigMem.Inst_frame7_bit4.Q
+ sky130_fd_sc_hd__dlxtp_1
X_0848_ _0677_ _0676_ Inst_SimpleCLB_ConfigMem.Inst_frame1_bit0.Q VGND VGND VPWR VPWR
+ _0678_ sky130_fd_sc_hd__mux2_1
X_0779_ net653 net650 N2END[2] N4END[2] Inst_SimpleCLB_ConfigMem.Inst_frame4_bit30.Q
+ Inst_SimpleCLB_ConfigMem.Inst_frame4_bit31.Q VGND VGND VPWR VPWR _0614_ sky130_fd_sc_hd__mux4_1
XFILLER_0_318 VGND VGND VPWR VPWR sky130_fd_sc_hd__decap_3
XFILLER_84_29 VGND VGND VPWR VPWR sky130_fd_sc_hd__decap_3
XFILLER_75_119 VGND VGND VPWR VPWR sky130_fd_sc_hd__decap_3
XFILLER_83_152 VGND VGND VPWR VPWR sky130_fd_sc_hd__decap_3
XTAP_TAPCELL_ROW_54_512 VGND VPWR sky130_fd_sc_hd__tapvpwrvgnd_1
XFILLER_33_66 VGND VGND VPWR VPWR sky130_fd_sc_hd__decap_3
XFILLER_33_88 VGND VGND VPWR VPWR sky130_fd_sc_hd__decap_3
XFILLER_58_52 VGND VGND VPWR VPWR sky130_fd_sc_hd__fill_2
XFILLER_58_85 VGND VGND VPWR VPWR sky130_fd_sc_hd__decap_3
XFILLER_59_160 VGND VGND VPWR VPWR sky130_fd_sc_hd__decap_3
XFILLER_59_193 VGND VGND VPWR VPWR sky130_fd_sc_hd__decap_3
XFILLER_74_141 VGND VGND VPWR VPWR sky130_fd_sc_hd__decap_3
XFILLER_74_51 VGND VGND VPWR VPWR sky130_fd_sc_hd__decap_3
XFILLER_30_200 VGND VGND VPWR VPWR sky130_fd_sc_hd__decap_3
X_1820_ net767 net726 VGND VGND VPWR VPWR Inst_SimpleCLB_ConfigMem.Inst_frame10_bit23.Q
+ sky130_fd_sc_hd__dlxtp_1
XTAP_TAPCELL_ROW_60_548 VGND VPWR sky130_fd_sc_hd__tapvpwrvgnd_1
XFILLER_30_277 VGND VGND VPWR VPWR sky130_fd_sc_hd__decap_3
X_1751_ net781 net717 VGND VGND VPWR VPWR Inst_SimpleCLB_ConfigMem.Inst_frame12_bit18.Q
+ sky130_fd_sc_hd__dlxtp_1
X_1682_ net791 net709 VGND VGND VPWR VPWR Inst_LH_LUT4c_frame_config_dffesr.inst_cus_mux161_buf.A6
+ sky130_fd_sc_hd__dlxtp_1
X_2303_ NN4END[14] VGND VGND VPWR VPWR net139 sky130_fd_sc_hd__buf_1
X_2234_ net755 VGND VGND VPWR VPWR net71 sky130_fd_sc_hd__clkbuf_1
XFILLER_57_119 VGND VGND VPWR VPWR sky130_fd_sc_hd__decap_3
X_2165_ Inst_SimpleCLB_switch_matrix.E2BEG4 VGND VGND VPWR VPWR net10 sky130_fd_sc_hd__buf_6
X_1116_ _0184_ _0185_ Inst_SimpleCLB_ConfigMem.Inst_frame9_bit24.Q VGND VGND VPWR
+ VPWR _0207_ sky130_fd_sc_hd__mux2_1
XFILLER_65_152 VGND VGND VPWR VPWR sky130_fd_sc_hd__decap_3
XFILLER_65_196 VGND VGND VPWR VPWR sky130_fd_sc_hd__decap_3
X_2096_ net794 net689 VGND VGND VPWR VPWR Inst_SimpleCLB_ConfigMem.Inst_frame1_bit11.Q
+ sky130_fd_sc_hd__dlxtp_1
X_1047_ _0139_ _0140_ _0131_ _0130_ Inst_SimpleCLB_ConfigMem.Inst_frame9_bit20.Q Inst_SimpleCLB_ConfigMem.Inst_frame9_bit21.Q
+ VGND VGND VPWR VPWR _0141_ sky130_fd_sc_hd__mux4_2
XFILLER_80_144 VGND VGND VPWR VPWR sky130_fd_sc_hd__decap_3
XFILLER_80_166 VGND VGND VPWR VPWR sky130_fd_sc_hd__fill_1
XFILLER_21_222 VGND VGND VPWR VPWR sky130_fd_sc_hd__fill_2
XFILLER_21_244 VGND VGND VPWR VPWR sky130_fd_sc_hd__decap_3
X_1949_ net764 net667 VGND VGND VPWR VPWR Inst_SimpleCLB_ConfigMem.Inst_frame6_bit24.Q
+ sky130_fd_sc_hd__dlxtp_1
XTAP_TAPCELL_ROW_8_237 VGND VPWR sky130_fd_sc_hd__tapvpwrvgnd_1
XFILLER_0_137 VGND VGND VPWR VPWR sky130_fd_sc_hd__decap_3
XFILLER_28_66 VGND VGND VPWR VPWR sky130_fd_sc_hd__fill_2
XFILLER_28_88 VGND VGND VPWR VPWR sky130_fd_sc_hd__decap_3
XFILLER_28_99 VGND VGND VPWR VPWR sky130_fd_sc_hd__decap_3
XFILLER_44_32 VGND VGND VPWR VPWR sky130_fd_sc_hd__fill_2
XTAP_TAPCELL_ROW_82_684 VGND VPWR sky130_fd_sc_hd__tapvpwrvgnd_1
XFILLER_12_200 VGND VGND VPWR VPWR sky130_fd_sc_hd__decap_3
XFILLER_12_288 VGND VGND VPWR VPWR sky130_fd_sc_hd__fill_1
XFILLER_8_215 VGND VGND VPWR VPWR sky130_fd_sc_hd__decap_3
XFILLER_60_53 VGND VGND VPWR VPWR sky130_fd_sc_hd__decap_3
XFILLER_79_200 VGND VGND VPWR VPWR sky130_fd_sc_hd__decap_3
XFILLER_39_119 VGND VGND VPWR VPWR sky130_fd_sc_hd__decap_3
XPHY_EDGE_ROW_13_Right_13 VGND VGND VPWR VPWR sky130_fd_sc_hd__decap_3
XFILLER_62_133 VGND VGND VPWR VPWR sky130_fd_sc_hd__decap_3
XFILLER_86_3 VGND VGND VPWR VPWR sky130_fd_sc_hd__decap_3
XPHY_EDGE_ROW_22_Right_22 VGND VGND VPWR VPWR sky130_fd_sc_hd__decap_3
X_1803_ net740 net728 VGND VGND VPWR VPWR Inst_SimpleCLB_ConfigMem.Inst_frame10_bit6.Q
+ sky130_fd_sc_hd__dlxtp_1
X_1734_ net777 net718 VGND VGND VPWR VPWR Inst_SimpleCLB_ConfigMem.Inst_frame12_bit1.Q
+ sky130_fd_sc_hd__dlxtp_1
X_1665_ net757 net705 VGND VGND VPWR VPWR Inst_LG_LUT4c_frame_config_dffesr.inst_cus_mux161_buf.A8
+ sky130_fd_sc_hd__dlxtp_1
X_1596_ net767 net695 VGND VGND VPWR VPWR Inst_LC_LUT4c_frame_config_dffesr.inst_cus_mux161_buf.A15
+ sky130_fd_sc_hd__dlxtp_1
Xfanout706 FrameStrobe[15] VGND VGND VPWR VPWR net706 sky130_fd_sc_hd__clkbuf_2
XTAP_TAPCELL_ROW_5_218 VGND VPWR sky130_fd_sc_hd__tapvpwrvgnd_1
Xfanout739 net740 VGND VGND VPWR VPWR net739 sky130_fd_sc_hd__clkbuf_4
Xfanout728 FrameStrobe[10] VGND VGND VPWR VPWR net728 sky130_fd_sc_hd__buf_4
Xfanout717 FrameStrobe[12] VGND VGND VPWR VPWR net717 sky130_fd_sc_hd__clkbuf_2
XFILLER_85_225 VGND VGND VPWR VPWR sky130_fd_sc_hd__decap_3
XPHY_EDGE_ROW_31_Right_31 VGND VGND VPWR VPWR sky130_fd_sc_hd__decap_3
X_2217_ net792 VGND VGND VPWR VPWR net53 sky130_fd_sc_hd__clkbuf_2
XFILLER_38_141 VGND VGND VPWR VPWR sky130_fd_sc_hd__decap_3
X_2148_ net747 net730 VGND VGND VPWR VPWR Inst_SimpleCLB_ConfigMem.Inst_frame0_bit31.Q
+ sky130_fd_sc_hd__dlxtp_1
XFILLER_26_336 VGND VGND VPWR VPWR sky130_fd_sc_hd__decap_3
X_2079_ net760 net684 VGND VGND VPWR VPWR Inst_SimpleCLB_ConfigMem.Inst_frame2_bit26.Q
+ sky130_fd_sc_hd__dlxtp_1
XFILLER_53_166 VGND VGND VPWR VPWR sky130_fd_sc_hd__fill_2
XFILLER_81_19 VGND VGND VPWR VPWR sky130_fd_sc_hd__decap_3
XPHY_EDGE_ROW_40_Right_40 VGND VGND VPWR VPWR sky130_fd_sc_hd__decap_3
XFILLER_30_23 VGND VGND VPWR VPWR sky130_fd_sc_hd__decap_3
XFILLER_30_56 VGND VGND VPWR VPWR sky130_fd_sc_hd__decap_3
XTAP_TAPCELL_ROW_87_710 VGND VPWR sky130_fd_sc_hd__tapvpwrvgnd_1
XFILLER_39_43 VGND VGND VPWR VPWR sky130_fd_sc_hd__decap_3
XFILLER_29_130 VGND VGND VPWR VPWR sky130_fd_sc_hd__fill_2
XFILLER_39_87 VGND VGND VPWR VPWR sky130_fd_sc_hd__decap_3
XFILLER_29_185 VGND VGND VPWR VPWR sky130_fd_sc_hd__decap_3
XFILLER_44_100 VGND VGND VPWR VPWR sky130_fd_sc_hd__decap_3
XFILLER_44_122 VGND VGND VPWR VPWR sky130_fd_sc_hd__decap_3
XFILLER_55_75 VGND VGND VPWR VPWR sky130_fd_sc_hd__decap_3
XTAP_TAPCELL_ROW_27_353 VGND VPWR sky130_fd_sc_hd__tapvpwrvgnd_1
XTAP_TAPCELL_ROW_70_610 VGND VPWR sky130_fd_sc_hd__tapvpwrvgnd_1
XTAP_TAPCELL_ROW_10_253 VGND VPWR sky130_fd_sc_hd__tapvpwrvgnd_1
X_1450_ net297 _0131_ Inst_SimpleCLB_ConfigMem.Inst_frame13_bit13.Q VGND VGND VPWR
+ VPWR _0507_ sky130_fd_sc_hd__mux2_4
X_1381_ _0442_ _0445_ _0446_ Inst_SimpleCLB_ConfigMem.Inst_frame11_bit4.Q VGND VGND
+ VPWR VPWR Inst_SimpleCLB_switch_matrix.SS4BEG0 sky130_fd_sc_hd__o22a_1
XFILLER_82_239 VGND VGND VPWR VPWR sky130_fd_sc_hd__decap_3
X_2002_ net791 net676 VGND VGND VPWR VPWR Inst_SimpleCLB_ConfigMem.Inst_frame4_bit13.Q
+ sky130_fd_sc_hd__dlxtp_1
XFILLER_35_155 VGND VGND VPWR VPWR sky130_fd_sc_hd__decap_3
XFILLER_23_317 VGND VGND VPWR VPWR sky130_fd_sc_hd__decap_3
XFILLER_50_103 VGND VGND VPWR VPWR sky130_fd_sc_hd__decap_3
XFILLER_50_136 VGND VGND VPWR VPWR sky130_fd_sc_hd__decap_3
XFILLER_50_147 VGND VGND VPWR VPWR sky130_fd_sc_hd__decap_3
XTAP_TAPCELL_ROW_33_389 VGND VPWR sky130_fd_sc_hd__tapvpwrvgnd_1
X_1717_ net784 net712 VGND VGND VPWR VPWR Inst_SimpleCLB_ConfigMem.Inst_frame13_bit16.Q
+ sky130_fd_sc_hd__dlxtp_1
X_1648_ net795 net703 VGND VGND VPWR VPWR Inst_LF_LUT4c_frame_config_dffesr.inst_cus_mux161_buf.A10
+ sky130_fd_sc_hd__dlxtp_1
X_1579_ net739 net697 VGND VGND VPWR VPWR Inst_LB_LUT4c_frame_config_dffesr.c_I0mux
+ sky130_fd_sc_hd__dlxtp_1
XFILLER_58_203 VGND VGND VPWR VPWR sky130_fd_sc_hd__fill_1
XFILLER_58_247 VGND VGND VPWR VPWR sky130_fd_sc_hd__decap_3
Xrebuffer30 _0218_ VGND VGND VPWR VPWR net284 sky130_fd_sc_hd__dlygate4sd1_1
XFILLER_73_228 VGND VGND VPWR VPWR sky130_fd_sc_hd__decap_3
Xrebuffer52 _0299_ VGND VGND VPWR VPWR net306 sky130_fd_sc_hd__clkbuf_2
XFILLER_26_144 VGND VGND VPWR VPWR sky130_fd_sc_hd__decap_3
XFILLER_81_261 VGND VGND VPWR VPWR sky130_fd_sc_hd__fill_2
XFILLER_25_34 VGND VGND VPWR VPWR sky130_fd_sc_hd__decap_3
XTAP_TAPCELL_ROW_24_334 VGND VPWR sky130_fd_sc_hd__tapvpwrvgnd_1
XFILLER_41_169 VGND VGND VPWR VPWR sky130_fd_sc_hd__decap_3
XFILLER_49_225 VGND VGND VPWR VPWR sky130_fd_sc_hd__decap_3
XFILLER_49_258 VGND VGND VPWR VPWR sky130_fd_sc_hd__decap_3
XTAP_TAPCELL_ROW_90_738 VGND VPWR sky130_fd_sc_hd__tapvpwrvgnd_1
XFILLER_17_188 VGND VGND VPWR VPWR sky130_fd_sc_hd__decap_3
XFILLER_32_114 VGND VGND VPWR VPWR sky130_fd_sc_hd__decap_3
XFILLER_82_73 VGND VGND VPWR VPWR sky130_fd_sc_hd__decap_3
XFILLER_32_147 VGND VGND VPWR VPWR sky130_fd_sc_hd__decap_3
X_0950_ N2MID[3] E2MID[3] S2MID[3] W2MID[3] Inst_SimpleCLB_ConfigMem.Inst_frame6_bit4.Q
+ Inst_SimpleCLB_ConfigMem.Inst_frame6_bit5.Q VGND VGND VPWR VPWR _0050_ sky130_fd_sc_hd__mux4_2
X_0881_ net648 N2END[3] N4END[3] E1END[1] Inst_SimpleCLB_ConfigMem.Inst_frame4_bit2.Q
+ Inst_SimpleCLB_ConfigMem.Inst_frame4_bit3.Q VGND VGND VPWR VPWR _0708_ sky130_fd_sc_hd__mux4_1
XFILLER_70_6 VGND VGND VPWR VPWR sky130_fd_sc_hd__decap_3
Xoutput106 net106 VGND VGND VPWR VPWR N2BEG[0] sky130_fd_sc_hd__buf_4
Xoutput128 Inst_SimpleCLB_switch_matrix.N4BEG3 VGND VGND VPWR VPWR N4BEG[15] sky130_fd_sc_hd__buf_8
Xoutput139 net139 VGND VGND VPWR VPWR NN4BEG[10] sky130_fd_sc_hd__buf_2
Xoutput117 net117 VGND VGND VPWR VPWR N2BEGb[3] sky130_fd_sc_hd__buf_2
X_1502_ Inst_SimpleCLB_ConfigMem.Inst_frame0_bit26.Q _0633_ Inst_SimpleCLB_ConfigMem.Inst_frame0_bit27.Q
+ VGND VGND VPWR VPWR _0532_ sky130_fd_sc_hd__a21oi_1
XFILLER_49_3 VGND VGND VPWR VPWR sky130_fd_sc_hd__decap_3
X_1433_ _0565_ Inst_SimpleCLB_ConfigMem.Inst_frame13_bit30.Q Inst_SimpleCLB_ConfigMem.Inst_frame13_bit31.Q
+ _0492_ VGND VGND VPWR VPWR _0493_ sky130_fd_sc_hd__a211o_1
X_1364_ Inst_SimpleCLB_ConfigMem.Inst_frame11_bit13.Q _0427_ _0429_ _0432_ VGND VGND
+ VPWR VPWR Inst_SimpleCLB_switch_matrix.SS4BEG3 sky130_fd_sc_hd__o22a_1
X_1295_ _0371_ _0372_ Inst_SimpleCLB_ConfigMem.Inst_frame4_bit28.Q VGND VGND VPWR
+ VPWR _0373_ sky130_fd_sc_hd__mux2_1
XFILLER_55_228 VGND VGND VPWR VPWR sky130_fd_sc_hd__decap_3
XFILLER_23_169 VGND VGND VPWR VPWR sky130_fd_sc_hd__fill_1
XTAP_TAPCELL_ROW_21_315 VGND VPWR sky130_fd_sc_hd__tapvpwrvgnd_1
XFILLER_87_18 VGND VGND VPWR VPWR sky130_fd_sc_hd__fill_1
XFILLER_86_331 VGND VGND VPWR VPWR sky130_fd_sc_hd__fill_1
XFILLER_36_88 VGND VGND VPWR VPWR sky130_fd_sc_hd__decap_3
XFILLER_54_272 VGND VGND VPWR VPWR sky130_fd_sc_hd__decap_3
XFILLER_14_147 VGND VGND VPWR VPWR sky130_fd_sc_hd__decap_3
XFILLER_6_324 VGND VGND VPWR VPWR sky130_fd_sc_hd__decap_3
XFILLER_77_73 VGND VGND VPWR VPWR sky130_fd_sc_hd__decap_3
XFILLER_37_217 VGND VGND VPWR VPWR sky130_fd_sc_hd__decap_3
XFILLER_37_228 VGND VGND VPWR VPWR sky130_fd_sc_hd__decap_3
X_1080_ net259 _0168_ VGND VGND VPWR VPWR _0173_ sky130_fd_sc_hd__nand2_1
XTAP_TAPCELL_ROW_43_451 VGND VPWR sky130_fd_sc_hd__tapvpwrvgnd_1
XFILLER_60_253 VGND VGND VPWR VPWR sky130_fd_sc_hd__fill_1
X_1982_ net762 net671 VGND VGND VPWR VPWR Inst_SimpleCLB_ConfigMem.Inst_frame5_bit25.Q
+ sky130_fd_sc_hd__dlxtp_1
XFILLER_60_275 VGND VGND VPWR VPWR sky130_fd_sc_hd__decap_3
X_0933_ W6END[1] net637 net641 net617 Inst_SimpleCLB_ConfigMem.Inst_frame3_bit3.Q
+ Inst_SimpleCLB_ConfigMem.Inst_frame3_bit2.Q VGND VGND VPWR VPWR _0035_ sky130_fd_sc_hd__mux4_2
X_0864_ _0690_ _0691_ Inst_SimpleCLB_ConfigMem.Inst_frame10_bit17.Q VGND VGND VPWR
+ VPWR _0692_ sky130_fd_sc_hd__mux2_1
X_0795_ N2MID[6] S2MID[6] Inst_SimpleCLB_ConfigMem.Inst_frame8_bit26.Q VGND VGND VPWR
+ VPWR _0628_ sky130_fd_sc_hd__mux2_1
X_2396_ WW4END[6] VGND VGND VPWR VPWR net247 sky130_fd_sc_hd__clkbuf_2
X_1416_ net302 _0140_ Inst_SimpleCLB_ConfigMem.Inst_frame12_bit4.Q VGND VGND VPWR
+ VPWR _0478_ sky130_fd_sc_hd__mux2_1
X_1347_ _0416_ _0417_ Inst_SimpleCLB_ConfigMem.Inst_frame11_bit27.Q VGND VGND VPWR
+ VPWR Inst_SimpleCLB_switch_matrix.WW4BEG1 sky130_fd_sc_hd__mux2_4
XFILLER_28_239 VGND VGND VPWR VPWR sky130_fd_sc_hd__decap_3
X_1278_ net800 S4END[1] S2END[1] W2END[1] Inst_SimpleCLB_ConfigMem.Inst_frame3_bit27.Q
+ Inst_SimpleCLB_ConfigMem.Inst_frame3_bit26.Q VGND VGND VPWR VPWR _0358_ sky130_fd_sc_hd__mux4_1
XFILLER_36_250 VGND VGND VPWR VPWR sky130_fd_sc_hd__fill_2
XTAP_TAPCELL_ROW_66_587 VGND VPWR sky130_fd_sc_hd__tapvpwrvgnd_1
XFILLER_0_6 VGND VGND VPWR VPWR sky130_fd_sc_hd__decap_3
XFILLER_19_206 VGND VGND VPWR VPWR sky130_fd_sc_hd__decap_3
XFILLER_19_217 VGND VGND VPWR VPWR sky130_fd_sc_hd__decap_3
XFILLER_19_228 VGND VGND VPWR VPWR sky130_fd_sc_hd__decap_3
XTAP_TAPCELL_ROW_57_532 VGND VPWR sky130_fd_sc_hd__tapvpwrvgnd_1
XFILLER_27_261 VGND VGND VPWR VPWR sky130_fd_sc_hd__decap_3
XFILLER_63_42 VGND VGND VPWR VPWR sky130_fd_sc_hd__decap_3
XFILLER_42_231 VGND VGND VPWR VPWR sky130_fd_sc_hd__decap_3
XFILLER_42_253 VGND VGND VPWR VPWR sky130_fd_sc_hd__fill_2
XPHY_EDGE_ROW_69_Right_69 VGND VGND VPWR VPWR sky130_fd_sc_hd__decap_3
XFILLER_63_86 VGND VGND VPWR VPWR sky130_fd_sc_hd__decap_3
XTAP_TAPCELL_ROW_40_432 VGND VPWR sky130_fd_sc_hd__tapvpwrvgnd_1
XFILLER_10_150 VGND VGND VPWR VPWR sky130_fd_sc_hd__decap_3
XFILLER_10_172 VGND VGND VPWR VPWR sky130_fd_sc_hd__decap_3
XFILLER_6_165 VGND VGND VPWR VPWR sky130_fd_sc_hd__decap_3
XPHY_EDGE_ROW_78_Right_78 VGND VGND VPWR VPWR sky130_fd_sc_hd__decap_3
XFILLER_88_50 VGND VGND VPWR VPWR sky130_fd_sc_hd__fill_2
XFILLER_69_106 VGND VGND VPWR VPWR sky130_fd_sc_hd__decap_3
X_2250_ net714 VGND VGND VPWR VPWR net86 sky130_fd_sc_hd__clkbuf_2
XFILLER_69_128 VGND VGND VPWR VPWR sky130_fd_sc_hd__decap_3
XFILLER_84_109 VGND VGND VPWR VPWR sky130_fd_sc_hd__decap_3
X_1201_ _0172_ _0259_ _0218_ _0258_ Inst_LH_LUT4c_frame_config_dffesr.c_I0mux VGND
+ VGND VPWR VPWR _0286_ sky130_fd_sc_hd__o311a_4
X_2181_ E6END[6] VGND VGND VPWR VPWR net28 sky130_fd_sc_hd__buf_1
X_1132_ net648 N2END[7] net802 E2END[7] Inst_SimpleCLB_ConfigMem.Inst_frame4_bit18.Q
+ Inst_SimpleCLB_ConfigMem.Inst_frame4_bit19.Q VGND VGND VPWR VPWR _0222_ sky130_fd_sc_hd__mux4_1
XFILLER_77_194 VGND VGND VPWR VPWR sky130_fd_sc_hd__decap_3
XFILLER_18_250 VGND VGND VPWR VPWR sky130_fd_sc_hd__fill_2
X_1063_ _0141_ _0153_ VGND VGND VPWR VPWR _0156_ sky130_fd_sc_hd__nand2_2
XPHY_EDGE_ROW_87_Right_87 VGND VGND VPWR VPWR sky130_fd_sc_hd__decap_3
XFILLER_33_231 VGND VGND VPWR VPWR sky130_fd_sc_hd__decap_3
XTAP_TAPCELL_ROW_63_568 VGND VPWR sky130_fd_sc_hd__tapvpwrvgnd_1
XFILLER_33_264 VGND VGND VPWR VPWR sky130_fd_sc_hd__decap_3
X_1965_ net735 net672 VGND VGND VPWR VPWR Inst_SimpleCLB_ConfigMem.Inst_frame5_bit8.Q
+ sky130_fd_sc_hd__dlxtp_1
X_0916_ E6END[1] S2END[3] S4END[3] W2END[3] Inst_SimpleCLB_ConfigMem.Inst_frame2_bit2.Q
+ Inst_SimpleCLB_ConfigMem.Inst_frame2_bit3.Q VGND VGND VPWR VPWR _0020_ sky130_fd_sc_hd__mux4_1
X_1896_ net746 net666 VGND VGND VPWR VPWR Inst_SimpleCLB_ConfigMem.Inst_frame7_bit3.Q
+ sky130_fd_sc_hd__dlxtp_1
X_0847_ net653 net650 N2END[2] E2END[2] Inst_SimpleCLB_ConfigMem.Inst_frame2_bit30.Q
+ Inst_SimpleCLB_ConfigMem.Inst_frame2_bit31.Q VGND VGND VPWR VPWR _0677_ sky130_fd_sc_hd__mux4_1
X_0778_ _0569_ _0610_ Inst_SimpleCLB_ConfigMem.Inst_frame3_bit1.Q VGND VGND VPWR VPWR
+ _0613_ sky130_fd_sc_hd__o21a_1
X_2379_ W2MID[5] VGND VGND VPWR VPWR net224 sky130_fd_sc_hd__clkbuf_2
XFILLER_83_164 VGND VGND VPWR VPWR sky130_fd_sc_hd__decap_3
XFILLER_16_209 VGND VGND VPWR VPWR sky130_fd_sc_hd__decap_3
XFILLER_71_304 VGND VGND VPWR VPWR sky130_fd_sc_hd__decap_3
XFILLER_83_186 VGND VGND VPWR VPWR sky130_fd_sc_hd__decap_3
XFILLER_17_57 VGND VGND VPWR VPWR sky130_fd_sc_hd__decap_3
XTAP_TAPCELL_ROW_54_513 VGND VPWR sky130_fd_sc_hd__tapvpwrvgnd_1
XFILLER_24_297 VGND VGND VPWR VPWR sky130_fd_sc_hd__decap_3
XFILLER_3_113 VGND VGND VPWR VPWR sky130_fd_sc_hd__fill_1
XFILLER_47_323 VGND VGND VPWR VPWR sky130_fd_sc_hd__fill_1
XFILLER_74_175 VGND VGND VPWR VPWR sky130_fd_sc_hd__fill_1
XFILLER_74_197 VGND VGND VPWR VPWR sky130_fd_sc_hd__fill_1
XFILLER_90_73 VGND VGND VPWR VPWR sky130_fd_sc_hd__decap_3
XTAP_TAPCELL_ROW_60_549 VGND VPWR sky130_fd_sc_hd__tapvpwrvgnd_1
XFILLER_30_256 VGND VGND VPWR VPWR sky130_fd_sc_hd__fill_2
XFILLER_30_289 VGND VGND VPWR VPWR sky130_fd_sc_hd__decap_3
X_1750_ net782 net719 VGND VGND VPWR VPWR Inst_SimpleCLB_ConfigMem.Inst_frame12_bit17.Q
+ sky130_fd_sc_hd__dlxtp_1
X_1681_ net792 net708 VGND VGND VPWR VPWR Inst_LH_LUT4c_frame_config_dffesr.inst_cus_mux161_buf.A5
+ sky130_fd_sc_hd__dlxtp_1
X_2302_ NN4END[13] VGND VGND VPWR VPWR net153 sky130_fd_sc_hd__buf_1
X_2233_ net757 VGND VGND VPWR VPWR net70 sky130_fd_sc_hd__clkbuf_1
X_2164_ Inst_SimpleCLB_switch_matrix.E2BEG3 VGND VGND VPWR VPWR net9 sky130_fd_sc_hd__buf_1
X_1115_ _0176_ _0175_ Inst_SimpleCLB_ConfigMem.Inst_frame9_bit24.Q VGND VGND VPWR
+ VPWR _0206_ sky130_fd_sc_hd__mux2_1
XFILLER_65_164 VGND VGND VPWR VPWR sky130_fd_sc_hd__decap_3
XFILLER_65_175 VGND VGND VPWR VPWR sky130_fd_sc_hd__decap_3
X_2095_ net796 net689 VGND VGND VPWR VPWR Inst_SimpleCLB_ConfigMem.Inst_frame1_bit10.Q
+ sky130_fd_sc_hd__dlxtp_1
XFILLER_80_134 VGND VGND VPWR VPWR sky130_fd_sc_hd__decap_3
XFILLER_0_82 VGND VGND VPWR VPWR sky130_fd_sc_hd__fill_2
X_1046_ N2MID[3] E2MID[3] S2MID[3] W2MID[3] Inst_SimpleCLB_ConfigMem.Inst_frame6_bit12.Q
+ Inst_SimpleCLB_ConfigMem.Inst_frame6_bit13.Q VGND VGND VPWR VPWR _0140_ sky130_fd_sc_hd__mux4_2
XFILLER_21_256 VGND VGND VPWR VPWR sky130_fd_sc_hd__fill_2
XFILLER_21_267 VGND VGND VPWR VPWR sky130_fd_sc_hd__decap_3
X_1948_ net766 net669 VGND VGND VPWR VPWR Inst_SimpleCLB_ConfigMem.Inst_frame6_bit23.Q
+ sky130_fd_sc_hd__dlxtp_1
X_1879_ net780 net660 VGND VGND VPWR VPWR Inst_SimpleCLB_ConfigMem.Inst_frame8_bit18.Q
+ sky130_fd_sc_hd__dlxtp_1
XTAP_TAPCELL_ROW_8_238 VGND VPWR sky130_fd_sc_hd__tapvpwrvgnd_1
XFILLER_56_120 VGND VGND VPWR VPWR sky130_fd_sc_hd__decap_3
XFILLER_56_153 VGND VGND VPWR VPWR sky130_fd_sc_hd__fill_1
XFILLER_56_175 VGND VGND VPWR VPWR sky130_fd_sc_hd__fill_1
XFILLER_56_197 VGND VGND VPWR VPWR sky130_fd_sc_hd__fill_2
XTAP_TAPCELL_ROW_82_685 VGND VPWR sky130_fd_sc_hd__tapvpwrvgnd_1
XFILLER_12_212 VGND VGND VPWR VPWR sky130_fd_sc_hd__decap_3
XFILLER_44_77 VGND VGND VPWR VPWR sky130_fd_sc_hd__decap_3
XFILLER_71_178 VGND VGND VPWR VPWR sky130_fd_sc_hd__fill_1
XFILLER_44_88 VGND VGND VPWR VPWR sky130_fd_sc_hd__decap_3
XFILLER_12_256 VGND VGND VPWR VPWR sky130_fd_sc_hd__decap_3
XFILLER_60_21 VGND VGND VPWR VPWR sky130_fd_sc_hd__decap_3
XFILLER_79_223 VGND VGND VPWR VPWR sky130_fd_sc_hd__fill_1
XFILLER_79_245 VGND VGND VPWR VPWR sky130_fd_sc_hd__decap_3
XFILLER_39_109 VGND VGND VPWR VPWR sky130_fd_sc_hd__decap_3
XFILLER_47_197 VGND VGND VPWR VPWR sky130_fd_sc_hd__fill_1
XFILLER_62_101 VGND VGND VPWR VPWR sky130_fd_sc_hd__decap_3
XFILLER_62_156 VGND VGND VPWR VPWR sky130_fd_sc_hd__fill_1
XTAP_TAPCELL_ROW_73_630 VGND VPWR sky130_fd_sc_hd__tapvpwrvgnd_1
XPHY_EDGE_ROW_28_Left_119 VGND VGND VPWR VPWR sky130_fd_sc_hd__decap_3
X_1802_ net742 net728 VGND VGND VPWR VPWR Inst_SimpleCLB_ConfigMem.Inst_frame10_bit5.Q
+ sky130_fd_sc_hd__dlxtp_1
XFILLER_79_3 VGND VGND VPWR VPWR sky130_fd_sc_hd__fill_1
X_1733_ net799 net719 VGND VGND VPWR VPWR Inst_SimpleCLB_ConfigMem.Inst_frame12_bit0.Q
+ sky130_fd_sc_hd__dlxtp_1
X_1664_ net759 net705 VGND VGND VPWR VPWR Inst_LG_LUT4c_frame_config_dffesr.inst_cus_mux161_buf.A7
+ sky130_fd_sc_hd__dlxtp_1
X_1595_ net769 net694 VGND VGND VPWR VPWR Inst_LC_LUT4c_frame_config_dffesr.inst_cus_mux161_buf.A14
+ sky130_fd_sc_hd__dlxtp_1
Xfanout707 net708 VGND VGND VPWR VPWR net707 sky130_fd_sc_hd__clkbuf_2
XTAP_TAPCELL_ROW_5_219 VGND VPWR sky130_fd_sc_hd__tapvpwrvgnd_1
Xfanout729 net730 VGND VGND VPWR VPWR net729 sky130_fd_sc_hd__buf_2
Xfanout718 FrameStrobe[12] VGND VGND VPWR VPWR net718 sky130_fd_sc_hd__clkbuf_2
XFILLER_85_215 VGND VGND VPWR VPWR sky130_fd_sc_hd__decap_3
XPHY_EDGE_ROW_37_Left_128 VGND VGND VPWR VPWR sky130_fd_sc_hd__decap_3
X_2216_ FrameData[11] VGND VGND VPWR VPWR net52 sky130_fd_sc_hd__buf_1
XFILLER_38_131 VGND VGND VPWR VPWR sky130_fd_sc_hd__decap_3
X_2147_ net749 net730 VGND VGND VPWR VPWR Inst_SimpleCLB_ConfigMem.Inst_frame0_bit30.Q
+ sky130_fd_sc_hd__dlxtp_1
XFILLER_38_197 VGND VGND VPWR VPWR sky130_fd_sc_hd__decap_3
X_2078_ net762 net683 VGND VGND VPWR VPWR Inst_SimpleCLB_ConfigMem.Inst_frame2_bit25.Q
+ sky130_fd_sc_hd__dlxtp_1
XFILLER_53_134 VGND VGND VPWR VPWR sky130_fd_sc_hd__decap_3
X_1029_ _0119_ _0121_ _0124_ Inst_SimpleCLB_ConfigMem.Inst_frame4_bit17.Q VGND VGND
+ VPWR VPWR Inst_SimpleCLB_switch_matrix.JN2BEG5 sky130_fd_sc_hd__o2bb2a_4
XPHY_EDGE_ROW_46_Left_137 VGND VGND VPWR VPWR sky130_fd_sc_hd__decap_3
XFILLER_5_208 VGND VGND VPWR VPWR sky130_fd_sc_hd__decap_3
XFILLER_30_79 VGND VGND VPWR VPWR sky130_fd_sc_hd__decap_3
XPHY_EDGE_ROW_55_Left_146 VGND VGND VPWR VPWR sky130_fd_sc_hd__decap_3
XTAP_TAPCELL_ROW_87_711 VGND VPWR sky130_fd_sc_hd__tapvpwrvgnd_1
XFILLER_39_55 VGND VGND VPWR VPWR sky130_fd_sc_hd__fill_1
XFILLER_39_99 VGND VGND VPWR VPWR sky130_fd_sc_hd__decap_3
XFILLER_76_259 VGND VGND VPWR VPWR sky130_fd_sc_hd__decap_3
XFILLER_29_142 VGND VGND VPWR VPWR sky130_fd_sc_hd__fill_2
XFILLER_17_337 VGND VGND VPWR VPWR sky130_fd_sc_hd__decap_3
XFILLER_29_175 VGND VGND VPWR VPWR sky130_fd_sc_hd__decap_3
XFILLER_44_134 VGND VGND VPWR VPWR sky130_fd_sc_hd__decap_3
XTAP_TAPCELL_ROW_27_354 VGND VPWR sky130_fd_sc_hd__tapvpwrvgnd_1
XFILLER_32_307 VGND VGND VPWR VPWR sky130_fd_sc_hd__fill_1
XFILLER_32_318 VGND VGND VPWR VPWR sky130_fd_sc_hd__fill_1
XFILLER_44_178 VGND VGND VPWR VPWR sky130_fd_sc_hd__decap_3
XPHY_EDGE_ROW_64_Left_155 VGND VGND VPWR VPWR sky130_fd_sc_hd__decap_3
XTAP_TAPCELL_ROW_70_611 VGND VPWR sky130_fd_sc_hd__tapvpwrvgnd_1
XPHY_EDGE_ROW_73_Left_164 VGND VGND VPWR VPWR sky130_fd_sc_hd__decap_3
X_1380_ net650 net647 E1END[2] net304 Inst_SimpleCLB_ConfigMem.Inst_frame11_bit3.Q
+ Inst_SimpleCLB_ConfigMem.Inst_frame11_bit2.Q VGND VGND VPWR VPWR _0446_ sky130_fd_sc_hd__mux4_1
XFILLER_67_215 VGND VGND VPWR VPWR sky130_fd_sc_hd__decap_3
X_2001_ net792 net676 VGND VGND VPWR VPWR Inst_SimpleCLB_ConfigMem.Inst_frame4_bit12.Q
+ sky130_fd_sc_hd__dlxtp_1
XFILLER_90_240 VGND VGND VPWR VPWR sky130_fd_sc_hd__decap_3
XPHY_EDGE_ROW_82_Left_173 VGND VGND VPWR VPWR sky130_fd_sc_hd__decap_3
XFILLER_90_262 VGND VGND VPWR VPWR sky130_fd_sc_hd__fill_2
XFILLER_35_167 VGND VGND VPWR VPWR sky130_fd_sc_hd__fill_1
XFILLER_35_178 VGND VGND VPWR VPWR sky130_fd_sc_hd__decap_3
XFILLER_50_115 VGND VGND VPWR VPWR sky130_fd_sc_hd__decap_3
X_1716_ net786 net712 VGND VGND VPWR VPWR Inst_SimpleCLB_ConfigMem.Inst_frame13_bit15.Q
+ sky130_fd_sc_hd__dlxtp_1
XFILLER_6_81 VGND VGND VPWR VPWR sky130_fd_sc_hd__decap_3
X_1647_ net797 net704 VGND VGND VPWR VPWR Inst_LF_LUT4c_frame_config_dffesr.inst_cus_mux161_buf.A9
+ sky130_fd_sc_hd__dlxtp_1
X_1578_ net741 net697 VGND VGND VPWR VPWR Inst_LB_LUT4c_frame_config_dffesr.c_out_mux
+ sky130_fd_sc_hd__dlxtp_1
XFILLER_58_226 VGND VGND VPWR VPWR sky130_fd_sc_hd__decap_3
XFILLER_58_259 VGND VGND VPWR VPWR sky130_fd_sc_hd__fill_2
Xrebuffer64 _0313_ VGND VGND VPWR VPWR net318 sky130_fd_sc_hd__dlygate4sd1_1
XFILLER_26_134 VGND VGND VPWR VPWR sky130_fd_sc_hd__decap_3
Xrebuffer53 _0272_ VGND VGND VPWR VPWR net307 sky130_fd_sc_hd__dlygate4sd1_1
Xrebuffer42 net299 VGND VGND VPWR VPWR net296 sky130_fd_sc_hd__clkbuf_2
Xrebuffer31 _0218_ VGND VGND VPWR VPWR net285 sky130_fd_sc_hd__clkbuf_2
XFILLER_14_307 VGND VGND VPWR VPWR sky130_fd_sc_hd__fill_1
XFILLER_26_156 VGND VGND VPWR VPWR sky130_fd_sc_hd__decap_3
XTAP_TAPCELL_ROW_24_335 VGND VPWR sky130_fd_sc_hd__tapvpwrvgnd_1
XFILLER_25_57 VGND VGND VPWR VPWR sky130_fd_sc_hd__decap_3
XFILLER_41_78 VGND VGND VPWR VPWR sky130_fd_sc_hd__decap_3
XFILLER_1_222 VGND VGND VPWR VPWR sky130_fd_sc_hd__fill_2
XFILLER_1_277 VGND VGND VPWR VPWR sky130_fd_sc_hd__decap_3
XFILLER_49_204 VGND VGND VPWR VPWR sky130_fd_sc_hd__decap_3
XFILLER_49_237 VGND VGND VPWR VPWR sky130_fd_sc_hd__decap_3
XFILLER_66_20 VGND VGND VPWR VPWR sky130_fd_sc_hd__decap_3
XFILLER_57_270 VGND VGND VPWR VPWR sky130_fd_sc_hd__decap_3
XFILLER_57_281 VGND VGND VPWR VPWR sky130_fd_sc_hd__decap_3
XFILLER_66_97 VGND VGND VPWR VPWR sky130_fd_sc_hd__fill_1
XFILLER_72_240 VGND VGND VPWR VPWR sky130_fd_sc_hd__decap_3
XTAP_TAPCELL_ROW_90_739 VGND VPWR sky130_fd_sc_hd__tapvpwrvgnd_1
XTAP_TAPCELL_ROW_90_728 VGND VPWR sky130_fd_sc_hd__tapvpwrvgnd_1
XFILLER_32_159 VGND VGND VPWR VPWR sky130_fd_sc_hd__decap_3
XFILLER_40_170 VGND VGND VPWR VPWR sky130_fd_sc_hd__decap_3
XFILLER_40_192 VGND VGND VPWR VPWR sky130_fd_sc_hd__decap_3
X_0880_ _0705_ _0706_ Inst_SimpleCLB_ConfigMem.Inst_frame4_bit4.Q VGND VGND VPWR VPWR
+ _0707_ sky130_fd_sc_hd__mux2_4
Xoutput107 net107 VGND VGND VPWR VPWR N2BEG[1] sky130_fd_sc_hd__buf_4
Xoutput129 net129 VGND VGND VPWR VPWR N4BEG[1] sky130_fd_sc_hd__buf_2
Xoutput118 net118 VGND VGND VPWR VPWR N2BEGb[4] sky130_fd_sc_hd__buf_2
X_1501_ Inst_SimpleCLB_ConfigMem.Inst_frame0_bit26.Q _0225_ VGND VGND VPWR VPWR _0531_
+ sky130_fd_sc_hd__or2_1
X_1432_ net650 Inst_SimpleCLB_ConfigMem.Inst_frame13_bit30.Q VGND VGND VPWR VPWR _0492_
+ sky130_fd_sc_hd__nor2_1
X_1363_ Inst_SimpleCLB_ConfigMem.Inst_frame11_bit12.Q _0431_ Inst_SimpleCLB_ConfigMem.Inst_frame11_bit13.Q
+ VGND VGND VPWR VPWR _0432_ sky130_fd_sc_hd__o21ai_1
X_1294_ EE4END[1] S2END[1] net800 W2END[1] Inst_SimpleCLB_ConfigMem.Inst_frame4_bit27.Q
+ Inst_SimpleCLB_ConfigMem.Inst_frame4_bit26.Q VGND VGND VPWR VPWR _0372_ sky130_fd_sc_hd__mux4_1
XTAP_TAPCELL_ROW_38_416 VGND VPWR sky130_fd_sc_hd__tapvpwrvgnd_1
XTAP_TAPCELL_ROW_21_316 VGND VPWR sky130_fd_sc_hd__tapvpwrvgnd_1
XFILLER_31_181 VGND VGND VPWR VPWR sky130_fd_sc_hd__decap_3
XFILLER_36_78 VGND VGND VPWR VPWR sky130_fd_sc_hd__decap_3
XFILLER_54_251 VGND VGND VPWR VPWR sky130_fd_sc_hd__fill_1
XFILLER_14_137 VGND VGND VPWR VPWR sky130_fd_sc_hd__decap_3
XFILLER_54_284 VGND VGND VPWR VPWR sky130_fd_sc_hd__decap_3
XFILLER_52_88 VGND VGND VPWR VPWR sky130_fd_sc_hd__fill_1
XFILLER_6_336 VGND VGND VPWR VPWR sky130_fd_sc_hd__decap_3
XFILLER_89_181 VGND VGND VPWR VPWR sky130_fd_sc_hd__decap_3
XFILLER_77_85 VGND VGND VPWR VPWR sky130_fd_sc_hd__decap_3
XFILLER_45_240 VGND VGND VPWR VPWR sky130_fd_sc_hd__fill_1
X_1981_ net764 net671 VGND VGND VPWR VPWR Inst_SimpleCLB_ConfigMem.Inst_frame5_bit24.Q
+ sky130_fd_sc_hd__dlxtp_1
XFILLER_13_192 VGND VGND VPWR VPWR sky130_fd_sc_hd__fill_2
X_0932_ net623 net312 net635 net609 Inst_SimpleCLB_ConfigMem.Inst_frame3_bit3.Q Inst_SimpleCLB_ConfigMem.Inst_frame3_bit2.Q
+ VGND VGND VPWR VPWR _0034_ sky130_fd_sc_hd__mux4_2
X_0863_ _0680_ _0679_ Inst_SimpleCLB_ConfigMem.Inst_frame10_bit16.Q VGND VGND VPWR
+ VPWR _0691_ sky130_fd_sc_hd__mux2_1
XFILLER_61_3 VGND VGND VPWR VPWR sky130_fd_sc_hd__decap_3
X_0794_ _0621_ _0623_ _0625_ _0627_ VGND VGND VPWR VPWR Inst_SimpleCLB_switch_matrix.JN2BEG3
+ sky130_fd_sc_hd__o2bb2a_4
X_2395_ WW4END[5] VGND VGND VPWR VPWR net246 sky130_fd_sc_hd__clkbuf_2
X_1415_ Inst_SimpleCLB_ConfigMem.Inst_frame12_bit5.Q _0476_ VGND VGND VPWR VPWR _0477_
+ sky130_fd_sc_hd__nand2_1
XFILLER_68_321 VGND VGND VPWR VPWR sky130_fd_sc_hd__decap_3
X_1346_ net363 _0667_ net296 _0143_ Inst_SimpleCLB_ConfigMem.Inst_frame11_bit25.Q
+ Inst_SimpleCLB_ConfigMem.Inst_frame11_bit26.Q VGND VGND VPWR VPWR _0417_ sky130_fd_sc_hd__mux4_2
XFILLER_83_346 VGND VGND VPWR VPWR sky130_fd_sc_hd__fill_1
X_1277_ net652 NN4END[1] net802 E2END[1] Inst_SimpleCLB_ConfigMem.Inst_frame3_bit26.Q
+ Inst_SimpleCLB_ConfigMem.Inst_frame3_bit27.Q VGND VGND VPWR VPWR _0357_ sky130_fd_sc_hd__mux4_1
XTAP_TAPCELL_ROW_66_588 VGND VPWR sky130_fd_sc_hd__tapvpwrvgnd_1
XFILLER_36_295 VGND VGND VPWR VPWR sky130_fd_sc_hd__fill_1
XFILLER_51_265 VGND VGND VPWR VPWR sky130_fd_sc_hd__decap_3
XFILLER_78_107 VGND VGND VPWR VPWR sky130_fd_sc_hd__decap_3
XFILLER_47_44 VGND VGND VPWR VPWR sky130_fd_sc_hd__decap_3
XFILLER_47_55 VGND VGND VPWR VPWR sky130_fd_sc_hd__fill_1
XFILLER_86_195 VGND VGND VPWR VPWR sky130_fd_sc_hd__fill_1
XTAP_TAPCELL_ROW_57_533 VGND VPWR sky130_fd_sc_hd__tapvpwrvgnd_1
XFILLER_27_284 VGND VGND VPWR VPWR sky130_fd_sc_hd__decap_3
XFILLER_63_54 VGND VGND VPWR VPWR sky130_fd_sc_hd__fill_2
XFILLER_42_276 VGND VGND VPWR VPWR sky130_fd_sc_hd__decap_3
XTAP_TAPCELL_ROW_40_433 VGND VPWR sky130_fd_sc_hd__tapvpwrvgnd_1
XFILLER_10_184 VGND VGND VPWR VPWR sky130_fd_sc_hd__decap_3
XFILLER_6_144 VGND VGND VPWR VPWR sky130_fd_sc_hd__decap_3
XFILLER_6_177 VGND VGND VPWR VPWR sky130_fd_sc_hd__decap_3
XFILLER_12_91 VGND VGND VPWR VPWR sky130_fd_sc_hd__decap_3
X_2180_ E6END[5] VGND VGND VPWR VPWR net27 sky130_fd_sc_hd__buf_1
X_1200_ _0285_ Inst_LG_LUT4c_frame_config_dffesr.LUT_flop Inst_LG_LUT4c_frame_config_dffesr.c_out_mux
+ VGND VGND VPWR VPWR Inst_LG_LUT4c_frame_config_dffesr.O sky130_fd_sc_hd__mux2_4
X_1131_ _0220_ _0219_ Inst_SimpleCLB_ConfigMem.Inst_frame4_bit20.Q VGND VGND VPWR
+ VPWR _0221_ sky130_fd_sc_hd__mux2_1
X_1062_ _0153_ _0141_ VGND VGND VPWR VPWR _0155_ sky130_fd_sc_hd__or2_4
XFILLER_33_243 VGND VGND VPWR VPWR sky130_fd_sc_hd__decap_3
XTAP_TAPCELL_ROW_63_569 VGND VPWR sky130_fd_sc_hd__tapvpwrvgnd_1
XFILLER_33_276 VGND VGND VPWR VPWR sky130_fd_sc_hd__decap_3
X_1964_ net737 net671 VGND VGND VPWR VPWR Inst_SimpleCLB_ConfigMem.Inst_frame5_bit7.Q
+ sky130_fd_sc_hd__dlxtp_1
X_0915_ net649 E1END[1] NN4END[3] E2END[3] Inst_SimpleCLB_ConfigMem.Inst_frame2_bit3.Q
+ Inst_SimpleCLB_ConfigMem.Inst_frame2_bit2.Q VGND VGND VPWR VPWR _0019_ sky130_fd_sc_hd__mux4_1
X_1895_ net752 net666 VGND VGND VPWR VPWR Inst_SimpleCLB_ConfigMem.Inst_frame7_bit2.Q
+ sky130_fd_sc_hd__dlxtp_1
X_0846_ net801 S2END[2] S4END[2] W2END[2] Inst_SimpleCLB_ConfigMem.Inst_frame2_bit30.Q
+ Inst_SimpleCLB_ConfigMem.Inst_frame2_bit31.Q VGND VGND VPWR VPWR _0676_ sky130_fd_sc_hd__mux4_1
X_0777_ Inst_SimpleCLB_ConfigMem.Inst_frame3_bit0.Q _0611_ VGND VGND VPWR VPWR _0612_
+ sky130_fd_sc_hd__or2_1
XFILLER_0_309 VGND VGND VPWR VPWR sky130_fd_sc_hd__decap_3
X_2378_ W2MID[4] VGND VGND VPWR VPWR net223 sky130_fd_sc_hd__buf_1
XFILLER_83_110 VGND VGND VPWR VPWR sky130_fd_sc_hd__fill_2
XFILLER_56_346 VGND VGND VPWR VPWR sky130_fd_sc_hd__fill_1
XFILLER_68_195 VGND VGND VPWR VPWR sky130_fd_sc_hd__fill_1
X_1329_ _0402_ VGND VGND VPWR VPWR _0403_ sky130_fd_sc_hd__inv_1
Xclone5 net261 _0152_ _0143_ _0142_ Inst_SimpleCLB_ConfigMem.Inst_frame8_bit0.Q Inst_SimpleCLB_ConfigMem.Inst_frame8_bit1.Q
+ VGND VGND VPWR VPWR net259 sky130_fd_sc_hd__mux4_1
XTAP_TAPCELL_ROW_54_514 VGND VPWR sky130_fd_sc_hd__tapvpwrvgnd_1
XFILLER_24_265 VGND VGND VPWR VPWR sky130_fd_sc_hd__decap_3
XFILLER_33_57 VGND VGND VPWR VPWR sky130_fd_sc_hd__decap_3
XFILLER_58_10 VGND VGND VPWR VPWR sky130_fd_sc_hd__decap_3
XFILLER_59_184 VGND VGND VPWR VPWR sky130_fd_sc_hd__decap_3
XFILLER_74_121 VGND VGND VPWR VPWR sky130_fd_sc_hd__decap_3
XFILLER_15_243 VGND VGND VPWR VPWR sky130_fd_sc_hd__decap_3
XFILLER_15_221 VGND VGND VPWR VPWR sky130_fd_sc_hd__decap_3
XFILLER_15_265 VGND VGND VPWR VPWR sky130_fd_sc_hd__fill_1
XFILLER_90_85 VGND VGND VPWR VPWR sky130_fd_sc_hd__decap_3
XFILLER_23_90 VGND VGND VPWR VPWR sky130_fd_sc_hd__decap_3
X_1680_ net795 net708 VGND VGND VPWR VPWR Inst_LH_LUT4c_frame_config_dffesr.inst_cus_mux161_buf.A4
+ sky130_fd_sc_hd__dlxtp_1
X_2301_ NN4END[12] VGND VGND VPWR VPWR net152 sky130_fd_sc_hd__buf_1
XFILLER_2_180 VGND VGND VPWR VPWR sky130_fd_sc_hd__decap_3
X_2232_ net759 VGND VGND VPWR VPWR net69 sky130_fd_sc_hd__buf_1
X_2163_ Inst_SimpleCLB_switch_matrix.E2BEG2 VGND VGND VPWR VPWR net8 sky130_fd_sc_hd__clkbuf_2
XFILLER_53_305 VGND VGND VPWR VPWR sky130_fd_sc_hd__decap_3
X_1114_ Inst_LE_LUT4c_frame_config_dffesr.inst_cus_mux161_buf.A11 _0202_ _0203_ Inst_LE_LUT4c_frame_config_dffesr.inst_cus_mux161_buf.A13
+ _0204_ VGND VGND VPWR VPWR _0205_ sky130_fd_sc_hd__o221a_1
XFILLER_65_143 VGND VGND VPWR VPWR sky130_fd_sc_hd__decap_3
X_2094_ net733 net687 VGND VGND VPWR VPWR Inst_SimpleCLB_ConfigMem.Inst_frame1_bit9.Q
+ sky130_fd_sc_hd__dlxtp_1
XFILLER_0_50 VGND VGND VPWR VPWR sky130_fd_sc_hd__decap_3
XFILLER_65_187 VGND VGND VPWR VPWR sky130_fd_sc_hd__decap_3
XFILLER_0_94 VGND VGND VPWR VPWR sky130_fd_sc_hd__fill_1
X_1045_ N2MID[2] S2MID[2] E2MID[2] Inst_SimpleCLB_switch_matrix.E2BEG5 Inst_SimpleCLB_ConfigMem.Inst_frame7_bit13.Q
+ Inst_SimpleCLB_ConfigMem.Inst_frame7_bit12.Q VGND VGND VPWR VPWR _0139_ sky130_fd_sc_hd__mux4_2
XFILLER_21_213 VGND VGND VPWR VPWR sky130_fd_sc_hd__decap_3
X_1947_ net768 net669 VGND VGND VPWR VPWR Inst_SimpleCLB_ConfigMem.Inst_frame6_bit22.Q
+ sky130_fd_sc_hd__dlxtp_1
X_1878_ net782 net661 VGND VGND VPWR VPWR Inst_SimpleCLB_ConfigMem.Inst_frame8_bit17.Q
+ sky130_fd_sc_hd__dlxtp_1
X_0829_ WW4END[2] net636 net305 net626 Inst_SimpleCLB_ConfigMem.Inst_frame2_bit7.Q
+ Inst_SimpleCLB_ConfigMem.Inst_frame2_bit6.Q VGND VGND VPWR VPWR _0660_ sky130_fd_sc_hd__mux4_2
XFILLER_88_213 VGND VGND VPWR VPWR sky130_fd_sc_hd__fill_1
XTAP_TAPCELL_ROW_8_239 VGND VPWR sky130_fd_sc_hd__tapvpwrvgnd_1
XFILLER_88_246 VGND VGND VPWR VPWR sky130_fd_sc_hd__decap_3
XFILLER_0_128 VGND VGND VPWR VPWR sky130_fd_sc_hd__decap_3
XFILLER_29_302 VGND VGND VPWR VPWR sky130_fd_sc_hd__fill_1
XFILLER_29_335 VGND VGND VPWR VPWR sky130_fd_sc_hd__fill_1
XFILLER_29_346 VGND VGND VPWR VPWR sky130_fd_sc_hd__fill_1
XFILLER_28_79 VGND VGND VPWR VPWR sky130_fd_sc_hd__decap_3
XFILLER_71_157 VGND VGND VPWR VPWR sky130_fd_sc_hd__fill_2
XFILLER_12_279 VGND VGND VPWR VPWR sky130_fd_sc_hd__decap_3
XFILLER_8_206 VGND VGND VPWR VPWR sky130_fd_sc_hd__decap_3
XFILLER_8_239 VGND VGND VPWR VPWR sky130_fd_sc_hd__fill_1
XFILLER_60_88 VGND VGND VPWR VPWR sky130_fd_sc_hd__decap_3
XFILLER_69_42 VGND VGND VPWR VPWR sky130_fd_sc_hd__fill_2
XFILLER_69_97 VGND VGND VPWR VPWR sky130_fd_sc_hd__decap_3
XFILLER_35_327 VGND VGND VPWR VPWR sky130_fd_sc_hd__decap_3
XFILLER_47_165 VGND VGND VPWR VPWR sky130_fd_sc_hd__decap_3
XFILLER_62_124 VGND VGND VPWR VPWR sky130_fd_sc_hd__decap_3
XTAP_TAPCELL_ROW_73_631 VGND VPWR sky130_fd_sc_hd__tapvpwrvgnd_1
X_1801_ net744 net728 VGND VGND VPWR VPWR Inst_SimpleCLB_ConfigMem.Inst_frame10_bit4.Q
+ sky130_fd_sc_hd__dlxtp_1
XFILLER_11_290 VGND VGND VPWR VPWR sky130_fd_sc_hd__decap_3
X_1732_ net748 net714 VGND VGND VPWR VPWR Inst_SimpleCLB_ConfigMem.Inst_frame13_bit31.Q
+ sky130_fd_sc_hd__dlxtp_1
X_1663_ net761 net705 VGND VGND VPWR VPWR Inst_LG_LUT4c_frame_config_dffesr.inst_cus_mux161_buf.A6
+ sky130_fd_sc_hd__dlxtp_1
X_1594_ net772 net694 VGND VGND VPWR VPWR Inst_LC_LUT4c_frame_config_dffesr.inst_cus_mux161_buf.A13
+ sky130_fd_sc_hd__dlxtp_1
Xfanout708 net709 VGND VGND VPWR VPWR net708 sky130_fd_sc_hd__clkbuf_2
Xfanout719 FrameStrobe[12] VGND VGND VPWR VPWR net719 sky130_fd_sc_hd__clkbuf_2
XPHY_EDGE_ROW_7_Right_7 VGND VGND VPWR VPWR sky130_fd_sc_hd__decap_3
X_2215_ FrameData[10] VGND VGND VPWR VPWR net51 sky130_fd_sc_hd__buf_1
X_2146_ net754 net730 VGND VGND VPWR VPWR Inst_SimpleCLB_ConfigMem.Inst_frame0_bit29.Q
+ sky130_fd_sc_hd__dlxtp_1
XFILLER_38_187 VGND VGND VPWR VPWR sky130_fd_sc_hd__decap_3
X_2077_ net764 net683 VGND VGND VPWR VPWR Inst_SimpleCLB_ConfigMem.Inst_frame2_bit24.Q
+ sky130_fd_sc_hd__dlxtp_1
X_1028_ _0122_ _0123_ Inst_SimpleCLB_ConfigMem.Inst_frame4_bit16.Q VGND VGND VPWR
+ VPWR _0124_ sky130_fd_sc_hd__mux2_1
XFILLER_14_15 VGND VGND VPWR VPWR sky130_fd_sc_hd__decap_3
XFILLER_14_59 VGND VGND VPWR VPWR sky130_fd_sc_hd__decap_3
XFILLER_30_47 VGND VGND VPWR VPWR sky130_fd_sc_hd__decap_3
XFILLER_39_12 VGND VGND VPWR VPWR sky130_fd_sc_hd__fill_2
XTAP_TAPCELL_ROW_87_712 VGND VPWR sky130_fd_sc_hd__tapvpwrvgnd_1
XFILLER_29_121 VGND VGND VPWR VPWR sky130_fd_sc_hd__decap_3
XFILLER_29_165 VGND VGND VPWR VPWR sky130_fd_sc_hd__decap_3
XFILLER_44_113 VGND VGND VPWR VPWR sky130_fd_sc_hd__decap_3
XFILLER_55_55 VGND VGND VPWR VPWR sky130_fd_sc_hd__fill_1
XFILLER_55_66 VGND VGND VPWR VPWR sky130_fd_sc_hd__decap_3
XTAP_TAPCELL_ROW_27_355 VGND VPWR sky130_fd_sc_hd__tapvpwrvgnd_1
XFILLER_55_99 VGND VGND VPWR VPWR sky130_fd_sc_hd__decap_3
XTAP_TAPCELL_ROW_70_612 VGND VPWR sky130_fd_sc_hd__tapvpwrvgnd_1
XFILLER_4_253 VGND VGND VPWR VPWR sky130_fd_sc_hd__decap_3
X_2000_ net794 net676 VGND VGND VPWR VPWR Inst_SimpleCLB_ConfigMem.Inst_frame4_bit11.Q
+ sky130_fd_sc_hd__dlxtp_1
XTAP_TAPCELL_ROW_18_300 VGND VPWR sky130_fd_sc_hd__tapvpwrvgnd_1
XFILLER_35_113 VGND VGND VPWR VPWR sky130_fd_sc_hd__fill_2
XFILLER_75_293 VGND VGND VPWR VPWR sky130_fd_sc_hd__fill_1
XFILLER_23_308 VGND VGND VPWR VPWR sky130_fd_sc_hd__decap_3
XFILLER_90_296 VGND VGND VPWR VPWR sky130_fd_sc_hd__decap_3
X_1715_ net788 net712 VGND VGND VPWR VPWR Inst_SimpleCLB_ConfigMem.Inst_frame13_bit14.Q
+ sky130_fd_sc_hd__dlxtp_1
XFILLER_6_60 VGND VGND VPWR VPWR sky130_fd_sc_hd__decap_3
X_1646_ net734 net703 VGND VGND VPWR VPWR Inst_LF_LUT4c_frame_config_dffesr.inst_cus_mux161_buf.A8
+ sky130_fd_sc_hd__dlxtp_1
X_1577_ net743 net697 VGND VGND VPWR VPWR Inst_LB_LUT4c_frame_config_dffesr.inst_cus_mux161_buf.A15
+ sky130_fd_sc_hd__dlxtp_1
XFILLER_58_238 VGND VGND VPWR VPWR sky130_fd_sc_hd__decap_3
Xrebuffer32 net315 VGND VGND VPWR VPWR net286 sky130_fd_sc_hd__buf_6
Xrebuffer54 net307 VGND VGND VPWR VPWR net308 sky130_fd_sc_hd__dlygate4sd1_1
X_2129_ net793 net729 VGND VGND VPWR VPWR Inst_SimpleCLB_ConfigMem.Inst_frame0_bit12.Q
+ sky130_fd_sc_hd__dlxtp_1
Xrebuffer43 net296 VGND VGND VPWR VPWR net297 sky130_fd_sc_hd__buf_6
XFILLER_81_252 VGND VGND VPWR VPWR sky130_fd_sc_hd__decap_3
XTAP_TAPCELL_ROW_24_336 VGND VPWR sky130_fd_sc_hd__tapvpwrvgnd_1
XTAP_TAPCELL_ROW_32_380 VGND VPWR sky130_fd_sc_hd__tapvpwrvgnd_1
XFILLER_49_249 VGND VGND VPWR VPWR sky130_fd_sc_hd__decap_3
XTAP_TAPCELL_ROW_90_729 VGND VPWR sky130_fd_sc_hd__tapvpwrvgnd_1
XFILLER_82_20 VGND VGND VPWR VPWR sky130_fd_sc_hd__decap_3
XFILLER_82_53 VGND VGND VPWR VPWR sky130_fd_sc_hd__fill_2
XFILLER_32_138 VGND VGND VPWR VPWR sky130_fd_sc_hd__fill_2
XFILLER_9_334 VGND VGND VPWR VPWR sky130_fd_sc_hd__fill_2
Xoutput108 net108 VGND VGND VPWR VPWR N2BEG[2] sky130_fd_sc_hd__buf_6
Xoutput119 net119 VGND VGND VPWR VPWR N2BEGb[5] sky130_fd_sc_hd__buf_2
X_1500_ _0523_ _0525_ _0529_ _0527_ Inst_SimpleCLB_ConfigMem.Inst_frame0_bit30.Q Inst_SimpleCLB_ConfigMem.Inst_frame0_bit31.Q
+ VGND VGND VPWR VPWR _0530_ sky130_fd_sc_hd__mux4_2
XFILLER_56_6 VGND VGND VPWR VPWR sky130_fd_sc_hd__fill_2
X_1431_ Inst_SimpleCLB_ConfigMem.Inst_frame13_bit31.Q _0490_ _0488_ Inst_SimpleCLB_ConfigMem.Inst_frame12_bit0.Q
+ VGND VGND VPWR VPWR _0491_ sky130_fd_sc_hd__o211a_1
Xoutput90 net90 VGND VGND VPWR VPWR FrameStrobe_O[17] sky130_fd_sc_hd__buf_2
X_1362_ _0598_ net261 _0430_ VGND VGND VPWR VPWR _0431_ sky130_fd_sc_hd__o21ai_2
X_1293_ net652 N2END[1] net649 N4END[1] Inst_SimpleCLB_ConfigMem.Inst_frame4_bit27.Q
+ Inst_SimpleCLB_ConfigMem.Inst_frame4_bit26.Q VGND VGND VPWR VPWR _0371_ sky130_fd_sc_hd__mux4_1
XTAP_TAPCELL_ROW_38_417 VGND VPWR sky130_fd_sc_hd__tapvpwrvgnd_1
XFILLER_23_105 VGND VGND VPWR VPWR sky130_fd_sc_hd__decap_3
XFILLER_23_127 VGND VGND VPWR VPWR sky130_fd_sc_hd__decap_3
XFILLER_63_274 VGND VGND VPWR VPWR sky130_fd_sc_hd__decap_3
XFILLER_16_190 VGND VGND VPWR VPWR sky130_fd_sc_hd__decap_3
XTAP_TAPCELL_ROW_21_317 VGND VPWR sky130_fd_sc_hd__tapvpwrvgnd_1
XFILLER_31_193 VGND VGND VPWR VPWR sky130_fd_sc_hd__decap_3
X_1629_ net765 net699 VGND VGND VPWR VPWR Inst_LE_LUT4c_frame_config_dffesr.inst_cus_mux161_buf.A10
+ sky130_fd_sc_hd__dlxtp_1
XFILLER_39_293 VGND VGND VPWR VPWR sky130_fd_sc_hd__fill_2
XFILLER_54_230 VGND VGND VPWR VPWR sky130_fd_sc_hd__decap_3
XFILLER_54_263 VGND VGND VPWR VPWR sky130_fd_sc_hd__decap_3
XFILLER_54_296 VGND VGND VPWR VPWR sky130_fd_sc_hd__decap_3
XFILLER_52_23 VGND VGND VPWR VPWR sky130_fd_sc_hd__decap_3
XFILLER_10_300 VGND VGND VPWR VPWR sky130_fd_sc_hd__decap_3
XFILLER_77_31 VGND VGND VPWR VPWR sky130_fd_sc_hd__decap_3
XFILLER_77_53 VGND VGND VPWR VPWR sky130_fd_sc_hd__decap_3
XFILLER_37_208 VGND VGND VPWR VPWR sky130_fd_sc_hd__decap_3
XFILLER_60_200 VGND VGND VPWR VPWR sky130_fd_sc_hd__decap_3
XFILLER_60_233 VGND VGND VPWR VPWR sky130_fd_sc_hd__decap_3
X_1980_ net766 net674 VGND VGND VPWR VPWR Inst_SimpleCLB_ConfigMem.Inst_frame5_bit23.Q
+ sky130_fd_sc_hd__dlxtp_1
X_0931_ net255 _0032_ _0023_ _0022_ Inst_SimpleCLB_ConfigMem.Inst_frame9_bit2.Q Inst_SimpleCLB_ConfigMem.Inst_frame9_bit3.Q
+ VGND VGND VPWR VPWR _0033_ sky130_fd_sc_hd__mux4_2
XFILLER_60_266 VGND VGND VPWR VPWR sky130_fd_sc_hd__decap_3
X_0862_ _0688_ _0689_ Inst_SimpleCLB_ConfigMem.Inst_frame10_bit16.Q VGND VGND VPWR
+ VPWR _0690_ sky130_fd_sc_hd__mux2_1
X_0793_ Inst_SimpleCLB_ConfigMem.Inst_frame4_bit8.Q _0626_ Inst_SimpleCLB_ConfigMem.Inst_frame4_bit9.Q
+ VGND VGND VPWR VPWR _0627_ sky130_fd_sc_hd__a21o_1
Xrebuffer1 _0031_ VGND VGND VPWR VPWR net255 sky130_fd_sc_hd__buf_6
XFILLER_54_3 VGND VGND VPWR VPWR sky130_fd_sc_hd__fill_2
X_2394_ WW4END[4] VGND VGND VPWR VPWR net239 sky130_fd_sc_hd__clkbuf_2
X_1414_ net645 _0713_ Inst_SimpleCLB_ConfigMem.Inst_frame12_bit4.Q VGND VGND VPWR
+ VPWR _0476_ sky130_fd_sc_hd__mux2_1
X_1345_ net648 S1END[3] net646 net644 Inst_SimpleCLB_ConfigMem.Inst_frame11_bit25.Q
+ Inst_SimpleCLB_ConfigMem.Inst_frame11_bit26.Q VGND VGND VPWR VPWR _0416_ sky130_fd_sc_hd__mux4_1
X_1276_ Inst_SimpleCLB_ConfigMem.Inst_frame3_bit28.Q _0353_ Inst_SimpleCLB_ConfigMem.Inst_frame3_bit29.Q
+ VGND VGND VPWR VPWR _0356_ sky130_fd_sc_hd__o21a_1
XFILLER_51_222 VGND VGND VPWR VPWR sky130_fd_sc_hd__fill_2
XTAP_TAPCELL_ROW_66_589 VGND VPWR sky130_fd_sc_hd__tapvpwrvgnd_1
XFILLER_11_108 VGND VGND VPWR VPWR sky130_fd_sc_hd__decap_3
XFILLER_22_15 VGND VGND VPWR VPWR sky130_fd_sc_hd__fill_1
XFILLER_22_26 VGND VGND VPWR VPWR sky130_fd_sc_hd__fill_2
XTAP_TAPCELL_ROW_57_534 VGND VPWR sky130_fd_sc_hd__tapvpwrvgnd_1
XFILLER_27_252 VGND VGND VPWR VPWR sky130_fd_sc_hd__decap_3
XFILLER_27_296 VGND VGND VPWR VPWR sky130_fd_sc_hd__fill_1
XFILLER_63_66 VGND VGND VPWR VPWR sky130_fd_sc_hd__fill_1
XFILLER_63_99 VGND VGND VPWR VPWR sky130_fd_sc_hd__decap_3
XFILLER_8_17 VGND VGND VPWR VPWR sky130_fd_sc_hd__decap_3
XFILLER_10_141 VGND VGND VPWR VPWR sky130_fd_sc_hd__decap_3
XFILLER_6_134 VGND VGND VPWR VPWR sky130_fd_sc_hd__decap_3
XFILLER_12_81 VGND VGND VPWR VPWR sky130_fd_sc_hd__decap_3
XFILLER_6_156 VGND VGND VPWR VPWR sky130_fd_sc_hd__decap_3
XFILLER_6_189 VGND VGND VPWR VPWR sky130_fd_sc_hd__decap_3
XFILLER_88_85 VGND VGND VPWR VPWR sky130_fd_sc_hd__decap_3
XFILLER_69_119 VGND VGND VPWR VPWR sky130_fd_sc_hd__decap_3
XFILLER_77_152 VGND VGND VPWR VPWR sky130_fd_sc_hd__fill_1
X_1130_ W2END[7] net638 net642 net629 Inst_SimpleCLB_ConfigMem.Inst_frame4_bit19.Q
+ Inst_SimpleCLB_ConfigMem.Inst_frame4_bit18.Q VGND VGND VPWR VPWR _0220_ sky130_fd_sc_hd__mux4_1
XFILLER_77_185 VGND VGND VPWR VPWR sky130_fd_sc_hd__decap_3
X_1061_ _0153_ VGND VGND VPWR VPWR _0154_ sky130_fd_sc_hd__inv_2
XFILLER_33_222 VGND VGND VPWR VPWR sky130_fd_sc_hd__fill_2
XFILLER_33_255 VGND VGND VPWR VPWR sky130_fd_sc_hd__decap_3
X_1963_ net739 net671 VGND VGND VPWR VPWR Inst_SimpleCLB_ConfigMem.Inst_frame5_bit6.Q
+ sky130_fd_sc_hd__dlxtp_1
X_1894_ net776 net663 VGND VGND VPWR VPWR Inst_SimpleCLB_ConfigMem.Inst_frame7_bit1.Q
+ sky130_fd_sc_hd__dlxtp_1
X_0914_ _0017_ _0016_ Inst_SimpleCLB_ConfigMem.Inst_frame2_bit4.Q VGND VGND VPWR VPWR
+ _0018_ sky130_fd_sc_hd__mux2_4
X_0845_ _0673_ _0674_ Inst_SimpleCLB_ConfigMem.Inst_frame1_bit0.Q VGND VGND VPWR VPWR
+ _0675_ sky130_fd_sc_hd__mux2_1
X_0776_ WW4END[3] net626 net641 net617 Inst_SimpleCLB_ConfigMem.Inst_frame4_bit31.Q
+ Inst_SimpleCLB_ConfigMem.Inst_frame4_bit30.Q VGND VGND VPWR VPWR _0611_ sky130_fd_sc_hd__mux4_1
X_2377_ W2MID[3] VGND VGND VPWR VPWR net222 sky130_fd_sc_hd__buf_1
XFILLER_68_141 VGND VGND VPWR VPWR sky130_fd_sc_hd__decap_3
XFILLER_68_174 VGND VGND VPWR VPWR sky130_fd_sc_hd__decap_3
X_1328_ _0609_ _0050_ Inst_SimpleCLB_ConfigMem.Inst_frame10_bit2.Q VGND VGND VPWR
+ VPWR _0402_ sky130_fd_sc_hd__mux2_1
XFILLER_83_155 VGND VGND VPWR VPWR sky130_fd_sc_hd__decap_3
X_1259_ net622 net613 net632 net608 Inst_SimpleCLB_ConfigMem.Inst_frame2_bit27.Q Inst_SimpleCLB_ConfigMem.Inst_frame2_bit26.Q
+ VGND VGND VPWR VPWR _0341_ sky130_fd_sc_hd__mux4_1
XTAP_TAPCELL_ROW_54_515 VGND VPWR sky130_fd_sc_hd__tapvpwrvgnd_1
XFILLER_33_36 VGND VGND VPWR VPWR sky130_fd_sc_hd__fill_2
XFILLER_33_69 VGND VGND VPWR VPWR sky130_fd_sc_hd__decap_3
XFILLER_58_77 VGND VGND VPWR VPWR sky130_fd_sc_hd__decap_3
XFILLER_58_88 VGND VGND VPWR VPWR sky130_fd_sc_hd__fill_1
XFILLER_59_163 VGND VGND VPWR VPWR sky130_fd_sc_hd__decap_3
XFILLER_59_196 VGND VGND VPWR VPWR sky130_fd_sc_hd__decap_3
XFILLER_74_100 VGND VGND VPWR VPWR sky130_fd_sc_hd__decap_3
XFILLER_74_32 VGND VGND VPWR VPWR sky130_fd_sc_hd__decap_3
XFILLER_74_144 VGND VGND VPWR VPWR sky130_fd_sc_hd__decap_3
XFILLER_74_54 VGND VGND VPWR VPWR sky130_fd_sc_hd__decap_3
XFILLER_74_76 VGND VGND VPWR VPWR sky130_fd_sc_hd__decap_3
XFILLER_30_203 VGND VGND VPWR VPWR sky130_fd_sc_hd__fill_2
XPHY_EDGE_ROW_4_Left_95 VGND VGND VPWR VPWR sky130_fd_sc_hd__decap_3
X_2300_ NN4END[11] VGND VGND VPWR VPWR net151 sky130_fd_sc_hd__buf_1
X_2231_ net761 VGND VGND VPWR VPWR net68 sky130_fd_sc_hd__clkbuf_1
XFILLER_17_3 VGND VGND VPWR VPWR sky130_fd_sc_hd__fill_2
X_2162_ Inst_SimpleCLB_switch_matrix.E2BEG1 VGND VGND VPWR VPWR net7 sky130_fd_sc_hd__buf_4
XFILLER_38_325 VGND VGND VPWR VPWR sky130_fd_sc_hd__fill_1
X_2093_ net735 net687 VGND VGND VPWR VPWR Inst_SimpleCLB_ConfigMem.Inst_frame1_bit8.Q
+ sky130_fd_sc_hd__dlxtp_1
X_1113_ Inst_LE_LUT4c_frame_config_dffesr.inst_cus_mux161_buf.A9 _0155_ _0156_ Inst_LE_LUT4c_frame_config_dffesr.inst_cus_mux161_buf.A15
+ VGND VGND VPWR VPWR _0204_ sky130_fd_sc_hd__o22a_1
XFILLER_65_155 VGND VGND VPWR VPWR sky130_fd_sc_hd__decap_3
X_1044_ _0133_ _0135_ _0138_ Inst_SimpleCLB_ConfigMem.Inst_frame3_bit17.Q VGND VGND
+ VPWR VPWR Inst_SimpleCLB_switch_matrix.E2BEG5 sky130_fd_sc_hd__o22a_1
XFILLER_65_199 VGND VGND VPWR VPWR sky130_fd_sc_hd__decap_3
XFILLER_80_147 VGND VGND VPWR VPWR sky130_fd_sc_hd__decap_3
XFILLER_21_225 VGND VGND VPWR VPWR sky130_fd_sc_hd__decap_3
XFILLER_9_60 VGND VGND VPWR VPWR sky130_fd_sc_hd__fill_2
XFILLER_21_247 VGND VGND VPWR VPWR sky130_fd_sc_hd__decap_3
X_1946_ net770 net670 VGND VGND VPWR VPWR Inst_SimpleCLB_ConfigMem.Inst_frame6_bit21.Q
+ sky130_fd_sc_hd__dlxtp_1
X_1877_ net784 net661 VGND VGND VPWR VPWR Inst_SimpleCLB_ConfigMem.Inst_frame8_bit16.Q
+ sky130_fd_sc_hd__dlxtp_1
X_0828_ net621 net612 net631 net608 Inst_SimpleCLB_ConfigMem.Inst_frame2_bit7.Q Inst_SimpleCLB_ConfigMem.Inst_frame2_bit6.Q
+ VGND VGND VPWR VPWR _0659_ sky130_fd_sc_hd__mux4_1
X_0759_ Inst_SimpleCLB_ConfigMem.Inst_frame4_bit25.Q VGND VGND VPWR VPWR _0595_ sky130_fd_sc_hd__inv_1
XFILLER_0_107 VGND VGND VPWR VPWR sky130_fd_sc_hd__decap_3
XFILLER_56_111 VGND VGND VPWR VPWR sky130_fd_sc_hd__decap_3
XFILLER_71_103 VGND VGND VPWR VPWR sky130_fd_sc_hd__fill_1
XFILLER_12_203 VGND VGND VPWR VPWR sky130_fd_sc_hd__decap_3
XFILLER_71_169 VGND VGND VPWR VPWR sky130_fd_sc_hd__decap_3
XFILLER_8_218 VGND VGND VPWR VPWR sky130_fd_sc_hd__decap_3
XFILLER_20_280 VGND VGND VPWR VPWR sky130_fd_sc_hd__decap_3
XFILLER_60_56 VGND VGND VPWR VPWR sky130_fd_sc_hd__fill_1
XFILLER_60_78 VGND VGND VPWR VPWR sky130_fd_sc_hd__decap_3
XFILLER_79_203 VGND VGND VPWR VPWR sky130_fd_sc_hd__decap_3
XFILLER_79_225 VGND VGND VPWR VPWR sky130_fd_sc_hd__fill_1
XFILLER_85_20 VGND VGND VPWR VPWR sky130_fd_sc_hd__decap_3
XFILLER_47_111 VGND VGND VPWR VPWR sky130_fd_sc_hd__fill_1
XFILLER_18_91 VGND VGND VPWR VPWR sky130_fd_sc_hd__decap_3
XFILLER_62_136 VGND VGND VPWR VPWR sky130_fd_sc_hd__decap_3
XFILLER_86_6 VGND VGND VPWR VPWR sky130_fd_sc_hd__fill_1
X_1800_ net745 net728 VGND VGND VPWR VPWR Inst_SimpleCLB_ConfigMem.Inst_frame10_bit3.Q
+ sky130_fd_sc_hd__dlxtp_1
X_1731_ net750 net714 VGND VGND VPWR VPWR Inst_SimpleCLB_ConfigMem.Inst_frame13_bit30.Q
+ sky130_fd_sc_hd__dlxtp_1
X_1662_ net763 net706 VGND VGND VPWR VPWR Inst_LG_LUT4c_frame_config_dffesr.inst_cus_mux161_buf.A5
+ sky130_fd_sc_hd__dlxtp_1
X_1593_ net775 net694 VGND VGND VPWR VPWR Inst_LC_LUT4c_frame_config_dffesr.inst_cus_mux161_buf.A12
+ sky130_fd_sc_hd__dlxtp_1
Xfanout709 net710 VGND VGND VPWR VPWR net709 sky130_fd_sc_hd__buf_2
X_2214_ net734 VGND VGND VPWR VPWR net81 sky130_fd_sc_hd__buf_1
XFILLER_85_228 VGND VGND VPWR VPWR sky130_fd_sc_hd__decap_3
X_2145_ net757 net729 VGND VGND VPWR VPWR Inst_SimpleCLB_ConfigMem.Inst_frame0_bit28.Q
+ sky130_fd_sc_hd__dlxtp_1
XFILLER_38_122 VGND VGND VPWR VPWR sky130_fd_sc_hd__decap_3
XFILLER_38_144 VGND VGND VPWR VPWR sky130_fd_sc_hd__fill_2
X_2076_ net767 net683 VGND VGND VPWR VPWR Inst_SimpleCLB_ConfigMem.Inst_frame2_bit23.Q
+ sky130_fd_sc_hd__dlxtp_1
XFILLER_26_339 VGND VGND VPWR VPWR sky130_fd_sc_hd__fill_1
X_1027_ S1END[2] W1END[0] S2END[6] net647 Inst_SimpleCLB_ConfigMem.Inst_frame4_bit15.Q
+ Inst_SimpleCLB_ConfigMem.Inst_frame4_bit14.Q VGND VGND VPWR VPWR _0123_ sky130_fd_sc_hd__mux4_1
X_1929_ net744 net670 VGND VGND VPWR VPWR Inst_SimpleCLB_ConfigMem.Inst_frame6_bit4.Q
+ sky130_fd_sc_hd__dlxtp_1
XFILLER_30_26 VGND VGND VPWR VPWR sky130_fd_sc_hd__fill_2
XFILLER_30_59 VGND VGND VPWR VPWR sky130_fd_sc_hd__decap_3
XFILLER_39_46 VGND VGND VPWR VPWR sky130_fd_sc_hd__decap_3
XFILLER_39_57 VGND VGND VPWR VPWR sky130_fd_sc_hd__decap_3
XTAP_TAPCELL_ROW_87_713 VGND VPWR sky130_fd_sc_hd__tapvpwrvgnd_1
XFILLER_29_111 VGND VGND VPWR VPWR sky130_fd_sc_hd__fill_1
XFILLER_17_328 VGND VGND VPWR VPWR sky130_fd_sc_hd__decap_3
XFILLER_29_188 VGND VGND VPWR VPWR sky130_fd_sc_hd__decap_3
XFILLER_44_103 VGND VGND VPWR VPWR sky130_fd_sc_hd__decap_3
XFILLER_44_125 VGND VGND VPWR VPWR sky130_fd_sc_hd__decap_3
XFILLER_55_78 VGND VGND VPWR VPWR sky130_fd_sc_hd__decap_3
XTAP_TAPCELL_ROW_70_613 VGND VPWR sky130_fd_sc_hd__tapvpwrvgnd_1
XFILLER_20_81 VGND VGND VPWR VPWR sky130_fd_sc_hd__decap_3
XFILLER_29_90 VGND VGND VPWR VPWR sky130_fd_sc_hd__decap_3
XFILLER_75_272 VGND VGND VPWR VPWR sky130_fd_sc_hd__decap_3
XFILLER_90_231 VGND VGND VPWR VPWR sky130_fd_sc_hd__decap_3
XTAP_TAPCELL_ROW_18_301 VGND VPWR sky130_fd_sc_hd__tapvpwrvgnd_1
XFILLER_90_253 VGND VGND VPWR VPWR sky130_fd_sc_hd__decap_3
XFILLER_35_158 VGND VGND VPWR VPWR sky130_fd_sc_hd__decap_3
XFILLER_35_169 VGND VGND VPWR VPWR sky130_fd_sc_hd__decap_3
XFILLER_50_106 VGND VGND VPWR VPWR sky130_fd_sc_hd__decap_3
XFILLER_50_139 VGND VGND VPWR VPWR sky130_fd_sc_hd__fill_1
XFILLER_43_191 VGND VGND VPWR VPWR sky130_fd_sc_hd__decap_3
XFILLER_84_3 VGND VGND VPWR VPWR sky130_fd_sc_hd__decap_3
X_1714_ net791 net713 VGND VGND VPWR VPWR Inst_SimpleCLB_ConfigMem.Inst_frame13_bit13.Q
+ sky130_fd_sc_hd__dlxtp_1
XFILLER_6_72 VGND VGND VPWR VPWR sky130_fd_sc_hd__decap_3
X_1645_ net736 net704 VGND VGND VPWR VPWR Inst_LF_LUT4c_frame_config_dffesr.inst_cus_mux161_buf.A7
+ sky130_fd_sc_hd__dlxtp_1
X_1576_ net746 net697 VGND VGND VPWR VPWR Inst_LB_LUT4c_frame_config_dffesr.inst_cus_mux161_buf.A14
+ sky130_fd_sc_hd__dlxtp_1
Xrebuffer11 Inst_SimpleCLB_switch_matrix.JS2BEG2 VGND VGND VPWR VPWR net265 sky130_fd_sc_hd__dlygate4sd1_1
X_2128_ net794 net731 VGND VGND VPWR VPWR Inst_SimpleCLB_ConfigMem.Inst_frame0_bit11.Q
+ sky130_fd_sc_hd__dlxtp_1
Xrebuffer44 net297 VGND VGND VPWR VPWR net298 sky130_fd_sc_hd__clkbuf_2
Xrebuffer55 Inst_LH_LUT4c_frame_config_dffesr.O VGND VGND VPWR VPWR net309 sky130_fd_sc_hd__buf_6
X_2059_ net739 net684 VGND VGND VPWR VPWR Inst_SimpleCLB_ConfigMem.Inst_frame2_bit6.Q
+ sky130_fd_sc_hd__dlxtp_1
XFILLER_26_147 VGND VGND VPWR VPWR sky130_fd_sc_hd__decap_3
Xrebuffer77 net345 VGND VGND VPWR VPWR net331 sky130_fd_sc_hd__clkbuf_2
XFILLER_25_37 VGND VGND VPWR VPWR sky130_fd_sc_hd__decap_3
XTAP_TAPCELL_ROW_24_337 VGND VPWR sky130_fd_sc_hd__tapvpwrvgnd_1
XFILLER_34_191 VGND VGND VPWR VPWR sky130_fd_sc_hd__decap_3
XTAP_TAPCELL_ROW_32_381 VGND VPWR sky130_fd_sc_hd__tapvpwrvgnd_1
XFILLER_49_228 VGND VGND VPWR VPWR sky130_fd_sc_hd__decap_3
XFILLER_57_250 VGND VGND VPWR VPWR sky130_fd_sc_hd__decap_3
XFILLER_72_231 VGND VGND VPWR VPWR sky130_fd_sc_hd__decap_3
XFILLER_17_169 VGND VGND VPWR VPWR sky130_fd_sc_hd__decap_3
XFILLER_32_117 VGND VGND VPWR VPWR sky130_fd_sc_hd__decap_3
XFILLER_25_191 VGND VGND VPWR VPWR sky130_fd_sc_hd__fill_2
XFILLER_40_161 VGND VGND VPWR VPWR sky130_fd_sc_hd__decap_3
XFILLER_9_346 VGND VGND VPWR VPWR sky130_fd_sc_hd__fill_1
XFILLER_70_9 VGND VGND VPWR VPWR sky130_fd_sc_hd__decap_3
Xoutput109 net109 VGND VGND VPWR VPWR N2BEG[3] sky130_fd_sc_hd__buf_4
Xoutput1 net1 VGND VGND VPWR VPWR Co sky130_fd_sc_hd__buf_8
XFILLER_49_6 VGND VGND VPWR VPWR sky130_fd_sc_hd__decap_3
X_1430_ _0489_ VGND VGND VPWR VPWR _0490_ sky130_fd_sc_hd__inv_2
X_1361_ Inst_SimpleCLB_ConfigMem.Inst_frame11_bit11.Q net267 VGND VGND VPWR VPWR _0430_
+ sky130_fd_sc_hd__or2_1
Xoutput91 net91 VGND VGND VPWR VPWR FrameStrobe_O[18] sky130_fd_sc_hd__buf_2
Xoutput80 net80 VGND VGND VPWR VPWR FrameData_O[8] sky130_fd_sc_hd__buf_2
X_1292_ _0592_ _0369_ Inst_SimpleCLB_ConfigMem.Inst_frame4_bit29.Q VGND VGND VPWR
+ VPWR _0370_ sky130_fd_sc_hd__o21a_1
XTAP_TAPCELL_ROW_38_418 VGND VPWR sky130_fd_sc_hd__tapvpwrvgnd_1
XFILLER_48_250 VGND VGND VPWR VPWR sky130_fd_sc_hd__fill_2
XTAP_TAPCELL_ROW_21_318 VGND VPWR sky130_fd_sc_hd__tapvpwrvgnd_1
XFILLER_31_172 VGND VGND VPWR VPWR sky130_fd_sc_hd__decap_3
X_1628_ net766 net700 VGND VGND VPWR VPWR Inst_LE_LUT4c_frame_config_dffesr.inst_cus_mux161_buf.A9
+ sky130_fd_sc_hd__dlxtp_1
X_1559_ net781 net693 VGND VGND VPWR VPWR Inst_LA_LUT4c_frame_config_dffesr.c_out_mux
+ sky130_fd_sc_hd__dlxtp_1
XFILLER_39_272 VGND VGND VPWR VPWR sky130_fd_sc_hd__decap_3
XFILLER_54_242 VGND VGND VPWR VPWR sky130_fd_sc_hd__decap_3
XFILLER_14_128 VGND VGND VPWR VPWR sky130_fd_sc_hd__decap_3
XFILLER_54_275 VGND VGND VPWR VPWR sky130_fd_sc_hd__decap_3
XFILLER_10_312 VGND VGND VPWR VPWR sky130_fd_sc_hd__decap_3
XFILLER_6_305 VGND VGND VPWR VPWR sky130_fd_sc_hd__decap_3
XFILLER_6_327 VGND VGND VPWR VPWR sky130_fd_sc_hd__decap_3
XFILLER_89_161 VGND VGND VPWR VPWR sky130_fd_sc_hd__decap_3
XFILLER_77_323 VGND VGND VPWR VPWR sky130_fd_sc_hd__fill_1
XFILLER_77_76 VGND VGND VPWR VPWR sky130_fd_sc_hd__decap_3
XFILLER_45_231 VGND VGND VPWR VPWR sky130_fd_sc_hd__decap_3
XANTENNA_230 _0142_ VGND VGND VPWR VPWR sky130_fd_sc_hd__diode_2
XFILLER_60_212 VGND VGND VPWR VPWR sky130_fd_sc_hd__decap_3
XFILLER_13_150 VGND VGND VPWR VPWR sky130_fd_sc_hd__fill_2
X_0930_ N2MID[5] E2MID[5] S2MID[5] W2MID[5] Inst_SimpleCLB_ConfigMem.Inst_frame6_bit6.Q
+ Inst_SimpleCLB_ConfigMem.Inst_frame6_bit7.Q VGND VGND VPWR VPWR _0032_ sky130_fd_sc_hd__mux4_1
XFILLER_60_278 VGND VGND VPWR VPWR sky130_fd_sc_hd__fill_1
XFILLER_13_183 VGND VGND VPWR VPWR sky130_fd_sc_hd__decap_3
XFILLER_13_161 VGND VGND VPWR VPWR sky130_fd_sc_hd__decap_3
X_0861_ N2MID[1] E2MID[1] S2MID[1] W2MID[1] Inst_SimpleCLB_ConfigMem.Inst_frame6_bit0.Q
+ Inst_SimpleCLB_ConfigMem.Inst_frame6_bit1.Q VGND VGND VPWR VPWR _0689_ sky130_fd_sc_hd__mux4_2
XFILLER_9_165 VGND VGND VPWR VPWR sky130_fd_sc_hd__decap_3
Xrebuffer2 _0040_ VGND VGND VPWR VPWR net256 sky130_fd_sc_hd__dlygate4sd1_1
X_0792_ E2END[4] S2END[4] net801 W2END[4] Inst_SimpleCLB_ConfigMem.Inst_frame4_bit7.Q
+ Inst_SimpleCLB_ConfigMem.Inst_frame4_bit6.Q VGND VGND VPWR VPWR _0626_ sky130_fd_sc_hd__mux4_1
XFILLER_87_109 VGND VGND VPWR VPWR sky130_fd_sc_hd__decap_3
XFILLER_47_3 VGND VGND VPWR VPWR sky130_fd_sc_hd__decap_3
X_1413_ _0474_ _0475_ Inst_SimpleCLB_ConfigMem.Inst_frame12_bit9.Q VGND VGND VPWR
+ VPWR Inst_SimpleCLB_switch_matrix.EE4BEG3 sky130_fd_sc_hd__mux2_1
X_1344_ Inst_SimpleCLB_ConfigMem.Inst_frame11_bit30.Q _0415_ _0414_ VGND VGND VPWR
+ VPWR Inst_SimpleCLB_switch_matrix.WW4BEG2 sky130_fd_sc_hd__o21ba_1
XPHY_EDGE_ROW_79_Left_170 VGND VGND VPWR VPWR sky130_fd_sc_hd__decap_3
XFILLER_83_315 VGND VGND VPWR VPWR sky130_fd_sc_hd__decap_3
X_1275_ _0588_ _0354_ VGND VGND VPWR VPWR _0355_ sky130_fd_sc_hd__or2_1
XFILLER_0_9 VGND VGND VPWR VPWR sky130_fd_sc_hd__decap_3
XFILLER_19_209 VGND VGND VPWR VPWR sky130_fd_sc_hd__fill_2
XFILLER_86_186 VGND VGND VPWR VPWR sky130_fd_sc_hd__decap_3
XPHY_EDGE_ROW_29_Right_29 VGND VGND VPWR VPWR sky130_fd_sc_hd__decap_3
XTAP_TAPCELL_ROW_57_535 VGND VPWR sky130_fd_sc_hd__tapvpwrvgnd_1
XFILLER_27_231 VGND VGND VPWR VPWR sky130_fd_sc_hd__decap_3
XFILLER_27_264 VGND VGND VPWR VPWR sky130_fd_sc_hd__fill_2
XFILLER_42_212 VGND VGND VPWR VPWR sky130_fd_sc_hd__fill_1
XFILLER_63_45 VGND VGND VPWR VPWR sky130_fd_sc_hd__decap_3
XFILLER_42_267 VGND VGND VPWR VPWR sky130_fd_sc_hd__decap_3
XFILLER_63_89 VGND VGND VPWR VPWR sky130_fd_sc_hd__decap_3
XPHY_EDGE_ROW_38_Right_38 VGND VGND VPWR VPWR sky130_fd_sc_hd__decap_3
XFILLER_10_175 VGND VGND VPWR VPWR sky130_fd_sc_hd__decap_3
XFILLER_10_153 VGND VGND VPWR VPWR sky130_fd_sc_hd__decap_3
XFILLER_10_197 VGND VGND VPWR VPWR sky130_fd_sc_hd__decap_3
XFILLER_6_168 VGND VGND VPWR VPWR sky130_fd_sc_hd__decap_3
XFILLER_69_109 VGND VGND VPWR VPWR sky130_fd_sc_hd__decap_3
XPHY_EDGE_ROW_47_Right_47 VGND VGND VPWR VPWR sky130_fd_sc_hd__decap_3
XFILLER_77_164 VGND VGND VPWR VPWR sky130_fd_sc_hd__decap_3
XFILLER_77_197 VGND VGND VPWR VPWR sky130_fd_sc_hd__decap_3
X_1060_ net261 _0152_ _0143_ _0142_ Inst_SimpleCLB_ConfigMem.Inst_frame9_bit22.Q Inst_SimpleCLB_ConfigMem.Inst_frame9_bit23.Q
+ VGND VGND VPWR VPWR _0153_ sky130_fd_sc_hd__mux4_2
XFILLER_18_286 VGND VGND VPWR VPWR sky130_fd_sc_hd__fill_1
XFILLER_33_267 VGND VGND VPWR VPWR sky130_fd_sc_hd__decap_3
X_1962_ net741 net671 VGND VGND VPWR VPWR Inst_SimpleCLB_ConfigMem.Inst_frame5_bit5.Q
+ sky130_fd_sc_hd__dlxtp_1
XPHY_EDGE_ROW_56_Right_56 VGND VGND VPWR VPWR sky130_fd_sc_hd__decap_3
X_1893_ net798 net663 VGND VGND VPWR VPWR Inst_SimpleCLB_ConfigMem.Inst_frame7_bit0.Q
+ sky130_fd_sc_hd__dlxtp_1
X_0913_ W6END[1] net637 net641 net617 Inst_SimpleCLB_ConfigMem.Inst_frame2_bit3.Q
+ Inst_SimpleCLB_ConfigMem.Inst_frame2_bit2.Q VGND VGND VPWR VPWR _0017_ sky130_fd_sc_hd__mux4_2
X_0844_ net621 net612 net631 net608 Inst_SimpleCLB_ConfigMem.Inst_frame2_bit31.Q Inst_SimpleCLB_ConfigMem.Inst_frame2_bit30.Q
+ VGND VGND VPWR VPWR _0674_ sky130_fd_sc_hd__mux4_1
X_0775_ net623 net613 net635 net609 Inst_SimpleCLB_ConfigMem.Inst_frame4_bit31.Q Inst_SimpleCLB_ConfigMem.Inst_frame4_bit30.Q
+ VGND VGND VPWR VPWR _0610_ sky130_fd_sc_hd__mux4_1
XFILLER_5_190 VGND VGND VPWR VPWR sky130_fd_sc_hd__decap_3
XPHY_EDGE_ROW_65_Right_65 VGND VGND VPWR VPWR sky130_fd_sc_hd__decap_3
XFILLER_68_120 VGND VGND VPWR VPWR sky130_fd_sc_hd__decap_3
X_2376_ W2MID[2] VGND VGND VPWR VPWR net221 sky130_fd_sc_hd__buf_4
X_1327_ Inst_SimpleCLB_ConfigMem.Inst_frame10_bit4.Q _0400_ Inst_SimpleCLB_ConfigMem.Inst_frame10_bit5.Q
+ VGND VGND VPWR VPWR _0401_ sky130_fd_sc_hd__o21ai_1
X_1258_ Inst_SimpleCLB_ConfigMem.Inst_frame2_bit28.Q _0339_ VGND VGND VPWR VPWR _0340_
+ sky130_fd_sc_hd__or2_1
Xclone7 N2MID[4] W2MID[4] S2MID[4] Inst_SimpleCLB_switch_matrix.JS2BEG5 Inst_SimpleCLB_ConfigMem.Inst_frame7_bit15.Q
+ Inst_SimpleCLB_ConfigMem.Inst_frame7_bit14.Q VGND VGND VPWR VPWR net261 sky130_fd_sc_hd__mux4_2
XFILLER_71_307 VGND VGND VPWR VPWR sky130_fd_sc_hd__decap_3
XFILLER_83_189 VGND VGND VPWR VPWR sky130_fd_sc_hd__decap_3
XFILLER_83_167 VGND VGND VPWR VPWR sky130_fd_sc_hd__fill_1
X_1189_ _0274_ VGND VGND VPWR VPWR _0275_ sky130_fd_sc_hd__inv_1
XTAP_TAPCELL_ROW_54_516 VGND VPWR sky130_fd_sc_hd__tapvpwrvgnd_1
XFILLER_33_15 VGND VGND VPWR VPWR sky130_fd_sc_hd__decap_3
XTAP_TAPCELL_ROW_62_560 VGND VPWR sky130_fd_sc_hd__tapvpwrvgnd_1
XPHY_EDGE_ROW_74_Right_74 VGND VGND VPWR VPWR sky130_fd_sc_hd__decap_3
XPHY_EDGE_ROW_83_Right_83 VGND VGND VPWR VPWR sky130_fd_sc_hd__decap_3
XFILLER_74_11 VGND VGND VPWR VPWR sky130_fd_sc_hd__decap_3
XFILLER_74_22 VGND VGND VPWR VPWR sky130_fd_sc_hd__decap_3
XFILLER_15_278 VGND VGND VPWR VPWR sky130_fd_sc_hd__fill_2
XFILLER_23_81 VGND VGND VPWR VPWR sky130_fd_sc_hd__decap_3
X_2230_ net763 VGND VGND VPWR VPWR net67 sky130_fd_sc_hd__clkbuf_2
X_2161_ Inst_SimpleCLB_switch_matrix.E2BEG0 VGND VGND VPWR VPWR net6 sky130_fd_sc_hd__buf_1
X_2092_ net737 net687 VGND VGND VPWR VPWR Inst_SimpleCLB_ConfigMem.Inst_frame1_bit7.Q
+ sky130_fd_sc_hd__dlxtp_1
X_1112_ _0141_ _0154_ VGND VGND VPWR VPWR _0203_ sky130_fd_sc_hd__or2_1
XFILLER_65_134 VGND VGND VPWR VPWR sky130_fd_sc_hd__decap_3
XFILLER_0_41 VGND VGND VPWR VPWR sky130_fd_sc_hd__decap_3
X_1043_ _0137_ _0136_ Inst_SimpleCLB_ConfigMem.Inst_frame3_bit16.Q VGND VGND VPWR
+ VPWR _0138_ sky130_fd_sc_hd__mux2_1
XFILLER_65_167 VGND VGND VPWR VPWR sky130_fd_sc_hd__fill_1
XFILLER_65_178 VGND VGND VPWR VPWR sky130_fd_sc_hd__decap_3
XFILLER_80_115 VGND VGND VPWR VPWR sky130_fd_sc_hd__fill_1
XFILLER_0_85 VGND VGND VPWR VPWR sky130_fd_sc_hd__decap_3
XFILLER_80_137 VGND VGND VPWR VPWR sky130_fd_sc_hd__decap_3
XTAP_TAPCELL_ROW_16_284 VGND VPWR sky130_fd_sc_hd__tapvpwrvgnd_1
X_1945_ net773 net670 VGND VGND VPWR VPWR Inst_SimpleCLB_ConfigMem.Inst_frame6_bit20.Q
+ sky130_fd_sc_hd__dlxtp_1
X_1876_ net786 net660 VGND VGND VPWR VPWR Inst_SimpleCLB_ConfigMem.Inst_frame8_bit15.Q
+ sky130_fd_sc_hd__dlxtp_1
X_0827_ N2END[4] S2END[4] EE4END[0] W2END[4] Inst_SimpleCLB_ConfigMem.Inst_frame6_bit31.Q
+ Inst_SimpleCLB_ConfigMem.Inst_frame6_bit30.Q VGND VGND VPWR VPWR _0658_ sky130_fd_sc_hd__mux4_2
X_0758_ Inst_SimpleCLB_ConfigMem.Inst_frame4_bit24.Q VGND VGND VPWR VPWR _0594_ sky130_fd_sc_hd__inv_1
XFILLER_88_226 VGND VGND VPWR VPWR sky130_fd_sc_hd__decap_3
XFILLER_0_119 VGND VGND VPWR VPWR sky130_fd_sc_hd__decap_3
X_2359_ Inst_SimpleCLB_switch_matrix.SS4BEG2 VGND VGND VPWR VPWR net195 sky130_fd_sc_hd__clkbuf_2
XFILLER_28_15 VGND VGND VPWR VPWR sky130_fd_sc_hd__fill_2
XFILLER_56_123 VGND VGND VPWR VPWR sky130_fd_sc_hd__decap_3
XFILLER_12_215 VGND VGND VPWR VPWR sky130_fd_sc_hd__decap_3
XFILLER_12_259 VGND VGND VPWR VPWR sky130_fd_sc_hd__decap_3
XFILLER_12_237 VGND VGND VPWR VPWR sky130_fd_sc_hd__fill_2
XFILLER_60_24 VGND VGND VPWR VPWR sky130_fd_sc_hd__decap_3
XTAP_TAPCELL_ROW_7_230 VGND VPWR sky130_fd_sc_hd__tapvpwrvgnd_1
XFILLER_87_281 VGND VGND VPWR VPWR sky130_fd_sc_hd__fill_2
XFILLER_47_156 VGND VGND VPWR VPWR sky130_fd_sc_hd__decap_3
XFILLER_62_104 VGND VGND VPWR VPWR sky130_fd_sc_hd__decap_3
XFILLER_34_80 VGND VGND VPWR VPWR sky130_fd_sc_hd__decap_3
XFILLER_11_281 VGND VGND VPWR VPWR sky130_fd_sc_hd__decap_3
X_1730_ net754 net711 VGND VGND VPWR VPWR Inst_SimpleCLB_ConfigMem.Inst_frame13_bit29.Q
+ sky130_fd_sc_hd__dlxtp_1
X_1661_ net765 net705 VGND VGND VPWR VPWR Inst_LG_LUT4c_frame_config_dffesr.inst_cus_mux161_buf.A4
+ sky130_fd_sc_hd__dlxtp_1
X_1592_ net779 net694 VGND VGND VPWR VPWR Inst_LC_LUT4c_frame_config_dffesr.inst_cus_mux161_buf.A11
+ sky130_fd_sc_hd__dlxtp_1
X_2213_ net736 VGND VGND VPWR VPWR net80 sky130_fd_sc_hd__buf_1
XFILLER_85_218 VGND VGND VPWR VPWR sky130_fd_sc_hd__decap_3
X_2144_ net759 net729 VGND VGND VPWR VPWR Inst_SimpleCLB_ConfigMem.Inst_frame0_bit27.Q
+ sky130_fd_sc_hd__dlxtp_1
XFILLER_38_134 VGND VGND VPWR VPWR sky130_fd_sc_hd__decap_3
XFILLER_26_307 VGND VGND VPWR VPWR sky130_fd_sc_hd__fill_1
X_2075_ net769 net683 VGND VGND VPWR VPWR Inst_SimpleCLB_ConfigMem.Inst_frame2_bit22.Q
+ sky130_fd_sc_hd__dlxtp_1
XFILLER_53_137 VGND VGND VPWR VPWR sky130_fd_sc_hd__fill_2
X_1026_ net651 N2END[6] E1END[2] E2END[6] Inst_SimpleCLB_ConfigMem.Inst_frame4_bit14.Q
+ Inst_SimpleCLB_ConfigMem.Inst_frame4_bit15.Q VGND VGND VPWR VPWR _0122_ sky130_fd_sc_hd__mux4_1
XPHY_EDGE_ROW_15_Left_106 VGND VGND VPWR VPWR sky130_fd_sc_hd__decap_3
X_1928_ net745 net668 VGND VGND VPWR VPWR Inst_SimpleCLB_ConfigMem.Inst_frame6_bit3.Q
+ sky130_fd_sc_hd__dlxtp_1
XFILLER_30_38 VGND VGND VPWR VPWR sky130_fd_sc_hd__decap_3
X_1859_ net750 net657 VGND VGND VPWR VPWR Inst_SimpleCLB_ConfigMem.Inst_frame9_bit30.Q
+ sky130_fd_sc_hd__dlxtp_1
XTAP_TAPCELL_ROW_87_714 VGND VPWR sky130_fd_sc_hd__tapvpwrvgnd_1
XPHY_EDGE_ROW_24_Left_115 VGND VGND VPWR VPWR sky130_fd_sc_hd__decap_3
XFILLER_69_281 VGND VGND VPWR VPWR sky130_fd_sc_hd__fill_2
XFILLER_29_178 VGND VGND VPWR VPWR sky130_fd_sc_hd__fill_1
XFILLER_44_137 VGND VGND VPWR VPWR sky130_fd_sc_hd__decap_3
XFILLER_55_57 VGND VGND VPWR VPWR sky130_fd_sc_hd__decap_3
XPHY_EDGE_ROW_33_Left_124 VGND VGND VPWR VPWR sky130_fd_sc_hd__decap_3
XFILLER_4_200 VGND VGND VPWR VPWR sky130_fd_sc_hd__decap_3
XPHY_EDGE_ROW_42_Left_133 VGND VGND VPWR VPWR sky130_fd_sc_hd__decap_3
XFILLER_67_218 VGND VGND VPWR VPWR sky130_fd_sc_hd__decap_3
XFILLER_90_221 VGND VGND VPWR VPWR sky130_fd_sc_hd__decap_3
XFILLER_90_243 VGND VGND VPWR VPWR sky130_fd_sc_hd__decap_3
XFILLER_16_340 VGND VGND VPWR VPWR sky130_fd_sc_hd__decap_3
XFILLER_35_148 VGND VGND VPWR VPWR sky130_fd_sc_hd__fill_1
XFILLER_50_118 VGND VGND VPWR VPWR sky130_fd_sc_hd__decap_3
XPHY_EDGE_ROW_51_Left_142 VGND VGND VPWR VPWR sky130_fd_sc_hd__decap_3
XFILLER_77_3 VGND VGND VPWR VPWR sky130_fd_sc_hd__fill_2
X_1713_ net792 net712 VGND VGND VPWR VPWR Inst_SimpleCLB_ConfigMem.Inst_frame13_bit12.Q
+ sky130_fd_sc_hd__dlxtp_1
X_1644_ net738 net703 VGND VGND VPWR VPWR Inst_LF_LUT4c_frame_config_dffesr.inst_cus_mux161_buf.A6
+ sky130_fd_sc_hd__dlxtp_1
X_1575_ net752 net697 VGND VGND VPWR VPWR Inst_LB_LUT4c_frame_config_dffesr.inst_cus_mux161_buf.A13
+ sky130_fd_sc_hd__dlxtp_1
XPHY_EDGE_ROW_60_Left_151 VGND VGND VPWR VPWR sky130_fd_sc_hd__decap_3
XFILLER_58_229 VGND VGND VPWR VPWR sky130_fd_sc_hd__decap_3
Xrebuffer12 net265 VGND VGND VPWR VPWR net266 sky130_fd_sc_hd__dlygate4sd1_1
XFILLER_66_251 VGND VGND VPWR VPWR sky130_fd_sc_hd__fill_1
XFILLER_81_221 VGND VGND VPWR VPWR sky130_fd_sc_hd__decap_3
XFILLER_26_137 VGND VGND VPWR VPWR sky130_fd_sc_hd__decap_3
XTAP_TAPCELL_ROW_49_482 VGND VPWR sky130_fd_sc_hd__tapvpwrvgnd_1
X_2127_ net796 net731 VGND VGND VPWR VPWR Inst_SimpleCLB_ConfigMem.Inst_frame0_bit10.Q
+ sky130_fd_sc_hd__dlxtp_1
Xrebuffer45 net300 VGND VGND VPWR VPWR net299 sky130_fd_sc_hd__buf_1
XFILLER_81_243 VGND VGND VPWR VPWR sky130_fd_sc_hd__decap_3
XFILLER_26_159 VGND VGND VPWR VPWR sky130_fd_sc_hd__fill_1
X_2058_ net741 net686 VGND VGND VPWR VPWR Inst_SimpleCLB_ConfigMem.Inst_frame2_bit5.Q
+ sky130_fd_sc_hd__dlxtp_1
Xrebuffer56 net309 VGND VGND VPWR VPWR net310 sky130_fd_sc_hd__dlygate4sd1_1
X_1009_ Inst_LB_LUT4c_frame_config_dffesr.inst_cus_mux161_buf.A4 _0097_ VGND VGND
+ VPWR VPWR _0106_ sky130_fd_sc_hd__or2_1
XTAP_TAPCELL_ROW_32_382 VGND VPWR sky130_fd_sc_hd__tapvpwrvgnd_1
XFILLER_1_247 VGND VGND VPWR VPWR sky130_fd_sc_hd__fill_2
XFILLER_49_207 VGND VGND VPWR VPWR sky130_fd_sc_hd__decap_3
XFILLER_66_23 VGND VGND VPWR VPWR sky130_fd_sc_hd__decap_3
XFILLER_17_137 VGND VGND VPWR VPWR sky130_fd_sc_hd__decap_3
XFILLER_57_273 VGND VGND VPWR VPWR sky130_fd_sc_hd__decap_3
XFILLER_57_284 VGND VGND VPWR VPWR sky130_fd_sc_hd__decap_3
XFILLER_66_89 VGND VGND VPWR VPWR sky130_fd_sc_hd__decap_3
XFILLER_82_11 VGND VGND VPWR VPWR sky130_fd_sc_hd__fill_1
XFILLER_72_298 VGND VGND VPWR VPWR sky130_fd_sc_hd__decap_3
XFILLER_13_310 VGND VGND VPWR VPWR sky130_fd_sc_hd__decap_3
XFILLER_40_173 VGND VGND VPWR VPWR sky130_fd_sc_hd__decap_3
XFILLER_40_195 VGND VGND VPWR VPWR sky130_fd_sc_hd__fill_1
XFILLER_31_92 VGND VGND VPWR VPWR sky130_fd_sc_hd__decap_3
Xoutput2 net2 VGND VGND VPWR VPWR E1BEG[0] sky130_fd_sc_hd__buf_4
X_1360_ Inst_SimpleCLB_ConfigMem.Inst_frame11_bit11.Q _0241_ _0428_ Inst_SimpleCLB_ConfigMem.Inst_frame11_bit12.Q
+ VGND VGND VPWR VPWR _0429_ sky130_fd_sc_hd__o211a_1
Xoutput70 net70 VGND VGND VPWR VPWR FrameData_O[28] sky130_fd_sc_hd__buf_2
Xoutput92 net92 VGND VGND VPWR VPWR FrameStrobe_O[19] sky130_fd_sc_hd__buf_2
Xoutput81 net81 VGND VGND VPWR VPWR FrameData_O[9] sky130_fd_sc_hd__buf_2
X_1291_ net622 net613 net632 net609 Inst_SimpleCLB_ConfigMem.Inst_frame4_bit27.Q Inst_SimpleCLB_ConfigMem.Inst_frame4_bit26.Q
+ VGND VGND VPWR VPWR _0369_ sky130_fd_sc_hd__mux4_1
XTAP_TAPCELL_ROW_38_419 VGND VPWR sky130_fd_sc_hd__tapvpwrvgnd_1
XTAP_TAPCELL_ROW_21_319 VGND VPWR sky130_fd_sc_hd__tapvpwrvgnd_1
XFILLER_31_184 VGND VGND VPWR VPWR sky130_fd_sc_hd__decap_3
X_1627_ net768 net699 VGND VGND VPWR VPWR Inst_LE_LUT4c_frame_config_dffesr.inst_cus_mux161_buf.A8
+ sky130_fd_sc_hd__dlxtp_1
X_1558_ net783 net693 VGND VGND VPWR VPWR Inst_LA_LUT4c_frame_config_dffesr.inst_cus_mux161_buf.A15
+ sky130_fd_sc_hd__dlxtp_1
X_1489_ net627 Inst_SimpleCLB_switch_matrix.JW2BEG3 _0076_ net256 Inst_SimpleCLB_ConfigMem.Inst_frame14_bit27.Q
+ Inst_SimpleCLB_ConfigMem.Inst_frame14_bit26.Q VGND VGND VPWR VPWR Inst_SimpleCLB_switch_matrix.N1BEG0
+ sky130_fd_sc_hd__mux4_1
XFILLER_39_251 VGND VGND VPWR VPWR sky130_fd_sc_hd__decap_3
XFILLER_54_221 VGND VGND VPWR VPWR sky130_fd_sc_hd__decap_3
XFILLER_54_287 VGND VGND VPWR VPWR sky130_fd_sc_hd__decap_3
XFILLER_22_162 VGND VGND VPWR VPWR sky130_fd_sc_hd__decap_3
XFILLER_6_339 VGND VGND VPWR VPWR sky130_fd_sc_hd__fill_1
XFILLER_7_3 VGND VGND VPWR VPWR sky130_fd_sc_hd__decap_3
XFILLER_89_195 VGND VGND VPWR VPWR sky130_fd_sc_hd__decap_3
XFILLER_89_184 VGND VGND VPWR VPWR sky130_fd_sc_hd__fill_2
XFILLER_77_88 VGND VGND VPWR VPWR sky130_fd_sc_hd__decap_3
XANTENNA_231 net720 VGND VGND VPWR VPWR sky130_fd_sc_hd__diode_2
XFILLER_45_265 VGND VGND VPWR VPWR sky130_fd_sc_hd__fill_1
XANTENNA_220 N2END[6] VGND VGND VPWR VPWR sky130_fd_sc_hd__diode_2
X_0860_ N2MID[0] E2MID[0] S2MID[0] Inst_SimpleCLB_switch_matrix.JW2BEG3 Inst_SimpleCLB_ConfigMem.Inst_frame7_bit0.Q
+ Inst_SimpleCLB_ConfigMem.Inst_frame7_bit1.Q VGND VGND VPWR VPWR _0688_ sky130_fd_sc_hd__mux4_2
XFILLER_42_80 VGND VGND VPWR VPWR sky130_fd_sc_hd__decap_3
X_0791_ Inst_SimpleCLB_ConfigMem.Inst_frame4_bit8.Q _0624_ VGND VGND VPWR VPWR _0625_
+ sky130_fd_sc_hd__and2b_1
XFILLER_42_91 VGND VGND VPWR VPWR sky130_fd_sc_hd__decap_3
Xrebuffer3 _0033_ VGND VGND VPWR VPWR net257 sky130_fd_sc_hd__buf_6
X_1412_ net267 _0151_ _0241_ _0645_ Inst_SimpleCLB_ConfigMem.Inst_frame12_bit7.Q Inst_SimpleCLB_ConfigMem.Inst_frame12_bit8.Q
+ VGND VGND VPWR VPWR _0475_ sky130_fd_sc_hd__mux4_1
X_2392_ Inst_SimpleCLB_switch_matrix.W6BEG0 VGND VGND VPWR VPWR net228 sky130_fd_sc_hd__buf_1
X_1343_ net653 W1END[0] S1END[0] net637 Inst_SimpleCLB_ConfigMem.Inst_frame11_bit29.Q
+ Inst_SimpleCLB_ConfigMem.Inst_frame11_bit28.Q VGND VGND VPWR VPWR _0415_ sky130_fd_sc_hd__mux4_1
X_1274_ net621 net612 net631 net608 Inst_SimpleCLB_ConfigMem.Inst_frame3_bit27.Q Inst_SimpleCLB_ConfigMem.Inst_frame3_bit26.Q
+ VGND VGND VPWR VPWR _0354_ sky130_fd_sc_hd__mux4_1
X_0989_ _0086_ _0083_ _0015_ VGND VGND VPWR VPWR _0087_ sky130_fd_sc_hd__mux2_1
XFILLER_3_309 VGND VGND VPWR VPWR sky130_fd_sc_hd__decap_3
XFILLER_59_346 VGND VGND VPWR VPWR sky130_fd_sc_hd__fill_1
XFILLER_47_47 VGND VGND VPWR VPWR sky130_fd_sc_hd__fill_2
XFILLER_27_287 VGND VGND VPWR VPWR sky130_fd_sc_hd__decap_3
XFILLER_42_246 VGND VGND VPWR VPWR sky130_fd_sc_hd__decap_3
XTAP_TAPCELL_ROW_65_580 VGND VPWR sky130_fd_sc_hd__tapvpwrvgnd_1
XFILLER_42_279 VGND VGND VPWR VPWR sky130_fd_sc_hd__fill_2
XFILLER_6_125 VGND VGND VPWR VPWR sky130_fd_sc_hd__decap_3
XFILLER_12_50 VGND VGND VPWR VPWR sky130_fd_sc_hd__decap_3
XFILLER_10_187 VGND VGND VPWR VPWR sky130_fd_sc_hd__decap_3
XFILLER_6_147 VGND VGND VPWR VPWR sky130_fd_sc_hd__decap_3
XFILLER_12_94 VGND VGND VPWR VPWR sky130_fd_sc_hd__decap_3
Xfanout690 FrameStrobe[1] VGND VGND VPWR VPWR net690 sky130_fd_sc_hd__clkbuf_2
XFILLER_33_202 VGND VGND VPWR VPWR sky130_fd_sc_hd__fill_1
XFILLER_33_246 VGND VGND VPWR VPWR sky130_fd_sc_hd__decap_3
XFILLER_33_279 VGND VGND VPWR VPWR sky130_fd_sc_hd__fill_1
X_1961_ net743 net671 VGND VGND VPWR VPWR Inst_SimpleCLB_ConfigMem.Inst_frame5_bit4.Q
+ sky130_fd_sc_hd__dlxtp_1
X_1892_ net747 net659 VGND VGND VPWR VPWR Inst_SimpleCLB_ConfigMem.Inst_frame8_bit31.Q
+ sky130_fd_sc_hd__dlxtp_1
X_0912_ net622 net312 net632 net609 Inst_SimpleCLB_ConfigMem.Inst_frame2_bit3.Q Inst_SimpleCLB_ConfigMem.Inst_frame2_bit2.Q
+ VGND VGND VPWR VPWR _0016_ sky130_fd_sc_hd__mux4_2
X_0843_ W6END[0] net626 net640 net616 Inst_SimpleCLB_ConfigMem.Inst_frame2_bit31.Q
+ Inst_SimpleCLB_ConfigMem.Inst_frame2_bit30.Q VGND VGND VPWR VPWR _0673_ sky130_fd_sc_hd__mux4_1
X_0774_ N2MID[3] E2MID[3] S2MID[3] W2MID[3] Inst_SimpleCLB_ConfigMem.Inst_frame7_bit28.Q
+ Inst_SimpleCLB_ConfigMem.Inst_frame7_bit29.Q VGND VGND VPWR VPWR _0609_ sky130_fd_sc_hd__mux4_2
X_2375_ W2MID[1] VGND VGND VPWR VPWR net220 sky130_fd_sc_hd__buf_1
X_1326_ net624 net348 net633 net363 Inst_SimpleCLB_ConfigMem.Inst_frame10_bit3.Q Inst_SimpleCLB_ConfigMem.Inst_frame10_bit2.Q
+ VGND VGND VPWR VPWR _0400_ sky130_fd_sc_hd__mux4_1
XFILLER_83_146 VGND VGND VPWR VPWR sky130_fd_sc_hd__decap_3
X_1257_ W6END[1] net627 net636 net616 Inst_SimpleCLB_ConfigMem.Inst_frame2_bit27.Q
+ Inst_SimpleCLB_ConfigMem.Inst_frame2_bit26.Q VGND VGND VPWR VPWR _0339_ sky130_fd_sc_hd__mux4_1
X_1188_ N2MID[1] E2MID[1] S2MID[1] W2MID[1] Inst_SimpleCLB_ConfigMem.Inst_frame6_bit24.Q
+ Inst_SimpleCLB_ConfigMem.Inst_frame6_bit25.Q VGND VGND VPWR VPWR _0274_ sky130_fd_sc_hd__mux4_1
XTAP_TAPCELL_ROW_54_517 VGND VPWR sky130_fd_sc_hd__tapvpwrvgnd_1
XFILLER_71_319 VGND VGND VPWR VPWR sky130_fd_sc_hd__fill_2
XFILLER_24_268 VGND VGND VPWR VPWR sky130_fd_sc_hd__fill_2
XTAP_TAPCELL_ROW_62_561 VGND VPWR sky130_fd_sc_hd__tapvpwrvgnd_1
XFILLER_58_13 VGND VGND VPWR VPWR sky130_fd_sc_hd__fill_1
XFILLER_59_187 VGND VGND VPWR VPWR sky130_fd_sc_hd__decap_3
XFILLER_74_124 VGND VGND VPWR VPWR sky130_fd_sc_hd__fill_2
XFILLER_70_330 VGND VGND VPWR VPWR sky130_fd_sc_hd__decap_3
XFILLER_15_246 VGND VGND VPWR VPWR sky130_fd_sc_hd__fill_1
XFILLER_23_93 VGND VGND VPWR VPWR sky130_fd_sc_hd__decap_3
XFILLER_2_172 VGND VGND VPWR VPWR sky130_fd_sc_hd__decap_3
XFILLER_2_183 VGND VGND VPWR VPWR sky130_fd_sc_hd__fill_1
X_2160_ Inst_SimpleCLB_switch_matrix.E1BEG3 VGND VGND VPWR VPWR net5 sky130_fd_sc_hd__buf_1
X_2091_ net739 net687 VGND VGND VPWR VPWR Inst_SimpleCLB_ConfigMem.Inst_frame1_bit6.Q
+ sky130_fd_sc_hd__dlxtp_1
X_1111_ _0141_ _0154_ VGND VGND VPWR VPWR _0202_ sky130_fd_sc_hd__nand2_1
XFILLER_65_146 VGND VGND VPWR VPWR sky130_fd_sc_hd__decap_3
XFILLER_0_53 VGND VGND VPWR VPWR sky130_fd_sc_hd__decap_3
XFILLER_53_308 VGND VGND VPWR VPWR sky130_fd_sc_hd__decap_3
X_1042_ net651 N2END[6] E1END[2] E2END[6] Inst_SimpleCLB_ConfigMem.Inst_frame3_bit14.Q
+ Inst_SimpleCLB_ConfigMem.Inst_frame3_bit15.Q VGND VGND VPWR VPWR _0137_ sky130_fd_sc_hd__mux4_1
XFILLER_21_216 VGND VGND VPWR VPWR sky130_fd_sc_hd__decap_3
XTAP_TAPCELL_ROW_16_285 VGND VPWR sky130_fd_sc_hd__tapvpwrvgnd_1
XFILLER_21_238 VGND VGND VPWR VPWR sky130_fd_sc_hd__decap_3
X_1944_ net779 net668 VGND VGND VPWR VPWR Inst_SimpleCLB_ConfigMem.Inst_frame6_bit19.Q
+ sky130_fd_sc_hd__dlxtp_1
XFILLER_9_95 VGND VGND VPWR VPWR sky130_fd_sc_hd__decap_3
X_1875_ net788 net661 VGND VGND VPWR VPWR Inst_SimpleCLB_ConfigMem.Inst_frame8_bit14.Q
+ sky130_fd_sc_hd__dlxtp_1
X_0826_ N4END[1] net800 W6END[1] Inst_SimpleCLB_switch_matrix.JS2BEG1 Inst_SimpleCLB_ConfigMem.Inst_frame1_bit30.Q
+ Inst_SimpleCLB_ConfigMem.Inst_frame1_bit31.Q VGND VGND VPWR VPWR _0657_ sky130_fd_sc_hd__mux4_2
X_0757_ Inst_SimpleCLB_ConfigMem.Inst_frame4_bit29.Q VGND VGND VPWR VPWR _0593_ sky130_fd_sc_hd__inv_1
XFILLER_88_249 VGND VGND VPWR VPWR sky130_fd_sc_hd__decap_3
XFILLER_28_27 VGND VGND VPWR VPWR sky130_fd_sc_hd__fill_1
XFILLER_56_102 VGND VGND VPWR VPWR sky130_fd_sc_hd__decap_3
X_1309_ E2END[1] SS4END[1] net800 W2END[1] Inst_SimpleCLB_ConfigMem.Inst_frame5_bit27.Q
+ Inst_SimpleCLB_ConfigMem.Inst_frame5_bit26.Q VGND VGND VPWR VPWR _0385_ sky130_fd_sc_hd__mux4_1
X_2289_ Inst_SimpleCLB_switch_matrix.N4BEG0 VGND VGND VPWR VPWR net125 sky130_fd_sc_hd__clkbuf_2
XFILLER_8_209 VGND VGND VPWR VPWR sky130_fd_sc_hd__decap_3
XFILLER_20_271 VGND VGND VPWR VPWR sky130_fd_sc_hd__decap_3
XFILLER_60_47 VGND VGND VPWR VPWR sky130_fd_sc_hd__decap_3
XFILLER_69_12 VGND VGND VPWR VPWR sky130_fd_sc_hd__decap_3
XTAP_TAPCELL_ROW_7_231 VGND VPWR sky130_fd_sc_hd__tapvpwrvgnd_1
XFILLER_85_11 VGND VGND VPWR VPWR sky130_fd_sc_hd__fill_1
XFILLER_85_77 VGND VGND VPWR VPWR sky130_fd_sc_hd__fill_1
XFILLER_18_60 VGND VGND VPWR VPWR sky130_fd_sc_hd__fill_1
XFILLER_18_82 VGND VGND VPWR VPWR sky130_fd_sc_hd__fill_2
XFILLER_62_127 VGND VGND VPWR VPWR sky130_fd_sc_hd__decap_3
XFILLER_70_171 VGND VGND VPWR VPWR sky130_fd_sc_hd__decap_3
XFILLER_70_182 VGND VGND VPWR VPWR sky130_fd_sc_hd__decap_3
XTAP_TAPCELL_ROW_13_266 VGND VPWR sky130_fd_sc_hd__tapvpwrvgnd_1
XFILLER_11_293 VGND VGND VPWR VPWR sky130_fd_sc_hd__decap_3
XFILLER_7_231 VGND VGND VPWR VPWR sky130_fd_sc_hd__decap_3
X_1660_ net766 net706 VGND VGND VPWR VPWR Inst_LG_LUT4c_frame_config_dffesr.inst_cus_mux161_buf.A3
+ sky130_fd_sc_hd__dlxtp_1
X_1591_ net781 net694 VGND VGND VPWR VPWR Inst_LC_LUT4c_frame_config_dffesr.inst_cus_mux161_buf.A10
+ sky130_fd_sc_hd__dlxtp_1
XFILLER_50_91 VGND VGND VPWR VPWR sky130_fd_sc_hd__decap_3
XFILLER_85_208 VGND VGND VPWR VPWR sky130_fd_sc_hd__decap_3
X_2212_ net738 VGND VGND VPWR VPWR net79 sky130_fd_sc_hd__buf_1
X_2143_ net761 net731 VGND VGND VPWR VPWR Inst_SimpleCLB_ConfigMem.Inst_frame0_bit26.Q
+ sky130_fd_sc_hd__dlxtp_1
X_2074_ net770 net686 VGND VGND VPWR VPWR Inst_SimpleCLB_ConfigMem.Inst_frame2_bit21.Q
+ sky130_fd_sc_hd__dlxtp_1
X_1025_ _0120_ Inst_SimpleCLB_ConfigMem.Inst_frame4_bit16.Q Inst_SimpleCLB_ConfigMem.Inst_frame4_bit17.Q
+ VGND VGND VPWR VPWR _0121_ sky130_fd_sc_hd__a21boi_2
XFILLER_14_18 VGND VGND VPWR VPWR sky130_fd_sc_hd__fill_1
X_1927_ net751 net668 VGND VGND VPWR VPWR Inst_SimpleCLB_ConfigMem.Inst_frame6_bit2.Q
+ sky130_fd_sc_hd__dlxtp_1
XFILLER_30_17 VGND VGND VPWR VPWR sky130_fd_sc_hd__decap_3
X_1858_ net755 net657 VGND VGND VPWR VPWR Inst_SimpleCLB_ConfigMem.Inst_frame9_bit29.Q
+ sky130_fd_sc_hd__dlxtp_1
X_0809_ net650 N2END[2] N4END[2] E1END[0] Inst_SimpleCLB_ConfigMem.Inst_frame5_bit30.Q
+ Inst_SimpleCLB_ConfigMem.Inst_frame5_bit31.Q VGND VGND VPWR VPWR _0642_ sky130_fd_sc_hd__mux4_1
X_1789_ net765 net723 VGND VGND VPWR VPWR Inst_SimpleCLB_ConfigMem.Inst_frame11_bit24.Q
+ sky130_fd_sc_hd__dlxtp_1
XFILLER_39_37 VGND VGND VPWR VPWR sky130_fd_sc_hd__decap_3
XTAP_TAPCELL_ROW_87_715 VGND VPWR sky130_fd_sc_hd__tapvpwrvgnd_1
XTAP_TAPCELL_ROW_4_212 VGND VPWR sky130_fd_sc_hd__tapvpwrvgnd_1
XFILLER_29_102 VGND VGND VPWR VPWR sky130_fd_sc_hd__decap_3
XFILLER_76_219 VGND VGND VPWR VPWR sky130_fd_sc_hd__decap_3
XFILLER_84_230 VGND VGND VPWR VPWR sky130_fd_sc_hd__decap_3
XFILLER_29_113 VGND VGND VPWR VPWR sky130_fd_sc_hd__fill_1
XFILLER_29_124 VGND VGND VPWR VPWR sky130_fd_sc_hd__decap_3
XFILLER_44_116 VGND VGND VPWR VPWR sky130_fd_sc_hd__decap_3
XFILLER_55_69 VGND VGND VPWR VPWR sky130_fd_sc_hd__decap_3
XFILLER_71_57 VGND VGND VPWR VPWR sky130_fd_sc_hd__fill_1
XFILLER_4_256 VGND VGND VPWR VPWR sky130_fd_sc_hd__fill_1
XFILLER_20_72 VGND VGND VPWR VPWR sky130_fd_sc_hd__decap_3
XFILLER_75_252 VGND VGND VPWR VPWR sky130_fd_sc_hd__decap_3
XFILLER_90_200 VGND VGND VPWR VPWR sky130_fd_sc_hd__decap_3
XFILLER_31_333 VGND VGND VPWR VPWR sky130_fd_sc_hd__decap_3
XFILLER_31_344 VGND VGND VPWR VPWR sky130_fd_sc_hd__decap_3
X_1712_ net794 net712 VGND VGND VPWR VPWR Inst_SimpleCLB_ConfigMem.Inst_frame13_bit11.Q
+ sky130_fd_sc_hd__dlxtp_1
XFILLER_61_90 VGND VGND VPWR VPWR sky130_fd_sc_hd__fill_1
XANTENNA_1 E1END[0] VGND VGND VPWR VPWR sky130_fd_sc_hd__diode_2
X_1643_ net740 net704 VGND VGND VPWR VPWR Inst_LF_LUT4c_frame_config_dffesr.inst_cus_mux161_buf.A5
+ sky130_fd_sc_hd__dlxtp_1
XFILLER_6_63 VGND VGND VPWR VPWR sky130_fd_sc_hd__decap_3
X_1574_ net776 net697 VGND VGND VPWR VPWR Inst_LB_LUT4c_frame_config_dffesr.inst_cus_mux161_buf.A12
+ sky130_fd_sc_hd__dlxtp_1
X_2126_ net734 net732 VGND VGND VPWR VPWR Inst_SimpleCLB_ConfigMem.Inst_frame0_bit9.Q
+ sky130_fd_sc_hd__dlxtp_1
XTAP_TAPCELL_ROW_49_483 VGND VPWR sky130_fd_sc_hd__tapvpwrvgnd_1
XFILLER_66_296 VGND VGND VPWR VPWR sky130_fd_sc_hd__fill_2
Xrebuffer46 _0031_ VGND VGND VPWR VPWR net300 sky130_fd_sc_hd__clkbuf_1
XFILLER_81_255 VGND VGND VPWR VPWR sky130_fd_sc_hd__decap_3
Xrebuffer57 _0272_ VGND VGND VPWR VPWR net311 sky130_fd_sc_hd__clkbuf_2
X_2057_ net743 net684 VGND VGND VPWR VPWR Inst_SimpleCLB_ConfigMem.Inst_frame2_bit4.Q
+ sky130_fd_sc_hd__dlxtp_1
X_1008_ _0104_ _0013_ Inst_LB_LUT4c_frame_config_dffesr.c_I0mux VGND VGND VPWR VPWR
+ _0105_ sky130_fd_sc_hd__mux2_4
XTAP_TAPCELL_ROW_32_383 VGND VPWR sky130_fd_sc_hd__tapvpwrvgnd_1
XFILLER_57_230 VGND VGND VPWR VPWR sky130_fd_sc_hd__fill_2
XFILLER_82_23 VGND VGND VPWR VPWR sky130_fd_sc_hd__decap_3
XFILLER_13_344 VGND VGND VPWR VPWR sky130_fd_sc_hd__decap_3
XFILLER_40_130 VGND VGND VPWR VPWR sky130_fd_sc_hd__decap_3
XFILLER_40_141 VGND VGND VPWR VPWR sky130_fd_sc_hd__fill_2
XFILLER_31_60 VGND VGND VPWR VPWR sky130_fd_sc_hd__fill_1
Xoutput3 net3 VGND VGND VPWR VPWR E1BEG[1] sky130_fd_sc_hd__buf_4
Xoutput60 net60 VGND VGND VPWR VPWR FrameData_O[19] sky130_fd_sc_hd__buf_2
Xoutput93 net93 VGND VGND VPWR VPWR FrameStrobe_O[1] sky130_fd_sc_hd__buf_2
Xoutput82 net82 VGND VGND VPWR VPWR FrameStrobe_O[0] sky130_fd_sc_hd__buf_2
Xoutput71 net71 VGND VGND VPWR VPWR FrameData_O[29] sky130_fd_sc_hd__buf_2
X_1290_ Inst_SimpleCLB_ConfigMem.Inst_frame4_bit28.Q _0367_ VGND VGND VPWR VPWR _0368_
+ sky130_fd_sc_hd__or2_1
XFILLER_23_108 VGND VGND VPWR VPWR sky130_fd_sc_hd__decap_3
XTAP_TAPCELL_ROW_46_464 VGND VPWR sky130_fd_sc_hd__tapvpwrvgnd_1
XFILLER_63_277 VGND VGND VPWR VPWR sky130_fd_sc_hd__decap_3
XFILLER_16_193 VGND VGND VPWR VPWR sky130_fd_sc_hd__decap_3
XFILLER_16_171 VGND VGND VPWR VPWR sky130_fd_sc_hd__fill_1
XFILLER_31_196 VGND VGND VPWR VPWR sky130_fd_sc_hd__decap_3
X_1626_ net770 net699 VGND VGND VPWR VPWR Inst_LE_LUT4c_frame_config_dffesr.inst_cus_mux161_buf.A7
+ sky130_fd_sc_hd__dlxtp_1
X_1557_ net785 net693 VGND VGND VPWR VPWR Inst_LA_LUT4c_frame_config_dffesr.inst_cus_mux161_buf.A14
+ sky130_fd_sc_hd__dlxtp_1
X_1488_ net618 _0126_ Inst_SimpleCLB_switch_matrix.JW2BEG0 _0142_ Inst_SimpleCLB_ConfigMem.Inst_frame14_bit28.Q
+ Inst_SimpleCLB_ConfigMem.Inst_frame14_bit29.Q VGND VGND VPWR VPWR Inst_SimpleCLB_switch_matrix.N1BEG1
+ sky130_fd_sc_hd__mux4_1
XFILLER_54_200 VGND VGND VPWR VPWR sky130_fd_sc_hd__decap_3
X_2109_ net764 net688 VGND VGND VPWR VPWR Inst_SimpleCLB_ConfigMem.Inst_frame1_bit24.Q
+ sky130_fd_sc_hd__dlxtp_1
XFILLER_54_233 VGND VGND VPWR VPWR sky130_fd_sc_hd__decap_3
XFILLER_54_266 VGND VGND VPWR VPWR sky130_fd_sc_hd__decap_3
XFILLER_54_299 VGND VGND VPWR VPWR sky130_fd_sc_hd__decap_3
XFILLER_10_303 VGND VGND VPWR VPWR sky130_fd_sc_hd__decap_3
XFILLER_77_34 VGND VGND VPWR VPWR sky130_fd_sc_hd__decap_3
XFILLER_77_67 VGND VGND VPWR VPWR sky130_fd_sc_hd__decap_3
XANTENNA_210 net765 VGND VGND VPWR VPWR sky130_fd_sc_hd__diode_2
XANTENNA_232 net736 VGND VGND VPWR VPWR sky130_fd_sc_hd__diode_2
XFILLER_60_203 VGND VGND VPWR VPWR sky130_fd_sc_hd__decap_3
XANTENNA_221 N2END[6] VGND VGND VPWR VPWR sky130_fd_sc_hd__diode_2
XFILLER_60_236 VGND VGND VPWR VPWR sky130_fd_sc_hd__decap_3
XFILLER_13_141 VGND VGND VPWR VPWR sky130_fd_sc_hd__decap_3
XFILLER_60_269 VGND VGND VPWR VPWR sky130_fd_sc_hd__decap_3
X_0790_ net653 N2END[4] N4END[0] E1END[2] Inst_SimpleCLB_ConfigMem.Inst_frame4_bit6.Q
+ Inst_SimpleCLB_ConfigMem.Inst_frame4_bit7.Q VGND VGND VPWR VPWR _0624_ sky130_fd_sc_hd__mux4_1
Xrebuffer4 _0262_ VGND VGND VPWR VPWR net258 sky130_fd_sc_hd__buf_6
X_1411_ net652 E1END[1] S1END[1] net620 Inst_SimpleCLB_ConfigMem.Inst_frame12_bit7.Q
+ Inst_SimpleCLB_ConfigMem.Inst_frame12_bit8.Q VGND VGND VPWR VPWR _0474_ sky130_fd_sc_hd__mux4_1
X_2391_ W6END[11] VGND VGND VPWR VPWR net238 sky130_fd_sc_hd__clkbuf_2
X_1342_ Inst_SimpleCLB_ConfigMem.Inst_frame11_bit29.Q _0413_ _0411_ Inst_SimpleCLB_ConfigMem.Inst_frame11_bit30.Q
+ VGND VGND VPWR VPWR _0414_ sky130_fd_sc_hd__o211a_1
X_1273_ W6END[1] net626 net268 net616 Inst_SimpleCLB_ConfigMem.Inst_frame3_bit27.Q
+ Inst_SimpleCLB_ConfigMem.Inst_frame3_bit26.Q VGND VGND VPWR VPWR _0353_ sky130_fd_sc_hd__mux4_1
XFILLER_36_200 VGND VGND VPWR VPWR sky130_fd_sc_hd__decap_3
XFILLER_36_299 VGND VGND VPWR VPWR sky130_fd_sc_hd__decap_3
X_0988_ Inst_LC_LUT4c_frame_config_dffesr.inst_cus_mux161_buf.A7 _0057_ _0084_ _0085_
+ VGND VGND VPWR VPWR _0086_ sky130_fd_sc_hd__o211a_1
X_1609_ net743 net698 VGND VGND VPWR VPWR Inst_LD_LUT4c_frame_config_dffesr.inst_cus_mux161_buf.A9
+ sky130_fd_sc_hd__dlxtp_1
XFILLER_27_222 VGND VGND VPWR VPWR sky130_fd_sc_hd__fill_2
XFILLER_27_255 VGND VGND VPWR VPWR sky130_fd_sc_hd__decap_3
XTAP_TAPCELL_ROW_65_581 VGND VPWR sky130_fd_sc_hd__tapvpwrvgnd_1
XFILLER_10_133 VGND VGND VPWR VPWR sky130_fd_sc_hd__decap_3
XFILLER_10_122 VGND VGND VPWR VPWR sky130_fd_sc_hd__fill_2
XFILLER_10_166 VGND VGND VPWR VPWR sky130_fd_sc_hd__decap_3
XFILLER_10_144 VGND VGND VPWR VPWR sky130_fd_sc_hd__decap_3
XFILLER_6_159 VGND VGND VPWR VPWR sky130_fd_sc_hd__decap_3
XFILLER_6_137 VGND VGND VPWR VPWR sky130_fd_sc_hd__decap_3
XFILLER_77_133 VGND VGND VPWR VPWR sky130_fd_sc_hd__fill_1
Xfanout691 net692 VGND VGND VPWR VPWR net691 sky130_fd_sc_hd__clkbuf_2
Xfanout680 net682 VGND VGND VPWR VPWR net680 sky130_fd_sc_hd__buf_2
XFILLER_77_188 VGND VGND VPWR VPWR sky130_fd_sc_hd__decap_3
XFILLER_37_81 VGND VGND VPWR VPWR sky130_fd_sc_hd__decap_3
XFILLER_80_309 VGND VGND VPWR VPWR sky130_fd_sc_hd__fill_2
XFILLER_33_225 VGND VGND VPWR VPWR sky130_fd_sc_hd__decap_3
XFILLER_33_258 VGND VGND VPWR VPWR sky130_fd_sc_hd__decap_3
X_1960_ net745 net673 VGND VGND VPWR VPWR Inst_SimpleCLB_ConfigMem.Inst_frame5_bit3.Q
+ sky130_fd_sc_hd__dlxtp_1
X_1891_ net749 net659 VGND VGND VPWR VPWR Inst_SimpleCLB_ConfigMem.Inst_frame8_bit30.Q
+ sky130_fd_sc_hd__dlxtp_1
X_0911_ _0715_ _0726_ _0579_ _0014_ VGND VGND VPWR VPWR _0015_ sky130_fd_sc_hd__o22a_4
X_0842_ _0649_ _0671_ _0619_ VGND VGND VPWR VPWR _0672_ sky130_fd_sc_hd__mux2_1
X_0773_ E2MID[2] S2MID[2] W2MID[2] Inst_SimpleCLB_switch_matrix.E2BEG3 Inst_SimpleCLB_ConfigMem.Inst_frame8_bit28.Q
+ Inst_SimpleCLB_ConfigMem.Inst_frame8_bit29.Q VGND VGND VPWR VPWR _0608_ sky130_fd_sc_hd__mux4_2
XFILLER_52_3 VGND VGND VPWR VPWR sky130_fd_sc_hd__decap_3
XFILLER_5_181 VGND VGND VPWR VPWR sky130_fd_sc_hd__decap_3
X_2374_ W2MID[0] VGND VGND VPWR VPWR net219 sky130_fd_sc_hd__buf_1
XFILLER_68_111 VGND VGND VPWR VPWR sky130_fd_sc_hd__decap_3
XFILLER_68_144 VGND VGND VPWR VPWR sky130_fd_sc_hd__fill_1
X_1325_ Inst_SimpleCLB_ConfigMem.Inst_frame10_bit2.Q _0600_ _0398_ Inst_SimpleCLB_ConfigMem.Inst_frame10_bit3.Q
+ VGND VGND VPWR VPWR _0399_ sky130_fd_sc_hd__a211o_1
XFILLER_68_177 VGND VGND VPWR VPWR sky130_fd_sc_hd__decap_3
XTAP_TAPCELL_ROW_79_662 VGND VPWR sky130_fd_sc_hd__tapvpwrvgnd_1
X_1256_ _0334_ _0335_ _0338_ _0583_ VGND VGND VPWR VPWR Inst_SimpleCLB_switch_matrix.JW2BEG7
+ sky130_fd_sc_hd__a22o_1
XFILLER_83_169 VGND VGND VPWR VPWR sky130_fd_sc_hd__decap_3
XFILLER_83_158 VGND VGND VPWR VPWR sky130_fd_sc_hd__decap_3
X_1187_ net311 VGND VGND VPWR VPWR _0273_ sky130_fd_sc_hd__inv_2
XFILLER_24_214 VGND VGND VPWR VPWR sky130_fd_sc_hd__decap_3
XTAP_TAPCELL_ROW_62_562 VGND VPWR sky130_fd_sc_hd__tapvpwrvgnd_1
XFILLER_32_280 VGND VGND VPWR VPWR sky130_fd_sc_hd__decap_3
Xoutput250 net250 VGND VGND VPWR VPWR WW4BEG[5] sky130_fd_sc_hd__buf_2
XFILLER_47_317 VGND VGND VPWR VPWR sky130_fd_sc_hd__decap_3
XFILLER_59_166 VGND VGND VPWR VPWR sky130_fd_sc_hd__fill_2
XFILLER_74_103 VGND VGND VPWR VPWR sky130_fd_sc_hd__decap_3
XFILLER_59_199 VGND VGND VPWR VPWR sky130_fd_sc_hd__decap_3
XFILLER_74_147 VGND VGND VPWR VPWR sky130_fd_sc_hd__fill_1
XFILLER_74_35 VGND VGND VPWR VPWR sky130_fd_sc_hd__fill_1
XFILLER_74_57 VGND VGND VPWR VPWR sky130_fd_sc_hd__fill_1
XTAP_TAPCELL_ROW_85_698 VGND VPWR sky130_fd_sc_hd__tapvpwrvgnd_1
XFILLER_82_180 VGND VGND VPWR VPWR sky130_fd_sc_hd__fill_2
XFILLER_74_79 VGND VGND VPWR VPWR sky130_fd_sc_hd__decap_3
XFILLER_82_191 VGND VGND VPWR VPWR sky130_fd_sc_hd__decap_3
X_1110_ Inst_LE_LUT4c_frame_config_dffesr.c_I0mux _0200_ _0199_ VGND VGND VPWR VPWR
+ _0201_ sky130_fd_sc_hd__o21ai_2
X_2090_ net742 net690 VGND VGND VPWR VPWR Inst_SimpleCLB_ConfigMem.Inst_frame1_bit5.Q
+ sky130_fd_sc_hd__dlxtp_1
XFILLER_0_21 VGND VGND VPWR VPWR sky130_fd_sc_hd__decap_3
X_1041_ S1END[0] S1END[2] S2END[6] net647 Inst_SimpleCLB_ConfigMem.Inst_frame3_bit14.Q
+ Inst_SimpleCLB_ConfigMem.Inst_frame3_bit15.Q VGND VGND VPWR VPWR _0136_ sky130_fd_sc_hd__mux4_1
XFILLER_65_158 VGND VGND VPWR VPWR sky130_fd_sc_hd__decap_3
XFILLER_65_169 VGND VGND VPWR VPWR sky130_fd_sc_hd__decap_3
XFILLER_0_76 VGND VGND VPWR VPWR sky130_fd_sc_hd__decap_3
XFILLER_80_128 VGND VGND VPWR VPWR sky130_fd_sc_hd__decap_3
XFILLER_21_228 VGND VGND VPWR VPWR sky130_fd_sc_hd__decap_3
XTAP_TAPCELL_ROW_16_286 VGND VPWR sky130_fd_sc_hd__tapvpwrvgnd_1
X_1943_ net781 net668 VGND VGND VPWR VPWR Inst_SimpleCLB_ConfigMem.Inst_frame6_bit18.Q
+ sky130_fd_sc_hd__dlxtp_1
X_1874_ net790 net659 VGND VGND VPWR VPWR Inst_SimpleCLB_ConfigMem.Inst_frame8_bit13.Q
+ sky130_fd_sc_hd__dlxtp_1
X_0825_ _0653_ _0652_ _0656_ _0577_ VGND VGND VPWR VPWR Inst_SimpleCLB_switch_matrix.JS2BEG1
+ sky130_fd_sc_hd__a22o_1
X_0756_ Inst_SimpleCLB_ConfigMem.Inst_frame4_bit28.Q VGND VGND VPWR VPWR _0592_ sky130_fd_sc_hd__inv_1
Xclkbuf_0_UserCLK UserCLK VGND VGND VPWR VPWR clknet_0_UserCLK sky130_fd_sc_hd__clkbuf_16
X_2357_ Inst_SimpleCLB_switch_matrix.SS4BEG0 VGND VGND VPWR VPWR net193 sky130_fd_sc_hd__buf_1
X_2288_ N4END[15] VGND VGND VPWR VPWR net124 sky130_fd_sc_hd__clkbuf_1
X_1308_ _0596_ _0383_ Inst_SimpleCLB_ConfigMem.Inst_frame5_bit29.Q VGND VGND VPWR
+ VPWR _0384_ sky130_fd_sc_hd__o21a_1
XFILLER_56_114 VGND VGND VPWR VPWR sky130_fd_sc_hd__decap_3
X_1239_ Inst_LD_LUT4c_frame_config_dffesr.inst_cus_mux161_buf.A8 _0160_ _0161_ Inst_LD_LUT4c_frame_config_dffesr.inst_cus_mux161_buf.A14
+ VGND VGND VPWR VPWR _0323_ sky130_fd_sc_hd__o22a_1
XFILLER_12_206 VGND VGND VPWR VPWR sky130_fd_sc_hd__decap_3
XFILLER_20_283 VGND VGND VPWR VPWR sky130_fd_sc_hd__fill_1
XFILLER_69_57 VGND VGND VPWR VPWR sky130_fd_sc_hd__fill_1
XFILLER_79_206 VGND VGND VPWR VPWR sky130_fd_sc_hd__fill_2
XTAP_TAPCELL_ROW_7_232 VGND VPWR sky130_fd_sc_hd__tapvpwrvgnd_1
XPHY_EDGE_ROW_8_Left_99 VGND VGND VPWR VPWR sky130_fd_sc_hd__decap_3
XFILLER_85_23 VGND VGND VPWR VPWR sky130_fd_sc_hd__decap_3
XFILLER_47_169 VGND VGND VPWR VPWR sky130_fd_sc_hd__decap_3
XFILLER_18_94 VGND VGND VPWR VPWR sky130_fd_sc_hd__decap_3
XFILLER_62_139 VGND VGND VPWR VPWR sky130_fd_sc_hd__fill_1
XFILLER_34_71 VGND VGND VPWR VPWR sky130_fd_sc_hd__decap_3
XFILLER_86_9 VGND VGND VPWR VPWR sky130_fd_sc_hd__fill_1
XTAP_TAPCELL_ROW_13_267 VGND VPWR sky130_fd_sc_hd__tapvpwrvgnd_1
XFILLER_7_210 VGND VGND VPWR VPWR sky130_fd_sc_hd__decap_3
X_1590_ net783 net695 VGND VGND VPWR VPWR Inst_LC_LUT4c_frame_config_dffesr.inst_cus_mux161_buf.A9
+ sky130_fd_sc_hd__dlxtp_1
XFILLER_50_70 VGND VGND VPWR VPWR sky130_fd_sc_hd__fill_1
XFILLER_50_81 VGND VGND VPWR VPWR sky130_fd_sc_hd__decap_3
X_2211_ net740 VGND VGND VPWR VPWR net78 sky130_fd_sc_hd__buf_1
X_2142_ net762 net729 VGND VGND VPWR VPWR Inst_SimpleCLB_ConfigMem.Inst_frame0_bit25.Q
+ sky130_fd_sc_hd__dlxtp_1
XFILLER_38_125 VGND VGND VPWR VPWR sky130_fd_sc_hd__decap_3
X_2073_ net773 net686 VGND VGND VPWR VPWR Inst_SimpleCLB_ConfigMem.Inst_frame2_bit20.Q
+ sky130_fd_sc_hd__dlxtp_1
X_1024_ net619 net615 net624 net363 Inst_SimpleCLB_ConfigMem.Inst_frame4_bit15.Q Inst_SimpleCLB_ConfigMem.Inst_frame4_bit14.Q
+ VGND VGND VPWR VPWR _0120_ sky130_fd_sc_hd__mux4_1
XFILLER_61_161 VGND VGND VPWR VPWR sky130_fd_sc_hd__decap_3
X_1926_ net776 FrameStrobe[6] VGND VGND VPWR VPWR Inst_SimpleCLB_ConfigMem.Inst_frame6_bit1.Q
+ sky130_fd_sc_hd__dlxtp_1
X_1857_ net757 net657 VGND VGND VPWR VPWR Inst_SimpleCLB_ConfigMem.Inst_frame9_bit28.Q
+ sky130_fd_sc_hd__dlxtp_1
X_0808_ E2END[2] S2END[2] E6END[0] W2END[2] Inst_SimpleCLB_ConfigMem.Inst_frame5_bit31.Q
+ Inst_SimpleCLB_ConfigMem.Inst_frame5_bit30.Q VGND VGND VPWR VPWR _0641_ sky130_fd_sc_hd__mux4_1
X_1788_ net766 net723 VGND VGND VPWR VPWR Inst_SimpleCLB_ConfigMem.Inst_frame11_bit23.Q
+ sky130_fd_sc_hd__dlxtp_1
X_0739_ W2MID[4] VGND VGND VPWR VPWR _0575_ sky130_fd_sc_hd__inv_1
XTAP_TAPCELL_ROW_4_213 VGND VPWR sky130_fd_sc_hd__tapvpwrvgnd_1
XFILLER_39_49 VGND VGND VPWR VPWR sky130_fd_sc_hd__decap_3
X_2409_ Inst_SimpleCLB_switch_matrix.WW4BEG3 VGND VGND VPWR VPWR net245 sky130_fd_sc_hd__buf_6
XFILLER_76_209 VGND VGND VPWR VPWR sky130_fd_sc_hd__fill_2
XFILLER_29_136 VGND VGND VPWR VPWR sky130_fd_sc_hd__decap_3
XFILLER_69_272 VGND VGND VPWR VPWR sky130_fd_sc_hd__decap_3
XFILLER_29_169 VGND VGND VPWR VPWR sky130_fd_sc_hd__decap_3
XFILLER_44_106 VGND VGND VPWR VPWR sky130_fd_sc_hd__decap_3
XFILLER_44_128 VGND VGND VPWR VPWR sky130_fd_sc_hd__decap_3
XFILLER_55_37 VGND VGND VPWR VPWR sky130_fd_sc_hd__decap_3
XFILLER_52_172 VGND VGND VPWR VPWR sky130_fd_sc_hd__decap_3
XTAP_TAPCELL_ROW_10_248 VGND VPWR sky130_fd_sc_hd__tapvpwrvgnd_1
XFILLER_75_220 VGND VGND VPWR VPWR sky130_fd_sc_hd__decap_3
XFILLER_29_93 VGND VGND VPWR VPWR sky130_fd_sc_hd__decap_3
XFILLER_90_212 VGND VGND VPWR VPWR sky130_fd_sc_hd__decap_3
XFILLER_75_275 VGND VGND VPWR VPWR sky130_fd_sc_hd__fill_2
XFILLER_90_256 VGND VGND VPWR VPWR sky130_fd_sc_hd__decap_3
XFILLER_90_234 VGND VGND VPWR VPWR sky130_fd_sc_hd__decap_3
XFILLER_16_331 VGND VGND VPWR VPWR sky130_fd_sc_hd__decap_3
XFILLER_90_278 VGND VGND VPWR VPWR sky130_fd_sc_hd__fill_2
XFILLER_31_301 VGND VGND VPWR VPWR sky130_fd_sc_hd__fill_2
XFILLER_43_150 VGND VGND VPWR VPWR sky130_fd_sc_hd__fill_1
XFILLER_50_109 VGND VGND VPWR VPWR sky130_fd_sc_hd__decap_3
XFILLER_43_194 VGND VGND VPWR VPWR sky130_fd_sc_hd__decap_3
X_1711_ net796 net714 VGND VGND VPWR VPWR Inst_SimpleCLB_ConfigMem.Inst_frame13_bit10.Q
+ sky130_fd_sc_hd__dlxtp_1
XANTENNA_2 E1END[0] VGND VGND VPWR VPWR sky130_fd_sc_hd__diode_2
X_1642_ net742 net703 VGND VGND VPWR VPWR Inst_LF_LUT4c_frame_config_dffesr.inst_cus_mux161_buf.A4
+ sky130_fd_sc_hd__dlxtp_1
XFILLER_6_75 VGND VGND VPWR VPWR sky130_fd_sc_hd__decap_3
X_1573_ net798 net697 VGND VGND VPWR VPWR Inst_LB_LUT4c_frame_config_dffesr.inst_cus_mux161_buf.A11
+ sky130_fd_sc_hd__dlxtp_1
XFILLER_66_231 VGND VGND VPWR VPWR sky130_fd_sc_hd__decap_3
XFILLER_66_242 VGND VGND VPWR VPWR sky130_fd_sc_hd__decap_3
XFILLER_66_253 VGND VGND VPWR VPWR sky130_fd_sc_hd__fill_1
X_2125_ net735 net732 VGND VGND VPWR VPWR Inst_SimpleCLB_ConfigMem.Inst_frame0_bit8.Q
+ sky130_fd_sc_hd__dlxtp_1
XTAP_TAPCELL_ROW_49_484 VGND VPWR sky130_fd_sc_hd__tapvpwrvgnd_1
XFILLER_19_191 VGND VGND VPWR VPWR sky130_fd_sc_hd__decap_3
Xrebuffer47 net257 VGND VGND VPWR VPWR net301 sky130_fd_sc_hd__buf_6
X_2056_ net745 net684 VGND VGND VPWR VPWR Inst_SimpleCLB_ConfigMem.Inst_frame2_bit3.Q
+ sky130_fd_sc_hd__dlxtp_1
Xrebuffer58 Inst_LG_LUT4c_frame_config_dffesr.O VGND VGND VPWR VPWR net312 sky130_fd_sc_hd__clkbuf_2
X_1007_ _0102_ _0103_ Inst_SimpleCLB_ConfigMem.Inst_frame10_bit21.Q VGND VGND VPWR
+ VPWR _0104_ sky130_fd_sc_hd__mux2_1
XFILLER_34_194 VGND VGND VPWR VPWR sky130_fd_sc_hd__fill_2
XTAP_TAPCELL_ROW_32_384 VGND VPWR sky130_fd_sc_hd__tapvpwrvgnd_1
X_1909_ net785 net663 VGND VGND VPWR VPWR Inst_SimpleCLB_ConfigMem.Inst_frame7_bit16.Q
+ sky130_fd_sc_hd__dlxtp_1
XFILLER_57_253 VGND VGND VPWR VPWR sky130_fd_sc_hd__decap_3
XFILLER_72_223 VGND VGND VPWR VPWR sky130_fd_sc_hd__decap_3
XFILLER_72_234 VGND VGND VPWR VPWR sky130_fd_sc_hd__decap_3
XFILLER_25_172 VGND VGND VPWR VPWR sky130_fd_sc_hd__decap_3
XFILLER_40_164 VGND VGND VPWR VPWR sky130_fd_sc_hd__decap_3
XFILLER_40_197 VGND VGND VPWR VPWR sky130_fd_sc_hd__fill_1
Xoutput4 Inst_SimpleCLB_switch_matrix.E1BEG2 VGND VGND VPWR VPWR E1BEG[2] sky130_fd_sc_hd__buf_6
XFILLER_49_9 VGND VGND VPWR VPWR sky130_fd_sc_hd__decap_3
Xoutput50 net50 VGND VGND VPWR VPWR FrameData_O[0] sky130_fd_sc_hd__buf_2
Xoutput61 net61 VGND VGND VPWR VPWR FrameData_O[1] sky130_fd_sc_hd__buf_2
Xoutput83 net83 VGND VGND VPWR VPWR FrameStrobe_O[10] sky130_fd_sc_hd__buf_2
Xoutput94 net94 VGND VGND VPWR VPWR FrameStrobe_O[2] sky130_fd_sc_hd__buf_2
Xoutput72 net72 VGND VGND VPWR VPWR FrameData_O[2] sky130_fd_sc_hd__buf_2
XTAP_TAPCELL_ROW_46_465 VGND VPWR sky130_fd_sc_hd__tapvpwrvgnd_1
XFILLER_31_142 VGND VGND VPWR VPWR sky130_fd_sc_hd__decap_3
XFILLER_31_175 VGND VGND VPWR VPWR sky130_fd_sc_hd__decap_3
X_1625_ net773 net699 VGND VGND VPWR VPWR Inst_LE_LUT4c_frame_config_dffesr.inst_cus_mux161_buf.A6
+ sky130_fd_sc_hd__dlxtp_1
X_1556_ net787 net691 VGND VGND VPWR VPWR Inst_LA_LUT4c_frame_config_dffesr.inst_cus_mux161_buf.A13
+ sky130_fd_sc_hd__dlxtp_1
X_1487_ net621 Inst_SimpleCLB_switch_matrix.JW2BEG1 net645 net258 Inst_SimpleCLB_ConfigMem.Inst_frame14_bit31.Q
+ Inst_SimpleCLB_ConfigMem.Inst_frame14_bit30.Q VGND VGND VPWR VPWR Inst_SimpleCLB_switch_matrix.N1BEG2
+ sky130_fd_sc_hd__mux4_2
XFILLER_39_220 VGND VGND VPWR VPWR sky130_fd_sc_hd__decap_3
XFILLER_39_242 VGND VGND VPWR VPWR sky130_fd_sc_hd__decap_3
XFILLER_39_275 VGND VGND VPWR VPWR sky130_fd_sc_hd__fill_1
XFILLER_54_212 VGND VGND VPWR VPWR sky130_fd_sc_hd__decap_3
X_2108_ net767 net687 VGND VGND VPWR VPWR Inst_SimpleCLB_ConfigMem.Inst_frame1_bit23.Q
+ sky130_fd_sc_hd__dlxtp_1
XTAP_TAPCELL_ROW_37_410 VGND VPWR sky130_fd_sc_hd__tapvpwrvgnd_1
XFILLER_54_245 VGND VGND VPWR VPWR sky130_fd_sc_hd__decap_3
XFILLER_54_278 VGND VGND VPWR VPWR sky130_fd_sc_hd__decap_3
X_2039_ net781 net681 VGND VGND VPWR VPWR Inst_SimpleCLB_ConfigMem.Inst_frame3_bit18.Q
+ sky130_fd_sc_hd__dlxtp_1
XFILLER_10_315 VGND VGND VPWR VPWR sky130_fd_sc_hd__fill_2
XTAP_TAPCELL_ROW_20_310 VGND VPWR sky130_fd_sc_hd__tapvpwrvgnd_1
XFILLER_22_197 VGND VGND VPWR VPWR sky130_fd_sc_hd__decap_3
XFILLER_89_164 VGND VGND VPWR VPWR sky130_fd_sc_hd__decap_3
XFILLER_77_79 VGND VGND VPWR VPWR sky130_fd_sc_hd__decap_3
XFILLER_77_337 VGND VGND VPWR VPWR sky130_fd_sc_hd__fill_2
XANTENNA_200 net174 VGND VGND VPWR VPWR sky130_fd_sc_hd__diode_2
XFILLER_45_234 VGND VGND VPWR VPWR sky130_fd_sc_hd__decap_3
XANTENNA_222 W2END[7] VGND VGND VPWR VPWR sky130_fd_sc_hd__diode_2
XANTENNA_211 net765 VGND VGND VPWR VPWR sky130_fd_sc_hd__diode_2
XANTENNA_233 net736 VGND VGND VPWR VPWR sky130_fd_sc_hd__diode_2
XFILLER_45_278 VGND VGND VPWR VPWR sky130_fd_sc_hd__fill_2
XFILLER_60_215 VGND VGND VPWR VPWR sky130_fd_sc_hd__decap_3
XTAP_TAPCELL_ROW_43_446 VGND VPWR sky130_fd_sc_hd__tapvpwrvgnd_1
XFILLER_13_164 VGND VGND VPWR VPWR sky130_fd_sc_hd__decap_3
XFILLER_13_186 VGND VGND VPWR VPWR sky130_fd_sc_hd__decap_3
XFILLER_9_146 VGND VGND VPWR VPWR sky130_fd_sc_hd__fill_1
XFILLER_42_71 VGND VGND VPWR VPWR sky130_fd_sc_hd__decap_3
XPHY_EDGE_ROW_39_Left_130 VGND VGND VPWR VPWR sky130_fd_sc_hd__decap_3
X_1410_ _0467_ _0472_ _0473_ VGND VGND VPWR VPWR Inst_SimpleCLB_switch_matrix.E6BEG0
+ sky130_fd_sc_hd__o21ai_1
X_2390_ W6END[10] VGND VGND VPWR VPWR net237 sky130_fd_sc_hd__clkbuf_2
X_1341_ _0412_ VGND VGND VPWR VPWR _0413_ sky130_fd_sc_hd__inv_1
X_1272_ _0348_ _0349_ _0352_ _0587_ VGND VGND VPWR VPWR Inst_SimpleCLB_switch_matrix.JS2BEG7
+ sky130_fd_sc_hd__a22o_1
XFILLER_3_87 VGND VGND VPWR VPWR sky130_fd_sc_hd__fill_1
XFILLER_83_318 VGND VGND VPWR VPWR sky130_fd_sc_hd__decap_3
XFILLER_51_237 VGND VGND VPWR VPWR sky130_fd_sc_hd__fill_2
XFILLER_51_259 VGND VGND VPWR VPWR sky130_fd_sc_hd__decap_3
X_0987_ Inst_LC_LUT4c_frame_config_dffesr.inst_cus_mux161_buf.A5 _0053_ VGND VGND
+ VPWR VPWR _0085_ sky130_fd_sc_hd__or2_1
X_1608_ FrameData[3] net698 VGND VGND VPWR VPWR Inst_LD_LUT4c_frame_config_dffesr.inst_cus_mux161_buf.A8
+ sky130_fd_sc_hd__dlxtp_1
X_1539_ Inst_SimpleCLB_ConfigMem.Inst_frame8_bit15.Q _0530_ VGND VGND VPWR VPWR _0562_
+ sky130_fd_sc_hd__nand2_1
XFILLER_86_145 VGND VGND VPWR VPWR sky130_fd_sc_hd__fill_2
XFILLER_86_189 VGND VGND VPWR VPWR sky130_fd_sc_hd__decap_3
XFILLER_27_234 VGND VGND VPWR VPWR sky130_fd_sc_hd__decap_3
XFILLER_27_278 VGND VGND VPWR VPWR sky130_fd_sc_hd__fill_2
XFILLER_63_48 VGND VGND VPWR VPWR sky130_fd_sc_hd__decap_3
XTAP_TAPCELL_ROW_65_582 VGND VPWR sky130_fd_sc_hd__tapvpwrvgnd_1
XFILLER_10_156 VGND VGND VPWR VPWR sky130_fd_sc_hd__fill_1
XFILLER_10_178 VGND VGND VPWR VPWR sky130_fd_sc_hd__decap_3
XFILLER_12_85 VGND VGND VPWR VPWR sky130_fd_sc_hd__decap_3
Xfanout692 FrameStrobe[18] VGND VGND VPWR VPWR net692 sky130_fd_sc_hd__clkbuf_2
Xfanout670 FrameStrobe[6] VGND VGND VPWR VPWR net670 sky130_fd_sc_hd__clkbuf_2
Xfanout681 net682 VGND VGND VPWR VPWR net681 sky130_fd_sc_hd__buf_2
XFILLER_77_167 VGND VGND VPWR VPWR sky130_fd_sc_hd__fill_1
XFILLER_18_212 VGND VGND VPWR VPWR sky130_fd_sc_hd__fill_2
XFILLER_37_60 VGND VGND VPWR VPWR sky130_fd_sc_hd__decap_3
XPHY_EDGE_ROW_16_Right_16 VGND VGND VPWR VPWR sky130_fd_sc_hd__decap_3
X_0910_ _0010_ _0011_ _0012_ _0008_ VGND VGND VPWR VPWR _0014_ sky130_fd_sc_hd__a31o_4
X_1890_ net753 net659 VGND VGND VPWR VPWR Inst_SimpleCLB_ConfigMem.Inst_frame8_bit29.Q
+ sky130_fd_sc_hd__dlxtp_1
XFILLER_41_281 VGND VGND VPWR VPWR sky130_fd_sc_hd__fill_1
X_0841_ Inst_LA_LUT4c_frame_config_dffesr.inst_cus_mux161_buf.A6 Inst_LA_LUT4c_frame_config_dffesr.inst_cus_mux161_buf.A7
+ _0648_ VGND VGND VPWR VPWR _0671_ sky130_fd_sc_hd__mux2_1
X_0772_ _0604_ _0602_ _0607_ _0568_ VGND VGND VPWR VPWR Inst_SimpleCLB_switch_matrix.E2BEG3
+ sky130_fd_sc_hd__a22o_4
XPHY_EDGE_ROW_25_Right_25 VGND VGND VPWR VPWR sky130_fd_sc_hd__decap_3
XFILLER_5_193 VGND VGND VPWR VPWR sky130_fd_sc_hd__decap_3
X_2373_ Inst_SimpleCLB_switch_matrix.JW2BEG7 VGND VGND VPWR VPWR net218 sky130_fd_sc_hd__clkbuf_1
XFILLER_68_123 VGND VGND VPWR VPWR sky130_fd_sc_hd__decap_3
X_1324_ Inst_SimpleCLB_ConfigMem.Inst_frame10_bit2.Q net642 VGND VGND VPWR VPWR _0398_
+ sky130_fd_sc_hd__nor2_1
XFILLER_83_104 VGND VGND VPWR VPWR sky130_fd_sc_hd__decap_3
XTAP_TAPCELL_ROW_79_663 VGND VPWR sky130_fd_sc_hd__tapvpwrvgnd_1
X_1255_ _0336_ _0337_ Inst_SimpleCLB_ConfigMem.Inst_frame1_bit24.Q VGND VGND VPWR
+ VPWR _0338_ sky130_fd_sc_hd__mux2_1
XPHY_EDGE_ROW_34_Right_34 VGND VGND VPWR VPWR sky130_fd_sc_hd__decap_3
X_1186_ N2MID[0] E2MID[0] W2MID[0] Inst_SimpleCLB_switch_matrix.JW2BEG6 Inst_SimpleCLB_ConfigMem.Inst_frame7_bit24.Q
+ Inst_SimpleCLB_ConfigMem.Inst_frame7_bit25.Q VGND VGND VPWR VPWR _0272_ sky130_fd_sc_hd__mux4_2
XFILLER_24_248 VGND VGND VPWR VPWR sky130_fd_sc_hd__decap_3
XTAP_TAPCELL_ROW_62_563 VGND VPWR sky130_fd_sc_hd__tapvpwrvgnd_1
XPHY_EDGE_ROW_43_Right_43 VGND VGND VPWR VPWR sky130_fd_sc_hd__decap_3
Xoutput251 net251 VGND VGND VPWR VPWR WW4BEG[6] sky130_fd_sc_hd__buf_2
Xoutput240 net240 VGND VGND VPWR VPWR WW4BEG[10] sky130_fd_sc_hd__buf_2
XFILLER_47_307 VGND VGND VPWR VPWR sky130_fd_sc_hd__fill_2
XPHY_EDGE_ROW_52_Right_52 VGND VGND VPWR VPWR sky130_fd_sc_hd__decap_3
XFILLER_59_178 VGND VGND VPWR VPWR sky130_fd_sc_hd__decap_3
XFILLER_74_14 VGND VGND VPWR VPWR sky130_fd_sc_hd__decap_3
XFILLER_74_25 VGND VGND VPWR VPWR sky130_fd_sc_hd__decap_3
XTAP_TAPCELL_ROW_85_699 VGND VPWR sky130_fd_sc_hd__tapvpwrvgnd_1
XFILLER_90_46 VGND VGND VPWR VPWR sky130_fd_sc_hd__fill_1
XPHY_EDGE_ROW_61_Right_61 VGND VGND VPWR VPWR sky130_fd_sc_hd__decap_3
XFILLER_23_84 VGND VGND VPWR VPWR sky130_fd_sc_hd__decap_3
XPHY_EDGE_ROW_70_Right_70 VGND VGND VPWR VPWR sky130_fd_sc_hd__decap_3
XFILLER_65_137 VGND VGND VPWR VPWR sky130_fd_sc_hd__decap_3
XFILLER_0_44 VGND VGND VPWR VPWR sky130_fd_sc_hd__decap_3
X_1040_ Inst_SimpleCLB_ConfigMem.Inst_frame3_bit16.Q _0134_ Inst_SimpleCLB_ConfigMem.Inst_frame3_bit17.Q
+ VGND VGND VPWR VPWR _0135_ sky130_fd_sc_hd__a21bo_1
XTAP_TAPCELL_ROW_76_644 VGND VPWR sky130_fd_sc_hd__tapvpwrvgnd_1
XFILLER_0_88 VGND VGND VPWR VPWR sky130_fd_sc_hd__decap_3
XTAP_TAPCELL_ROW_16_287 VGND VPWR sky130_fd_sc_hd__tapvpwrvgnd_1
X_1942_ net783 net667 VGND VGND VPWR VPWR Inst_SimpleCLB_ConfigMem.Inst_frame6_bit17.Q
+ sky130_fd_sc_hd__dlxtp_1
XFILLER_9_42 VGND VGND VPWR VPWR sky130_fd_sc_hd__fill_2
X_1873_ net793 net659 VGND VGND VPWR VPWR Inst_SimpleCLB_ConfigMem.Inst_frame8_bit12.Q
+ sky130_fd_sc_hd__dlxtp_1
X_0824_ _0654_ _0655_ _0576_ VGND VGND VPWR VPWR _0656_ sky130_fd_sc_hd__mux2_1
X_0755_ Inst_SimpleCLB_ConfigMem.Inst_frame3_bit25.Q VGND VGND VPWR VPWR _0591_ sky130_fd_sc_hd__inv_1
XFILLER_88_229 VGND VGND VPWR VPWR sky130_fd_sc_hd__decap_3
X_2356_ SS4END[15] VGND VGND VPWR VPWR net192 sky130_fd_sc_hd__clkbuf_2
X_2287_ N4END[14] VGND VGND VPWR VPWR net123 sky130_fd_sc_hd__clkbuf_1
X_1307_ net622 net613 net631 net608 Inst_SimpleCLB_ConfigMem.Inst_frame5_bit27.Q Inst_SimpleCLB_ConfigMem.Inst_frame5_bit26.Q
+ VGND VGND VPWR VPWR _0383_ sky130_fd_sc_hd__mux4_1
XFILLER_56_126 VGND VGND VPWR VPWR sky130_fd_sc_hd__fill_1
X_1238_ Inst_LD_LUT4c_frame_config_dffesr.inst_cus_mux161_buf.A12 _0158_ _0159_ VGND
+ VGND VPWR VPWR _0322_ sky130_fd_sc_hd__or3b_1
X_1169_ N2MID[3] E2MID[3] S2MID[3] W2MID[3] Inst_SimpleCLB_ConfigMem.Inst_frame6_bit20.Q
+ Inst_SimpleCLB_ConfigMem.Inst_frame6_bit21.Q VGND VGND VPWR VPWR _0256_ sky130_fd_sc_hd__mux4_2
XFILLER_12_218 VGND VGND VPWR VPWR sky130_fd_sc_hd__decap_3
XFILLER_20_251 VGND VGND VPWR VPWR sky130_fd_sc_hd__fill_1
XFILLER_60_27 VGND VGND VPWR VPWR sky130_fd_sc_hd__fill_1
XFILLER_20_262 VGND VGND VPWR VPWR sky130_fd_sc_hd__decap_3
XTAP_TAPCELL_ROW_7_233 VGND VPWR sky130_fd_sc_hd__tapvpwrvgnd_1
XFILLER_85_57 VGND VGND VPWR VPWR sky130_fd_sc_hd__fill_2
XFILLER_85_46 VGND VGND VPWR VPWR sky130_fd_sc_hd__decap_3
XFILLER_47_159 VGND VGND VPWR VPWR sky130_fd_sc_hd__decap_3
XFILLER_62_107 VGND VGND VPWR VPWR sky130_fd_sc_hd__fill_2
XFILLER_70_162 VGND VGND VPWR VPWR sky130_fd_sc_hd__decap_3
XFILLER_34_50 VGND VGND VPWR VPWR sky130_fd_sc_hd__decap_3
XFILLER_34_83 VGND VGND VPWR VPWR sky130_fd_sc_hd__fill_1
XTAP_TAPCELL_ROW_13_268 VGND VPWR sky130_fd_sc_hd__tapvpwrvgnd_1
XFILLER_11_284 VGND VGND VPWR VPWR sky130_fd_sc_hd__decap_3
XFILLER_11_273 VGND VGND VPWR VPWR sky130_fd_sc_hd__decap_3
XFILLER_11_262 VGND VGND VPWR VPWR sky130_fd_sc_hd__decap_3
XFILLER_7_222 VGND VGND VPWR VPWR sky130_fd_sc_hd__fill_2
X_2210_ net742 VGND VGND VPWR VPWR net77 sky130_fd_sc_hd__clkbuf_1
X_2141_ net764 net729 VGND VGND VPWR VPWR Inst_SimpleCLB_ConfigMem.Inst_frame0_bit24.Q
+ sky130_fd_sc_hd__dlxtp_1
XFILLER_38_137 VGND VGND VPWR VPWR sky130_fd_sc_hd__decap_3
X_2072_ net778 net685 VGND VGND VPWR VPWR Inst_SimpleCLB_ConfigMem.Inst_frame2_bit19.Q
+ sky130_fd_sc_hd__dlxtp_1
XFILLER_19_340 VGND VGND VPWR VPWR sky130_fd_sc_hd__decap_3
X_1023_ Inst_SimpleCLB_ConfigMem.Inst_frame4_bit16.Q _0118_ VGND VGND VPWR VPWR _0119_
+ sky130_fd_sc_hd__nand2b_1
XFILLER_34_321 VGND VGND VPWR VPWR sky130_fd_sc_hd__decap_3
X_1925_ net798 FrameStrobe[6] VGND VGND VPWR VPWR Inst_SimpleCLB_ConfigMem.Inst_frame6_bit0.Q
+ sky130_fd_sc_hd__dlxtp_1
X_1856_ net759 net658 VGND VGND VPWR VPWR Inst_SimpleCLB_ConfigMem.Inst_frame9_bit27.Q
+ sky130_fd_sc_hd__dlxtp_1
X_0807_ Inst_SimpleCLB_ConfigMem.Inst_frame4_bit0.Q _0637_ _0639_ Inst_SimpleCLB_ConfigMem.Inst_frame4_bit1.Q
+ VGND VGND VPWR VPWR _0640_ sky130_fd_sc_hd__o211a_1
X_1787_ net768 net723 VGND VGND VPWR VPWR Inst_SimpleCLB_ConfigMem.Inst_frame11_bit22.Q
+ sky130_fd_sc_hd__dlxtp_1
X_0738_ Inst_SimpleCLB_ConfigMem.Inst_frame2_bit9.Q VGND VGND VPWR VPWR _0574_ sky130_fd_sc_hd__inv_1
XTAP_TAPCELL_ROW_4_214 VGND VPWR sky130_fd_sc_hd__tapvpwrvgnd_1
X_2408_ Inst_SimpleCLB_switch_matrix.WW4BEG2 VGND VGND VPWR VPWR net244 sky130_fd_sc_hd__clkbuf_1
XFILLER_69_262 VGND VGND VPWR VPWR sky130_fd_sc_hd__fill_1
X_2339_ S4END[14] VGND VGND VPWR VPWR net175 sky130_fd_sc_hd__buf_4
XFILLER_84_221 VGND VGND VPWR VPWR sky130_fd_sc_hd__decap_3
XPHY_EDGE_ROW_2_Right_2 VGND VGND VPWR VPWR sky130_fd_sc_hd__decap_3
XFILLER_25_321 VGND VGND VPWR VPWR sky130_fd_sc_hd__decap_3
XFILLER_37_181 VGND VGND VPWR VPWR sky130_fd_sc_hd__decap_3
XFILLER_40_313 VGND VGND VPWR VPWR sky130_fd_sc_hd__fill_1
XTAP_TAPCELL_ROW_10_249 VGND VPWR sky130_fd_sc_hd__tapvpwrvgnd_1
XFILLER_4_203 VGND VGND VPWR VPWR sky130_fd_sc_hd__decap_3
XFILLER_4_247 VGND VGND VPWR VPWR sky130_fd_sc_hd__decap_3
XFILLER_20_85 VGND VGND VPWR VPWR sky130_fd_sc_hd__fill_1
XFILLER_4_269 VGND VGND VPWR VPWR sky130_fd_sc_hd__fill_1
XFILLER_29_50 VGND VGND VPWR VPWR sky130_fd_sc_hd__decap_3
XFILLER_75_243 VGND VGND VPWR VPWR sky130_fd_sc_hd__decap_3
XPHY_EDGE_ROW_11_Left_102 VGND VGND VPWR VPWR sky130_fd_sc_hd__decap_3
XFILLER_90_246 VGND VGND VPWR VPWR sky130_fd_sc_hd__decap_3
XFILLER_28_192 VGND VGND VPWR VPWR sky130_fd_sc_hd__decap_3
XFILLER_16_343 VGND VGND VPWR VPWR sky130_fd_sc_hd__decap_3
XFILLER_45_71 VGND VGND VPWR VPWR sky130_fd_sc_hd__decap_3
XPHY_EDGE_ROW_20_Left_111 VGND VGND VPWR VPWR sky130_fd_sc_hd__decap_3
X_1710_ net733 net711 VGND VGND VPWR VPWR Inst_SimpleCLB_ConfigMem.Inst_frame13_bit9.Q
+ sky130_fd_sc_hd__dlxtp_1
XFILLER_61_81 VGND VGND VPWR VPWR sky130_fd_sc_hd__decap_3
XFILLER_6_32 VGND VGND VPWR VPWR sky130_fd_sc_hd__decap_3
XFILLER_6_21 VGND VGND VPWR VPWR sky130_fd_sc_hd__decap_3
XANTENNA_3 E1END[0] VGND VGND VPWR VPWR sky130_fd_sc_hd__diode_2
X_1641_ net744 net704 VGND VGND VPWR VPWR Inst_LF_LUT4c_frame_config_dffesr.inst_cus_mux161_buf.A3
+ sky130_fd_sc_hd__dlxtp_1
X_1572_ net747 net691 VGND VGND VPWR VPWR Inst_LB_LUT4c_frame_config_dffesr.inst_cus_mux161_buf.A10
+ sky130_fd_sc_hd__dlxtp_1
X_2124_ net737 net729 VGND VGND VPWR VPWR Inst_SimpleCLB_ConfigMem.Inst_frame0_bit7.Q
+ sky130_fd_sc_hd__dlxtp_1
XFILLER_81_202 VGND VGND VPWR VPWR sky130_fd_sc_hd__decap_3
Xrebuffer59 _0299_ VGND VGND VPWR VPWR net313 sky130_fd_sc_hd__clkbuf_2
XFILLER_81_246 VGND VGND VPWR VPWR sky130_fd_sc_hd__decap_3
X_2055_ net751 net684 VGND VGND VPWR VPWR Inst_SimpleCLB_ConfigMem.Inst_frame2_bit2.Q
+ sky130_fd_sc_hd__dlxtp_1
XTAP_TAPCELL_ROW_49_485 VGND VPWR sky130_fd_sc_hd__tapvpwrvgnd_1
XFILLER_81_279 VGND VGND VPWR VPWR sky130_fd_sc_hd__fill_1
X_1006_ _0645_ _0644_ Inst_SimpleCLB_ConfigMem.Inst_frame10_bit20.Q VGND VGND VPWR
+ VPWR _0103_ sky130_fd_sc_hd__mux2_1
XTAP_TAPCELL_ROW_32_385 VGND VPWR sky130_fd_sc_hd__tapvpwrvgnd_1
X_1908_ net786 net665 VGND VGND VPWR VPWR Inst_SimpleCLB_ConfigMem.Inst_frame7_bit15.Q
+ sky130_fd_sc_hd__dlxtp_1
X_1839_ net797 net656 VGND VGND VPWR VPWR Inst_SimpleCLB_ConfigMem.Inst_frame9_bit10.Q
+ sky130_fd_sc_hd__dlxtp_1
XFILLER_89_346 VGND VGND VPWR VPWR sky130_fd_sc_hd__fill_1
XFILLER_66_26 VGND VGND VPWR VPWR sky130_fd_sc_hd__fill_2
XFILLER_57_276 VGND VGND VPWR VPWR sky130_fd_sc_hd__decap_3
XFILLER_82_14 VGND VGND VPWR VPWR sky130_fd_sc_hd__fill_1
XFILLER_13_313 VGND VGND VPWR VPWR sky130_fd_sc_hd__fill_2
XTAP_TAPCELL_ROW_23_330 VGND VPWR sky130_fd_sc_hd__tapvpwrvgnd_1
XFILLER_40_121 VGND VGND VPWR VPWR sky130_fd_sc_hd__decap_3
XFILLER_40_176 VGND VGND VPWR VPWR sky130_fd_sc_hd__decap_3
XFILLER_31_51 VGND VGND VPWR VPWR sky130_fd_sc_hd__decap_3
XFILLER_31_95 VGND VGND VPWR VPWR sky130_fd_sc_hd__decap_3
Xoutput5 net5 VGND VGND VPWR VPWR E1BEG[3] sky130_fd_sc_hd__buf_4
Xoutput40 net40 VGND VGND VPWR VPWR EE4BEG[15] sky130_fd_sc_hd__clkbuf_4
Xoutput51 net51 VGND VGND VPWR VPWR FrameData_O[10] sky130_fd_sc_hd__buf_2
Xoutput84 net84 VGND VGND VPWR VPWR FrameStrobe_O[11] sky130_fd_sc_hd__buf_2
Xoutput73 net73 VGND VGND VPWR VPWR FrameData_O[30] sky130_fd_sc_hd__buf_2
Xoutput62 net62 VGND VGND VPWR VPWR FrameData_O[20] sky130_fd_sc_hd__buf_2
Xoutput95 net95 VGND VGND VPWR VPWR FrameStrobe_O[3] sky130_fd_sc_hd__buf_2
XFILLER_48_265 VGND VGND VPWR VPWR sky130_fd_sc_hd__decap_3
XFILLER_63_202 VGND VGND VPWR VPWR sky130_fd_sc_hd__decap_3
XTAP_TAPCELL_ROW_46_466 VGND VPWR sky130_fd_sc_hd__tapvpwrvgnd_1
XFILLER_16_184 VGND VGND VPWR VPWR sky130_fd_sc_hd__decap_3
XFILLER_31_187 VGND VGND VPWR VPWR sky130_fd_sc_hd__decap_3
XFILLER_75_3 VGND VGND VPWR VPWR sky130_fd_sc_hd__fill_1
X_1624_ net778 net700 VGND VGND VPWR VPWR Inst_LE_LUT4c_frame_config_dffesr.inst_cus_mux161_buf.A5
+ sky130_fd_sc_hd__dlxtp_1
X_1555_ net789 net691 VGND VGND VPWR VPWR Inst_LA_LUT4c_frame_config_dffesr.inst_cus_mux161_buf.A12
+ sky130_fd_sc_hd__dlxtp_1
XFILLER_86_327 VGND VGND VPWR VPWR sky130_fd_sc_hd__fill_2
X_1486_ net635 _0669_ Inst_SimpleCLB_switch_matrix.JW2BEG2 _0644_ Inst_SimpleCLB_ConfigMem.Inst_frame13_bit0.Q
+ Inst_SimpleCLB_ConfigMem.Inst_frame13_bit1.Q VGND VGND VPWR VPWR Inst_SimpleCLB_switch_matrix.N1BEG3
+ sky130_fd_sc_hd__mux4_1
XFILLER_39_254 VGND VGND VPWR VPWR sky130_fd_sc_hd__decap_3
X_2107_ net769 net687 VGND VGND VPWR VPWR Inst_SimpleCLB_ConfigMem.Inst_frame1_bit22.Q
+ sky130_fd_sc_hd__dlxtp_1
XFILLER_36_29 VGND VGND VPWR VPWR sky130_fd_sc_hd__fill_2
XTAP_TAPCELL_ROW_37_411 VGND VPWR sky130_fd_sc_hd__tapvpwrvgnd_1
X_2038_ net782 net681 VGND VGND VPWR VPWR Inst_SimpleCLB_ConfigMem.Inst_frame3_bit17.Q
+ sky130_fd_sc_hd__dlxtp_1
XFILLER_22_132 VGND VGND VPWR VPWR sky130_fd_sc_hd__decap_3
XFILLER_22_165 VGND VGND VPWR VPWR sky130_fd_sc_hd__decap_3
XTAP_TAPCELL_ROW_20_311 VGND VPWR sky130_fd_sc_hd__tapvpwrvgnd_1
XFILLER_10_338 VGND VGND VPWR VPWR sky130_fd_sc_hd__fill_2
XFILLER_6_309 VGND VGND VPWR VPWR sky130_fd_sc_hd__decap_3
XFILLER_7_6 VGND VGND VPWR VPWR sky130_fd_sc_hd__decap_3
XFILLER_89_198 VGND VGND VPWR VPWR sky130_fd_sc_hd__decap_3
XANTENNA_212 net791 VGND VGND VPWR VPWR sky130_fd_sc_hd__diode_2
XANTENNA_223 _0142_ VGND VGND VPWR VPWR sky130_fd_sc_hd__diode_2
XANTENNA_234 net736 VGND VGND VPWR VPWR sky130_fd_sc_hd__diode_2
XANTENNA_201 SS4END[2] VGND VGND VPWR VPWR sky130_fd_sc_hd__diode_2
XTAP_TAPCELL_ROW_43_447 VGND VPWR sky130_fd_sc_hd__tapvpwrvgnd_1
XFILLER_53_290 VGND VGND VPWR VPWR sky130_fd_sc_hd__decap_3
XFILLER_42_83 VGND VGND VPWR VPWR sky130_fd_sc_hd__fill_1
XFILLER_42_94 VGND VGND VPWR VPWR sky130_fd_sc_hd__decap_3
Xrebuffer6 _0051_ VGND VGND VPWR VPWR net260 sky130_fd_sc_hd__buf_2
X_1340_ net627 _0140_ Inst_SimpleCLB_ConfigMem.Inst_frame11_bit28.Q VGND VGND VPWR
+ VPWR _0412_ sky130_fd_sc_hd__mux2_1
X_1271_ _0350_ _0351_ Inst_SimpleCLB_ConfigMem.Inst_frame2_bit24.Q VGND VGND VPWR
+ VPWR _0352_ sky130_fd_sc_hd__mux2_1
XFILLER_67_80 VGND VGND VPWR VPWR sky130_fd_sc_hd__decap_3
X_0986_ Inst_LC_LUT4c_frame_config_dffesr.inst_cus_mux161_buf.A3 _0054_ _0056_ Inst_LC_LUT4c_frame_config_dffesr.inst_cus_mux161_buf.A1
+ VGND VGND VPWR VPWR _0084_ sky130_fd_sc_hd__o22a_1
X_1607_ net752 net702 VGND VGND VPWR VPWR Inst_LD_LUT4c_frame_config_dffesr.inst_cus_mux161_buf.A7
+ sky130_fd_sc_hd__dlxtp_1
X_1538_ net396 _0561_ _0559_ VGND VGND VPWR VPWR _0006_ sky130_fd_sc_hd__mux2_1
X_1469_ net631 Inst_SimpleCLB_switch_matrix.JS2BEG3 _0076_ net256 Inst_SimpleCLB_ConfigMem.Inst_frame11_bit15.Q
+ Inst_SimpleCLB_ConfigMem.Inst_frame11_bit14.Q VGND VGND VPWR VPWR Inst_SimpleCLB_switch_matrix.W1BEG0
+ sky130_fd_sc_hd__mux4_1
XTAP_TAPCELL_ROW_65_583 VGND VPWR sky130_fd_sc_hd__tapvpwrvgnd_1
XFILLER_42_249 VGND VGND VPWR VPWR sky130_fd_sc_hd__decap_3
XTAP_TAPCELL_ROW_40_428 VGND VPWR sky130_fd_sc_hd__tapvpwrvgnd_1
XFILLER_12_53 VGND VGND VPWR VPWR sky130_fd_sc_hd__decap_3
XFILLER_6_128 VGND VGND VPWR VPWR sky130_fd_sc_hd__decap_3
XFILLER_12_97 VGND VGND VPWR VPWR sky130_fd_sc_hd__decap_3
XFILLER_5_3 VGND VGND VPWR VPWR sky130_fd_sc_hd__decap_3
Xfanout660 net661 VGND VGND VPWR VPWR net660 sky130_fd_sc_hd__clkbuf_2
Xfanout693 FrameStrobe[18] VGND VGND VPWR VPWR net693 sky130_fd_sc_hd__clkbuf_2
Xfanout671 net672 VGND VGND VPWR VPWR net671 sky130_fd_sc_hd__buf_2
Xfanout682 FrameStrobe[3] VGND VGND VPWR VPWR net682 sky130_fd_sc_hd__clkbuf_2
XFILLER_37_72 VGND VGND VPWR VPWR sky130_fd_sc_hd__decap_3
XFILLER_73_341 VGND VGND VPWR VPWR sky130_fd_sc_hd__fill_1
XFILLER_33_216 VGND VGND VPWR VPWR sky130_fd_sc_hd__decap_3
XFILLER_33_249 VGND VGND VPWR VPWR sky130_fd_sc_hd__decap_3
X_0840_ _0667_ _0669_ _0658_ _0657_ Inst_SimpleCLB_ConfigMem.Inst_frame10_bit14.Q
+ Inst_SimpleCLB_ConfigMem.Inst_frame10_bit15.Q VGND VGND VPWR VPWR _0670_ sky130_fd_sc_hd__mux4_2
X_0771_ _0605_ _0606_ Inst_SimpleCLB_ConfigMem.Inst_frame3_bit8.Q VGND VGND VPWR VPWR
+ _0607_ sky130_fd_sc_hd__mux2_1
XFILLER_5_172 VGND VGND VPWR VPWR sky130_fd_sc_hd__decap_3
XFILLER_5_150 VGND VGND VPWR VPWR sky130_fd_sc_hd__decap_3
X_2372_ Inst_SimpleCLB_switch_matrix.JW2BEG6 VGND VGND VPWR VPWR net217 sky130_fd_sc_hd__buf_1
X_1323_ Inst_SimpleCLB_ConfigMem.Inst_frame10_bit3.Q _0396_ VGND VGND VPWR VPWR _0397_
+ sky130_fd_sc_hd__nand2_1
X_1254_ S1END[0] S1END[2] S2END[0] W1END[0] Inst_SimpleCLB_ConfigMem.Inst_frame1_bit22.Q
+ Inst_SimpleCLB_ConfigMem.Inst_frame1_bit23.Q VGND VGND VPWR VPWR _0337_ sky130_fd_sc_hd__mux4_1
XTAP_TAPCELL_ROW_79_664 VGND VPWR sky130_fd_sc_hd__tapvpwrvgnd_1
XFILLER_83_149 VGND VGND VPWR VPWR sky130_fd_sc_hd__decap_3
X_1185_ _0271_ _0268_ Inst_SimpleCLB_ConfigMem.Inst_frame1_bit21.Q VGND VGND VPWR
+ VPWR Inst_SimpleCLB_switch_matrix.JW2BEG6 sky130_fd_sc_hd__mux2_4
XTAP_TAPCELL_ROW_62_564 VGND VPWR sky130_fd_sc_hd__tapvpwrvgnd_1
XFILLER_32_271 VGND VGND VPWR VPWR sky130_fd_sc_hd__decap_3
X_0969_ N2END[0] S2END[0] EE4END[1] W2END[0] Inst_SimpleCLB_ConfigMem.Inst_frame5_bit9.Q
+ Inst_SimpleCLB_ConfigMem.Inst_frame5_bit8.Q VGND VGND VPWR VPWR _0068_ sky130_fd_sc_hd__mux4_2
XFILLER_3_109 VGND VGND VPWR VPWR sky130_fd_sc_hd__decap_3
Xoutput252 net252 VGND VGND VPWR VPWR WW4BEG[7] sky130_fd_sc_hd__buf_2
Xoutput241 net241 VGND VGND VPWR VPWR WW4BEG[11] sky130_fd_sc_hd__buf_2
Xoutput230 net230 VGND VGND VPWR VPWR W6BEG[1] sky130_fd_sc_hd__buf_2
XPHY_EDGE_ROW_58_Left_149 VGND VGND VPWR VPWR sky130_fd_sc_hd__decap_3
XFILLER_59_113 VGND VGND VPWR VPWR sky130_fd_sc_hd__fill_2
XFILLER_74_138 VGND VGND VPWR VPWR sky130_fd_sc_hd__fill_2
XFILLER_74_48 VGND VGND VPWR VPWR sky130_fd_sc_hd__decap_3
XFILLER_70_333 VGND VGND VPWR VPWR sky130_fd_sc_hd__decap_3
XPHY_EDGE_ROW_67_Left_158 VGND VGND VPWR VPWR sky130_fd_sc_hd__decap_3
XFILLER_23_96 VGND VGND VPWR VPWR sky130_fd_sc_hd__decap_3
XFILLER_2_131 VGND VGND VPWR VPWR sky130_fd_sc_hd__decap_3
XPHY_EDGE_ROW_76_Left_167 VGND VGND VPWR VPWR sky130_fd_sc_hd__decap_3
XFILLER_2_175 VGND VGND VPWR VPWR sky130_fd_sc_hd__fill_1
XFILLER_2_197 VGND VGND VPWR VPWR sky130_fd_sc_hd__decap_3
XFILLER_48_82 VGND VGND VPWR VPWR sky130_fd_sc_hd__fill_2
XFILLER_0_12 VGND VGND VPWR VPWR sky130_fd_sc_hd__decap_3
XFILLER_65_149 VGND VGND VPWR VPWR sky130_fd_sc_hd__decap_3
XTAP_TAPCELL_ROW_76_645 VGND VPWR sky130_fd_sc_hd__tapvpwrvgnd_1
XPHY_EDGE_ROW_85_Left_176 VGND VGND VPWR VPWR sky130_fd_sc_hd__decap_3
XFILLER_21_219 VGND VGND VPWR VPWR sky130_fd_sc_hd__decap_3
XTAP_TAPCELL_ROW_16_288 VGND VPWR sky130_fd_sc_hd__tapvpwrvgnd_1
XFILLER_14_271 VGND VGND VPWR VPWR sky130_fd_sc_hd__fill_2
X_1941_ net785 net667 VGND VGND VPWR VPWR Inst_SimpleCLB_ConfigMem.Inst_frame6_bit16.Q
+ sky130_fd_sc_hd__dlxtp_1
X_1872_ net794 net661 VGND VGND VPWR VPWR Inst_SimpleCLB_ConfigMem.Inst_frame8_bit11.Q
+ sky130_fd_sc_hd__dlxtp_1
X_0823_ net650 E1END[0] NN4END[2] EE4END[2] Inst_SimpleCLB_ConfigMem.Inst_frame3_bit31.Q
+ Inst_SimpleCLB_ConfigMem.Inst_frame3_bit30.Q VGND VGND VPWR VPWR _0655_ sky130_fd_sc_hd__mux4_1
XFILLER_9_98 VGND VGND VPWR VPWR sky130_fd_sc_hd__fill_2
X_0754_ Inst_SimpleCLB_ConfigMem.Inst_frame3_bit24.Q VGND VGND VPWR VPWR _0590_ sky130_fd_sc_hd__inv_1
X_2355_ SS4END[14] VGND VGND VPWR VPWR net191 sky130_fd_sc_hd__clkbuf_2
X_1306_ Inst_SimpleCLB_ConfigMem.Inst_frame5_bit28.Q _0381_ VGND VGND VPWR VPWR _0382_
+ sky130_fd_sc_hd__or2_1
XFILLER_56_105 VGND VGND VPWR VPWR sky130_fd_sc_hd__decap_3
X_2286_ N4END[13] VGND VGND VPWR VPWR net137 sky130_fd_sc_hd__buf_1
X_1237_ _0159_ Inst_LD_LUT4c_frame_config_dffesr.inst_cus_mux161_buf.A10 _0158_ VGND
+ VGND VPWR VPWR _0321_ sky130_fd_sc_hd__or3b_1
X_1168_ N2MID[2] W2MID[2] S2MID[2] Inst_SimpleCLB_switch_matrix.E2BEG6 Inst_SimpleCLB_ConfigMem.Inst_frame7_bit21.Q
+ Inst_SimpleCLB_ConfigMem.Inst_frame7_bit20.Q VGND VGND VPWR VPWR _0255_ sky130_fd_sc_hd__mux4_2
XFILLER_44_29 VGND VGND VPWR VPWR sky130_fd_sc_hd__decap_3
X_1099_ Inst_LF_LUT4c_frame_config_dffesr.inst_cus_mux161_buf.A11 _0169_ _0190_ VGND
+ VGND VPWR VPWR _0191_ sky130_fd_sc_hd__o21a_1
XFILLER_20_274 VGND VGND VPWR VPWR sky130_fd_sc_hd__decap_3
XTAP_TAPCELL_ROW_7_234 VGND VPWR sky130_fd_sc_hd__tapvpwrvgnd_1
XFILLER_85_14 VGND VGND VPWR VPWR sky130_fd_sc_hd__decap_3
XFILLER_47_105 VGND VGND VPWR VPWR sky130_fd_sc_hd__decap_3
XFILLER_18_85 VGND VGND VPWR VPWR sky130_fd_sc_hd__decap_3
XTAP_TAPCELL_ROW_73_626 VGND VPWR sky130_fd_sc_hd__tapvpwrvgnd_1
XFILLER_43_344 VGND VGND VPWR VPWR sky130_fd_sc_hd__decap_3
XFILLER_55_182 VGND VGND VPWR VPWR sky130_fd_sc_hd__fill_2
XFILLER_34_62 VGND VGND VPWR VPWR sky130_fd_sc_hd__decap_3
XFILLER_70_174 VGND VGND VPWR VPWR sky130_fd_sc_hd__fill_1
XFILLER_70_185 VGND VGND VPWR VPWR sky130_fd_sc_hd__fill_2
XFILLER_34_95 VGND VGND VPWR VPWR sky130_fd_sc_hd__decap_3
XTAP_TAPCELL_ROW_13_269 VGND VPWR sky130_fd_sc_hd__tapvpwrvgnd_1
XFILLER_7_234 VGND VGND VPWR VPWR sky130_fd_sc_hd__decap_3
XFILLER_50_94 VGND VGND VPWR VPWR sky130_fd_sc_hd__decap_3
X_2140_ net766 net731 VGND VGND VPWR VPWR Inst_SimpleCLB_ConfigMem.Inst_frame0_bit23.Q
+ sky130_fd_sc_hd__dlxtp_1
X_2071_ net780 net685 VGND VGND VPWR VPWR Inst_SimpleCLB_ConfigMem.Inst_frame2_bit18.Q
+ sky130_fd_sc_hd__dlxtp_1
X_1022_ W2END[6] net638 net642 net629 Inst_SimpleCLB_ConfigMem.Inst_frame4_bit15.Q
+ Inst_SimpleCLB_ConfigMem.Inst_frame4_bit14.Q VGND VGND VPWR VPWR _0118_ sky130_fd_sc_hd__mux4_1
XFILLER_46_171 VGND VGND VPWR VPWR sky130_fd_sc_hd__fill_2
X_1924_ net748 net664 VGND VGND VPWR VPWR Inst_SimpleCLB_ConfigMem.Inst_frame7_bit31.Q
+ sky130_fd_sc_hd__dlxtp_1
X_1855_ net761 net658 VGND VGND VPWR VPWR Inst_SimpleCLB_ConfigMem.Inst_frame9_bit26.Q
+ sky130_fd_sc_hd__dlxtp_1
X_1786_ net772 net720 VGND VGND VPWR VPWR Inst_SimpleCLB_ConfigMem.Inst_frame11_bit21.Q
+ sky130_fd_sc_hd__dlxtp_1
X_0806_ Inst_SimpleCLB_ConfigMem.Inst_frame4_bit0.Q _0638_ VGND VGND VPWR VPWR _0639_
+ sky130_fd_sc_hd__nand2_1
X_0737_ Inst_SimpleCLB_ConfigMem.Inst_frame2_bit8.Q VGND VGND VPWR VPWR _0573_ sky130_fd_sc_hd__inv_2
XTAP_TAPCELL_ROW_4_215 VGND VPWR sky130_fd_sc_hd__tapvpwrvgnd_1
X_2407_ Inst_SimpleCLB_switch_matrix.WW4BEG1 VGND VGND VPWR VPWR net243 sky130_fd_sc_hd__buf_6
X_2338_ S4END[13] VGND VGND VPWR VPWR net189 sky130_fd_sc_hd__buf_4
XFILLER_29_105 VGND VGND VPWR VPWR sky130_fd_sc_hd__decap_3
XFILLER_29_127 VGND VGND VPWR VPWR sky130_fd_sc_hd__decap_3
XFILLER_84_233 VGND VGND VPWR VPWR sky130_fd_sc_hd__fill_1
X_2269_ N2MID[0] VGND VGND VPWR VPWR net114 sky130_fd_sc_hd__clkbuf_2
XFILLER_84_277 VGND VGND VPWR VPWR sky130_fd_sc_hd__fill_1
XFILLER_44_119 VGND VGND VPWR VPWR sky130_fd_sc_hd__decap_3
XFILLER_52_141 VGND VGND VPWR VPWR sky130_fd_sc_hd__fill_1
XFILLER_40_303 VGND VGND VPWR VPWR sky130_fd_sc_hd__fill_1
XFILLER_20_75 VGND VGND VPWR VPWR sky130_fd_sc_hd__decap_3
XFILLER_75_211 VGND VGND VPWR VPWR sky130_fd_sc_hd__decap_3
XFILLER_75_255 VGND VGND VPWR VPWR sky130_fd_sc_hd__decap_3
XFILLER_90_203 VGND VGND VPWR VPWR sky130_fd_sc_hd__decap_3
XFILLER_75_266 VGND VGND VPWR VPWR sky130_fd_sc_hd__decap_3
XFILLER_90_225 VGND VGND VPWR VPWR sky130_fd_sc_hd__decap_3
XFILLER_16_322 VGND VGND VPWR VPWR sky130_fd_sc_hd__decap_3
XFILLER_43_185 VGND VGND VPWR VPWR sky130_fd_sc_hd__decap_3
XFILLER_61_60 VGND VGND VPWR VPWR sky130_fd_sc_hd__decap_3
X_1640_ net745 net703 VGND VGND VPWR VPWR Inst_LF_LUT4c_frame_config_dffesr.inst_cus_mux161_buf.A2
+ sky130_fd_sc_hd__dlxtp_1
XFILLER_6_66 VGND VGND VPWR VPWR sky130_fd_sc_hd__decap_3
X_1571_ net749 net691 VGND VGND VPWR VPWR Inst_LB_LUT4c_frame_config_dffesr.inst_cus_mux161_buf.A9
+ sky130_fd_sc_hd__dlxtp_1
XANTENNA_4 E1END[0] VGND VGND VPWR VPWR sky130_fd_sc_hd__diode_2
XFILLER_6_99 VGND VGND VPWR VPWR sky130_fd_sc_hd__decap_3
XFILLER_20_3 VGND VGND VPWR VPWR sky130_fd_sc_hd__fill_2
XFILLER_66_200 VGND VGND VPWR VPWR sky130_fd_sc_hd__decap_3
X_2123_ net739 net729 VGND VGND VPWR VPWR Inst_SimpleCLB_ConfigMem.Inst_frame0_bit6.Q
+ sky130_fd_sc_hd__dlxtp_1
X_2054_ net776 net683 VGND VGND VPWR VPWR Inst_SimpleCLB_ConfigMem.Inst_frame2_bit1.Q
+ sky130_fd_sc_hd__dlxtp_1
Xrebuffer49 Inst_LC_LUT4c_frame_config_dffesr.O VGND VGND VPWR VPWR net303 sky130_fd_sc_hd__buf_6
XTAP_TAPCELL_ROW_49_486 VGND VPWR sky130_fd_sc_hd__tapvpwrvgnd_1
XFILLER_81_258 VGND VGND VPWR VPWR sky130_fd_sc_hd__decap_3
X_1005_ Inst_SimpleCLB_ConfigMem.Inst_frame10_bit20.Q _0631_ _0101_ VGND VGND VPWR
+ VPWR _0102_ sky130_fd_sc_hd__o21ai_1
XFILLER_34_141 VGND VGND VPWR VPWR sky130_fd_sc_hd__decap_3
XFILLER_34_174 VGND VGND VPWR VPWR sky130_fd_sc_hd__fill_1
X_1907_ net788 net665 VGND VGND VPWR VPWR Inst_SimpleCLB_ConfigMem.Inst_frame7_bit14.Q
+ sky130_fd_sc_hd__dlxtp_1
X_1838_ net733 net656 VGND VGND VPWR VPWR Inst_SimpleCLB_ConfigMem.Inst_frame9_bit9.Q
+ sky130_fd_sc_hd__dlxtp_1
X_1769_ net743 net721 VGND VGND VPWR VPWR Inst_SimpleCLB_ConfigMem.Inst_frame11_bit4.Q
+ sky130_fd_sc_hd__dlxtp_1
XFILLER_57_244 VGND VGND VPWR VPWR sky130_fd_sc_hd__decap_3
XFILLER_82_26 VGND VGND VPWR VPWR sky130_fd_sc_hd__fill_2
XFILLER_25_185 VGND VGND VPWR VPWR sky130_fd_sc_hd__decap_3
XFILLER_40_100 VGND VGND VPWR VPWR sky130_fd_sc_hd__decap_3
XTAP_TAPCELL_ROW_23_331 VGND VPWR sky130_fd_sc_hd__tapvpwrvgnd_1
XFILLER_40_133 VGND VGND VPWR VPWR sky130_fd_sc_hd__decap_3
XFILLER_40_155 VGND VGND VPWR VPWR sky130_fd_sc_hd__decap_3
Xoutput6 net6 VGND VGND VPWR VPWR E2BEG[0] sky130_fd_sc_hd__buf_4
Xoutput41 net41 VGND VGND VPWR VPWR EE4BEG[1] sky130_fd_sc_hd__buf_2
Xoutput30 net30 VGND VGND VPWR VPWR E6BEG[6] sky130_fd_sc_hd__buf_2
Xoutput52 net52 VGND VGND VPWR VPWR FrameData_O[11] sky130_fd_sc_hd__buf_2
Xoutput85 net85 VGND VGND VPWR VPWR FrameStrobe_O[12] sky130_fd_sc_hd__buf_2
Xoutput63 net63 VGND VGND VPWR VPWR FrameData_O[21] sky130_fd_sc_hd__buf_2
Xoutput74 net74 VGND VGND VPWR VPWR FrameData_O[31] sky130_fd_sc_hd__buf_2
Xoutput96 net96 VGND VGND VPWR VPWR FrameStrobe_O[4] sky130_fd_sc_hd__buf_2
XFILLER_0_251 VGND VGND VPWR VPWR sky130_fd_sc_hd__fill_1
XFILLER_48_200 VGND VGND VPWR VPWR sky130_fd_sc_hd__decap_3
XFILLER_48_244 VGND VGND VPWR VPWR sky130_fd_sc_hd__decap_3
XFILLER_63_225 VGND VGND VPWR VPWR sky130_fd_sc_hd__decap_3
XFILLER_16_141 VGND VGND VPWR VPWR sky130_fd_sc_hd__fill_1
XTAP_TAPCELL_ROW_46_467 VGND VPWR sky130_fd_sc_hd__tapvpwrvgnd_1
XFILLER_82_5 VGND VGND VPWR VPWR sky130_fd_sc_hd__fill_1
XFILLER_31_199 VGND VGND VPWR VPWR sky130_fd_sc_hd__decap_3
XFILLER_68_3 VGND VGND VPWR VPWR sky130_fd_sc_hd__decap_3
X_1623_ net780 net700 VGND VGND VPWR VPWR Inst_LE_LUT4c_frame_config_dffesr.inst_cus_mux161_buf.A4
+ sky130_fd_sc_hd__dlxtp_1
X_1554_ net790 FrameStrobe[18] VGND VGND VPWR VPWR Inst_LA_LUT4c_frame_config_dffesr.inst_cus_mux161_buf.A11
+ sky130_fd_sc_hd__dlxtp_1
X_1485_ N2END[2] N4END[1] net800 net622 Inst_SimpleCLB_ConfigMem.Inst_frame13_bit2.Q
+ Inst_SimpleCLB_ConfigMem.Inst_frame13_bit3.Q VGND VGND VPWR VPWR Inst_SimpleCLB_switch_matrix.N4BEG0
+ sky130_fd_sc_hd__mux4_1
.ends
